* NGSPICE file created from compute_core.ext - technology: sky130A

* Black-box entry subcircuit for sky130_fd_sc_hd__fill_1 abstract view
.subckt sky130_fd_sc_hd__fill_1 VGND VNB VPB VPWR
.ends

* Black-box entry subcircuit for sky130_fd_sc_hd__xnor2_2 abstract view
.subckt sky130_fd_sc_hd__xnor2_2 A B VGND VNB VPB VPWR Y
.ends

* Black-box entry subcircuit for sky130_ef_sc_hd__decap_12 abstract view
.subckt sky130_ef_sc_hd__decap_12 VPWR VGND VPB VNB
.ends

* Black-box entry subcircuit for sky130_fd_sc_hd__decap_3 abstract view
.subckt sky130_fd_sc_hd__decap_3 VGND VNB VPB VPWR
.ends

* Black-box entry subcircuit for sky130_fd_sc_hd__decap_6 abstract view
.subckt sky130_fd_sc_hd__decap_6 VGND VNB VPB VPWR
.ends

* Black-box entry subcircuit for sky130_fd_sc_hd__a21bo_1 abstract view
.subckt sky130_fd_sc_hd__a21bo_1 A1 A2 B1_N VGND VNB VPB VPWR X
.ends

* Black-box entry subcircuit for sky130_fd_sc_hd__fill_2 abstract view
.subckt sky130_fd_sc_hd__fill_2 VGND VNB VPB VPWR
.ends

* Black-box entry subcircuit for sky130_fd_sc_hd__tapvpwrvgnd_1 abstract view
.subckt sky130_fd_sc_hd__tapvpwrvgnd_1 VGND VPWR
.ends

* Black-box entry subcircuit for sky130_fd_sc_hd__nor2_1 abstract view
.subckt sky130_fd_sc_hd__nor2_1 A B VGND VNB VPB VPWR Y
.ends

* Black-box entry subcircuit for sky130_fd_sc_hd__a21o_1 abstract view
.subckt sky130_fd_sc_hd__a21o_1 A1 A2 B1 VGND VNB VPB VPWR X
.ends

* Black-box entry subcircuit for sky130_fd_sc_hd__o211ai_1 abstract view
.subckt sky130_fd_sc_hd__o211ai_1 A1 A2 B1 C1 VGND VNB VPB VPWR Y
.ends

* Black-box entry subcircuit for sky130_fd_sc_hd__and3_1 abstract view
.subckt sky130_fd_sc_hd__and3_1 A B C VGND VNB VPB VPWR X
.ends

* Black-box entry subcircuit for sky130_fd_sc_hd__decap_8 abstract view
.subckt sky130_fd_sc_hd__decap_8 VGND VNB VPB VPWR
.ends

* Black-box entry subcircuit for sky130_fd_sc_hd__and2_1 abstract view
.subckt sky130_fd_sc_hd__and2_1 A B VGND VNB VPB VPWR X
.ends

* Black-box entry subcircuit for sky130_fd_sc_hd__nand2b_4 abstract view
.subckt sky130_fd_sc_hd__nand2b_4 A_N B VGND VNB VPB VPWR Y
.ends

* Black-box entry subcircuit for sky130_fd_sc_hd__o211ai_2 abstract view
.subckt sky130_fd_sc_hd__o211ai_2 A1 A2 B1 C1 VGND VNB VPB VPWR Y
.ends

* Black-box entry subcircuit for sky130_fd_sc_hd__dlygate4sd3_1 abstract view
.subckt sky130_fd_sc_hd__dlygate4sd3_1 A VGND VNB VPB VPWR X
.ends

* Black-box entry subcircuit for sky130_fd_sc_hd__buf_1 abstract view
.subckt sky130_fd_sc_hd__buf_1 A VGND VNB VPB VPWR X
.ends

* Black-box entry subcircuit for sky130_fd_sc_hd__a311oi_2 abstract view
.subckt sky130_fd_sc_hd__a311oi_2 A1 A2 A3 B1 C1 VGND VNB VPB VPWR Y
.ends

* Black-box entry subcircuit for sky130_fd_sc_hd__nor3_1 abstract view
.subckt sky130_fd_sc_hd__nor3_1 A B C VGND VNB VPB VPWR Y
.ends

* Black-box entry subcircuit for sky130_fd_sc_hd__a21oi_1 abstract view
.subckt sky130_fd_sc_hd__a21oi_1 A1 A2 B1 VGND VNB VPB VPWR Y
.ends

* Black-box entry subcircuit for sky130_fd_sc_hd__o211a_1 abstract view
.subckt sky130_fd_sc_hd__o211a_1 A1 A2 B1 C1 VGND VNB VPB VPWR X
.ends

* Black-box entry subcircuit for sky130_fd_sc_hd__dfxtp_1 abstract view
.subckt sky130_fd_sc_hd__dfxtp_1 CLK D VGND VNB VPB VPWR Q
.ends

* Black-box entry subcircuit for sky130_fd_sc_hd__a211o_4 abstract view
.subckt sky130_fd_sc_hd__a211o_4 A1 A2 B1 C1 VGND VNB VPB VPWR X
.ends

* Black-box entry subcircuit for sky130_fd_sc_hd__o21bai_4 abstract view
.subckt sky130_fd_sc_hd__o21bai_4 A1 A2 B1_N VGND VNB VPB VPWR Y
.ends

* Black-box entry subcircuit for sky130_fd_sc_hd__and4_1 abstract view
.subckt sky130_fd_sc_hd__and4_1 A B C D VGND VNB VPB VPWR X
.ends

* Black-box entry subcircuit for sky130_fd_sc_hd__nand3_1 abstract view
.subckt sky130_fd_sc_hd__nand3_1 A B C VGND VNB VPB VPWR Y
.ends

* Black-box entry subcircuit for sky130_fd_sc_hd__o21ai_1 abstract view
.subckt sky130_fd_sc_hd__o21ai_1 A1 A2 B1 VGND VNB VPB VPWR Y
.ends

* Black-box entry subcircuit for sky130_fd_sc_hd__decap_4 abstract view
.subckt sky130_fd_sc_hd__decap_4 VGND VNB VPB VPWR
.ends

* Black-box entry subcircuit for sky130_fd_sc_hd__inv_2 abstract view
.subckt sky130_fd_sc_hd__inv_2 A VGND VNB VPB VPWR Y
.ends

* Black-box entry subcircuit for sky130_fd_sc_hd__a22o_1 abstract view
.subckt sky130_fd_sc_hd__a22o_1 A1 A2 B1 B2 VGND VNB VPB VPWR X
.ends

* Black-box entry subcircuit for sky130_fd_sc_hd__nand2_1 abstract view
.subckt sky130_fd_sc_hd__nand2_1 A B VGND VNB VPB VPWR Y
.ends

* Black-box entry subcircuit for sky130_fd_sc_hd__mux2_4 abstract view
.subckt sky130_fd_sc_hd__mux2_4 A0 A1 S VGND VNB VPB VPWR X
.ends

* Black-box entry subcircuit for sky130_fd_sc_hd__nand3_4 abstract view
.subckt sky130_fd_sc_hd__nand3_4 A B C VGND VNB VPB VPWR Y
.ends

* Black-box entry subcircuit for sky130_fd_sc_hd__o2bb2a_1 abstract view
.subckt sky130_fd_sc_hd__o2bb2a_1 A1_N A2_N B1 B2 VGND VNB VPB VPWR X
.ends

* Black-box entry subcircuit for sky130_fd_sc_hd__and2b_1 abstract view
.subckt sky130_fd_sc_hd__and2b_1 A_N B VGND VNB VPB VPWR X
.ends

* Black-box entry subcircuit for sky130_fd_sc_hd__o2bb2a_4 abstract view
.subckt sky130_fd_sc_hd__o2bb2a_4 A1_N A2_N B1 B2 VGND VNB VPB VPWR X
.ends

* Black-box entry subcircuit for sky130_fd_sc_hd__or2_4 abstract view
.subckt sky130_fd_sc_hd__or2_4 A B VGND VNB VPB VPWR X
.ends

* Black-box entry subcircuit for sky130_fd_sc_hd__nand2b_1 abstract view
.subckt sky130_fd_sc_hd__nand2b_1 A_N B VGND VNB VPB VPWR Y
.ends

* Black-box entry subcircuit for sky130_fd_sc_hd__o31ai_2 abstract view
.subckt sky130_fd_sc_hd__o31ai_2 A1 A2 A3 B1 VGND VNB VPB VPWR Y
.ends

* Black-box entry subcircuit for sky130_fd_sc_hd__clkbuf_2 abstract view
.subckt sky130_fd_sc_hd__clkbuf_2 A VGND VNB VPB VPWR X
.ends

* Black-box entry subcircuit for sky130_fd_sc_hd__buf_2 abstract view
.subckt sky130_fd_sc_hd__buf_2 A VGND VNB VPB VPWR X
.ends

* Black-box entry subcircuit for sky130_fd_sc_hd__a211o_1 abstract view
.subckt sky130_fd_sc_hd__a211o_1 A1 A2 B1 C1 VGND VNB VPB VPWR X
.ends

* Black-box entry subcircuit for sky130_fd_sc_hd__or2_1 abstract view
.subckt sky130_fd_sc_hd__or2_1 A B VGND VNB VPB VPWR X
.ends

* Black-box entry subcircuit for sky130_fd_sc_hd__a211oi_4 abstract view
.subckt sky130_fd_sc_hd__a211oi_4 A1 A2 B1 C1 VGND VNB VPB VPWR Y
.ends

* Black-box entry subcircuit for sky130_fd_sc_hd__xnor2_1 abstract view
.subckt sky130_fd_sc_hd__xnor2_1 A B VGND VNB VPB VPWR Y
.ends

* Black-box entry subcircuit for sky130_fd_sc_hd__a211oi_2 abstract view
.subckt sky130_fd_sc_hd__a211oi_2 A1 A2 B1 C1 VGND VNB VPB VPWR Y
.ends

* Black-box entry subcircuit for sky130_fd_sc_hd__nor2_2 abstract view
.subckt sky130_fd_sc_hd__nor2_2 A B VGND VNB VPB VPWR Y
.ends

* Black-box entry subcircuit for sky130_fd_sc_hd__nand3_2 abstract view
.subckt sky130_fd_sc_hd__nand3_2 A B C VGND VNB VPB VPWR Y
.ends

* Black-box entry subcircuit for sky130_fd_sc_hd__xor2_1 abstract view
.subckt sky130_fd_sc_hd__xor2_1 A B VGND VNB VPB VPWR X
.ends

* Black-box entry subcircuit for sky130_fd_sc_hd__o21ba_4 abstract view
.subckt sky130_fd_sc_hd__o21ba_4 A1 A2 B1_N VGND VNB VPB VPWR X
.ends

* Black-box entry subcircuit for sky130_fd_sc_hd__a21oi_4 abstract view
.subckt sky130_fd_sc_hd__a21oi_4 A1 A2 B1 VGND VNB VPB VPWR Y
.ends

* Black-box entry subcircuit for sky130_fd_sc_hd__diode_2 abstract view
.subckt sky130_fd_sc_hd__diode_2 DIODE VGND VNB VPB VPWR
.ends

* Black-box entry subcircuit for sky130_fd_sc_hd__buf_6 abstract view
.subckt sky130_fd_sc_hd__buf_6 A VGND VNB VPB VPWR X
.ends

* Black-box entry subcircuit for sky130_fd_sc_hd__dlygate4sd1_1 abstract view
.subckt sky130_fd_sc_hd__dlygate4sd1_1 A VGND VNB VPB VPWR X
.ends

* Black-box entry subcircuit for sky130_fd_sc_hd__nor4_4 abstract view
.subckt sky130_fd_sc_hd__nor4_4 A B C D VGND VNB VPB VPWR Y
.ends

* Black-box entry subcircuit for sky130_fd_sc_hd__and4bb_1 abstract view
.subckt sky130_fd_sc_hd__and4bb_1 A_N B_N C D VGND VNB VPB VPWR X
.ends

* Black-box entry subcircuit for sky130_fd_sc_hd__xor2_2 abstract view
.subckt sky130_fd_sc_hd__xor2_2 A B VGND VNB VPB VPWR X
.ends

* Black-box entry subcircuit for sky130_fd_sc_hd__or3_4 abstract view
.subckt sky130_fd_sc_hd__or3_4 A B C VGND VNB VPB VPWR X
.ends

* Black-box entry subcircuit for sky130_fd_sc_hd__nor2_4 abstract view
.subckt sky130_fd_sc_hd__nor2_4 A B VGND VNB VPB VPWR Y
.ends

* Black-box entry subcircuit for sky130_fd_sc_hd__o21a_1 abstract view
.subckt sky130_fd_sc_hd__o21a_1 A1 A2 B1 VGND VNB VPB VPWR X
.ends

* Black-box entry subcircuit for sky130_fd_sc_hd__or3_1 abstract view
.subckt sky130_fd_sc_hd__or3_1 A B C VGND VNB VPB VPWR X
.ends

* Black-box entry subcircuit for sky130_fd_sc_hd__a2bb2o_1 abstract view
.subckt sky130_fd_sc_hd__a2bb2o_1 A1_N A2_N B1 B2 VGND VNB VPB VPWR X
.ends

* Black-box entry subcircuit for sky130_fd_sc_hd__and3_4 abstract view
.subckt sky130_fd_sc_hd__and3_4 A B C VGND VNB VPB VPWR X
.ends

* Black-box entry subcircuit for sky130_fd_sc_hd__clkbuf_16 abstract view
.subckt sky130_fd_sc_hd__clkbuf_16 A VGND VNB VPB VPWR X
.ends

* Black-box entry subcircuit for sky130_fd_sc_hd__and2_4 abstract view
.subckt sky130_fd_sc_hd__and2_4 A B VGND VNB VPB VPWR X
.ends

* Black-box entry subcircuit for sky130_fd_sc_hd__a22oi_1 abstract view
.subckt sky130_fd_sc_hd__a22oi_1 A1 A2 B1 B2 VGND VNB VPB VPWR Y
.ends

* Black-box entry subcircuit for sky130_fd_sc_hd__a32o_1 abstract view
.subckt sky130_fd_sc_hd__a32o_1 A1 A2 A3 B1 B2 VGND VNB VPB VPWR X
.ends

* Black-box entry subcircuit for sky130_fd_sc_hd__o21ba_1 abstract view
.subckt sky130_fd_sc_hd__o21ba_1 A1 A2 B1_N VGND VNB VPB VPWR X
.ends

* Black-box entry subcircuit for sky130_fd_sc_hd__or4bb_4 abstract view
.subckt sky130_fd_sc_hd__or4bb_4 A B C_N D_N VGND VNB VPB VPWR X
.ends

* Black-box entry subcircuit for sky130_fd_sc_hd__clkbuf_8 abstract view
.subckt sky130_fd_sc_hd__clkbuf_8 A VGND VNB VPB VPWR X
.ends

* Black-box entry subcircuit for sky130_fd_sc_hd__mux2_1 abstract view
.subckt sky130_fd_sc_hd__mux2_1 A0 A1 S VGND VNB VPB VPWR X
.ends

* Black-box entry subcircuit for sky130_fd_sc_hd__dlymetal6s2s_1 abstract view
.subckt sky130_fd_sc_hd__dlymetal6s2s_1 A VGND VNB VPB VPWR X
.ends

* Black-box entry subcircuit for sky130_fd_sc_hd__a21oi_2 abstract view
.subckt sky130_fd_sc_hd__a21oi_2 A1 A2 B1 VGND VNB VPB VPWR Y
.ends

* Black-box entry subcircuit for sky130_fd_sc_hd__o31a_1 abstract view
.subckt sky130_fd_sc_hd__o31a_1 A1 A2 A3 B1 VGND VNB VPB VPWR X
.ends

* Black-box entry subcircuit for sky130_fd_sc_hd__xnor2_4 abstract view
.subckt sky130_fd_sc_hd__xnor2_4 A B VGND VNB VPB VPWR Y
.ends

* Black-box entry subcircuit for sky130_fd_sc_hd__or4b_1 abstract view
.subckt sky130_fd_sc_hd__or4b_1 A B C D_N VGND VNB VPB VPWR X
.ends

* Black-box entry subcircuit for sky130_fd_sc_hd__a32oi_1 abstract view
.subckt sky130_fd_sc_hd__a32oi_1 A1 A2 A3 B1 B2 VGND VNB VPB VPWR Y
.ends

* Black-box entry subcircuit for sky130_fd_sc_hd__o21bai_1 abstract view
.subckt sky130_fd_sc_hd__o21bai_1 A1 A2 B1_N VGND VNB VPB VPWR Y
.ends

* Black-box entry subcircuit for sky130_fd_sc_hd__clkbuf_1 abstract view
.subckt sky130_fd_sc_hd__clkbuf_1 A VGND VNB VPB VPWR X
.ends

* Black-box entry subcircuit for sky130_fd_sc_hd__a31o_1 abstract view
.subckt sky130_fd_sc_hd__a31o_1 A1 A2 A3 B1 VGND VNB VPB VPWR X
.ends

* Black-box entry subcircuit for sky130_fd_sc_hd__a21boi_1 abstract view
.subckt sky130_fd_sc_hd__a21boi_1 A1 A2 B1_N VGND VNB VPB VPWR Y
.ends

* Black-box entry subcircuit for sky130_fd_sc_hd__or3b_1 abstract view
.subckt sky130_fd_sc_hd__or3b_1 A B C_N VGND VNB VPB VPWR X
.ends

* Black-box entry subcircuit for sky130_fd_sc_hd__o311a_4 abstract view
.subckt sky130_fd_sc_hd__o311a_4 A1 A2 A3 B1 C1 VGND VNB VPB VPWR X
.ends

* Black-box entry subcircuit for sky130_fd_sc_hd__nand2_2 abstract view
.subckt sky130_fd_sc_hd__nand2_2 A B VGND VNB VPB VPWR Y
.ends

* Black-box entry subcircuit for sky130_fd_sc_hd__xor2_4 abstract view
.subckt sky130_fd_sc_hd__xor2_4 A B VGND VNB VPB VPWR X
.ends

* Black-box entry subcircuit for sky130_fd_sc_hd__or3b_4 abstract view
.subckt sky130_fd_sc_hd__or3b_4 A B C_N VGND VNB VPB VPWR X
.ends

* Black-box entry subcircuit for sky130_fd_sc_hd__nand2_8 abstract view
.subckt sky130_fd_sc_hd__nand2_8 A B VGND VNB VPB VPWR Y
.ends

* Black-box entry subcircuit for sky130_fd_sc_hd__buf_8 abstract view
.subckt sky130_fd_sc_hd__buf_8 A VGND VNB VPB VPWR X
.ends

* Black-box entry subcircuit for sky130_fd_sc_hd__nand2_4 abstract view
.subckt sky130_fd_sc_hd__nand2_4 A B VGND VNB VPB VPWR Y
.ends

* Black-box entry subcircuit for sky130_fd_sc_hd__a311oi_4 abstract view
.subckt sky130_fd_sc_hd__a311oi_4 A1 A2 A3 B1 C1 VGND VNB VPB VPWR Y
.ends

* Black-box entry subcircuit for sky130_fd_sc_hd__nor3_2 abstract view
.subckt sky130_fd_sc_hd__nor3_2 A B C VGND VNB VPB VPWR Y
.ends

* Black-box entry subcircuit for sky130_fd_sc_hd__o32a_1 abstract view
.subckt sky130_fd_sc_hd__o32a_1 A1 A2 A3 B1 B2 VGND VNB VPB VPWR X
.ends

* Black-box entry subcircuit for sky130_fd_sc_hd__a211oi_1 abstract view
.subckt sky130_fd_sc_hd__a211oi_1 A1 A2 B1 C1 VGND VNB VPB VPWR Y
.ends

* Black-box entry subcircuit for sky130_fd_sc_hd__nand3b_1 abstract view
.subckt sky130_fd_sc_hd__nand3b_1 A_N B C VGND VNB VPB VPWR Y
.ends

* Black-box entry subcircuit for sky130_fd_sc_hd__a311o_1 abstract view
.subckt sky130_fd_sc_hd__a311o_1 A1 A2 A3 B1 C1 VGND VNB VPB VPWR X
.ends

* Black-box entry subcircuit for sky130_fd_sc_hd__clkbuf_4 abstract view
.subckt sky130_fd_sc_hd__clkbuf_4 A VGND VNB VPB VPWR X
.ends

* Black-box entry subcircuit for sky130_fd_sc_hd__clkinv_4 abstract view
.subckt sky130_fd_sc_hd__clkinv_4 A VGND VNB VPB VPWR Y
.ends

* Black-box entry subcircuit for sky130_fd_sc_hd__clkinv_2 abstract view
.subckt sky130_fd_sc_hd__clkinv_2 A VGND VNB VPB VPWR Y
.ends

* Black-box entry subcircuit for sky130_fd_sc_hd__a31o_4 abstract view
.subckt sky130_fd_sc_hd__a31o_4 A1 A2 A3 B1 VGND VNB VPB VPWR X
.ends

* Black-box entry subcircuit for sky130_fd_sc_hd__a21o_2 abstract view
.subckt sky130_fd_sc_hd__a21o_2 A1 A2 B1 VGND VNB VPB VPWR X
.ends

* Black-box entry subcircuit for sky130_fd_sc_hd__and3b_1 abstract view
.subckt sky130_fd_sc_hd__and3b_1 A_N B C VGND VNB VPB VPWR X
.ends

* Black-box entry subcircuit for sky130_fd_sc_hd__buf_4 abstract view
.subckt sky130_fd_sc_hd__buf_4 A VGND VNB VPB VPWR X
.ends

* Black-box entry subcircuit for sky130_fd_sc_hd__clkinv_8 abstract view
.subckt sky130_fd_sc_hd__clkinv_8 A VGND VNB VPB VPWR Y
.ends

* Black-box entry subcircuit for sky130_fd_sc_hd__inv_6 abstract view
.subckt sky130_fd_sc_hd__inv_6 A VGND VNB VPB VPWR Y
.ends

* Black-box entry subcircuit for sky130_fd_sc_hd__clkinvlp_4 abstract view
.subckt sky130_fd_sc_hd__clkinvlp_4 A VGND VNB VPB VPWR Y
.ends

* Black-box entry subcircuit for sky130_fd_sc_hd__nand4b_1 abstract view
.subckt sky130_fd_sc_hd__nand4b_1 A_N B C D VGND VNB VPB VPWR Y
.ends

* Black-box entry subcircuit for sky130_fd_sc_hd__nor3_4 abstract view
.subckt sky130_fd_sc_hd__nor3_4 A B C VGND VNB VPB VPWR Y
.ends

* Black-box entry subcircuit for sky130_fd_sc_hd__o211ai_4 abstract view
.subckt sky130_fd_sc_hd__o211ai_4 A1 A2 B1 C1 VGND VNB VPB VPWR Y
.ends

* Black-box entry subcircuit for sky130_fd_sc_hd__or4_4 abstract view
.subckt sky130_fd_sc_hd__or4_4 A B C D VGND VNB VPB VPWR X
.ends

* Black-box entry subcircuit for sky130_fd_sc_hd__or3_2 abstract view
.subckt sky130_fd_sc_hd__or3_2 A B C VGND VNB VPB VPWR X
.ends

* Black-box entry subcircuit for sky130_fd_sc_hd__inv_8 abstract view
.subckt sky130_fd_sc_hd__inv_8 A VGND VNB VPB VPWR Y
.ends

* Black-box entry subcircuit for sky130_fd_sc_hd__o211a_2 abstract view
.subckt sky130_fd_sc_hd__o211a_2 A1 A2 B1 C1 VGND VNB VPB VPWR X
.ends

* Black-box entry subcircuit for sky130_fd_sc_hd__and2_2 abstract view
.subckt sky130_fd_sc_hd__and2_2 A B VGND VNB VPB VPWR X
.ends

* Black-box entry subcircuit for sky130_fd_sc_hd__inv_12 abstract view
.subckt sky130_fd_sc_hd__inv_12 A VGND VNB VPB VPWR Y
.ends

* Black-box entry subcircuit for sky130_fd_sc_hd__inv_16 abstract view
.subckt sky130_fd_sc_hd__inv_16 A VGND VNB VPB VPWR Y
.ends

* Black-box entry subcircuit for sky130_fd_sc_hd__o2bb2ai_1 abstract view
.subckt sky130_fd_sc_hd__o2bb2ai_1 A1_N A2_N B1 B2 VGND VNB VPB VPWR Y
.ends

* Black-box entry subcircuit for sky130_fd_sc_hd__o311a_1 abstract view
.subckt sky130_fd_sc_hd__o311a_1 A1 A2 A3 B1 C1 VGND VNB VPB VPWR X
.ends

* Black-box entry subcircuit for sky130_fd_sc_hd__buf_12 abstract view
.subckt sky130_fd_sc_hd__buf_12 A VGND VNB VPB VPWR X
.ends

* Black-box entry subcircuit for sky130_fd_sc_hd__nand4_2 abstract view
.subckt sky130_fd_sc_hd__nand4_2 A B C D VGND VNB VPB VPWR Y
.ends

* Black-box entry subcircuit for sky130_fd_sc_hd__or4bb_1 abstract view
.subckt sky130_fd_sc_hd__or4bb_1 A B C_N D_N VGND VNB VPB VPWR X
.ends

* Black-box entry subcircuit for sky130_fd_sc_hd__bufinv_16 abstract view
.subckt sky130_fd_sc_hd__bufinv_16 A VGND VNB VPB VPWR Y
.ends

* Black-box entry subcircuit for sky130_fd_sc_hd__o211a_4 abstract view
.subckt sky130_fd_sc_hd__o211a_4 A1 A2 B1 C1 VGND VNB VPB VPWR X
.ends

* Black-box entry subcircuit for sky130_fd_sc_hd__o2bb2a_2 abstract view
.subckt sky130_fd_sc_hd__o2bb2a_2 A1_N A2_N B1 B2 VGND VNB VPB VPWR X
.ends

* Black-box entry subcircuit for sky130_fd_sc_hd__o21ai_2 abstract view
.subckt sky130_fd_sc_hd__o21ai_2 A1 A2 B1 VGND VNB VPB VPWR Y
.ends

* Black-box entry subcircuit for sky130_fd_sc_hd__o32a_4 abstract view
.subckt sky130_fd_sc_hd__o32a_4 A1 A2 A3 B1 B2 VGND VNB VPB VPWR X
.ends

* Black-box entry subcircuit for sky130_fd_sc_hd__and2b_2 abstract view
.subckt sky130_fd_sc_hd__and2b_2 A_N B VGND VNB VPB VPWR X
.ends

* Black-box entry subcircuit for sky130_fd_sc_hd__o21a_4 abstract view
.subckt sky130_fd_sc_hd__o21a_4 A1 A2 B1 VGND VNB VPB VPWR X
.ends

* Black-box entry subcircuit for sky130_fd_sc_hd__a32o_2 abstract view
.subckt sky130_fd_sc_hd__a32o_2 A1 A2 A3 B1 B2 VGND VNB VPB VPWR X
.ends

* Black-box entry subcircuit for sky130_fd_sc_hd__o22a_1 abstract view
.subckt sky130_fd_sc_hd__o22a_1 A1 A2 B1 B2 VGND VNB VPB VPWR X
.ends

* Black-box entry subcircuit for sky130_fd_sc_hd__nand4_4 abstract view
.subckt sky130_fd_sc_hd__nand4_4 A B C D VGND VNB VPB VPWR Y
.ends

* Black-box entry subcircuit for sky130_fd_sc_hd__or4b_4 abstract view
.subckt sky130_fd_sc_hd__or4b_4 A B C D_N VGND VNB VPB VPWR X
.ends

* Black-box entry subcircuit for sky130_fd_sc_hd__nor4_2 abstract view
.subckt sky130_fd_sc_hd__nor4_2 A B C D VGND VNB VPB VPWR Y
.ends

* Black-box entry subcircuit for sky130_fd_sc_hd__a211o_2 abstract view
.subckt sky130_fd_sc_hd__a211o_2 A1 A2 B1 C1 VGND VNB VPB VPWR X
.ends

* Black-box entry subcircuit for sky130_fd_sc_hd__o22a_4 abstract view
.subckt sky130_fd_sc_hd__o22a_4 A1 A2 B1 B2 VGND VNB VPB VPWR X
.ends

* Black-box entry subcircuit for sky130_fd_sc_hd__dfxtp_2 abstract view
.subckt sky130_fd_sc_hd__dfxtp_2 CLK D VGND VNB VPB VPWR Q
.ends

* Black-box entry subcircuit for sky130_fd_sc_hd__nor2_8 abstract view
.subckt sky130_fd_sc_hd__nor2_8 A B VGND VNB VPB VPWR Y
.ends

* Black-box entry subcircuit for sky130_fd_sc_hd__and4_4 abstract view
.subckt sky130_fd_sc_hd__and4_4 A B C D VGND VNB VPB VPWR X
.ends

* Black-box entry subcircuit for sky130_fd_sc_hd__a311o_2 abstract view
.subckt sky130_fd_sc_hd__a311o_2 A1 A2 A3 B1 C1 VGND VNB VPB VPWR X
.ends

* Black-box entry subcircuit for sky130_fd_sc_hd__a31oi_4 abstract view
.subckt sky130_fd_sc_hd__a31oi_4 A1 A2 A3 B1 VGND VNB VPB VPWR Y
.ends

* Black-box entry subcircuit for sky130_fd_sc_hd__and4_2 abstract view
.subckt sky130_fd_sc_hd__and4_2 A B C D VGND VNB VPB VPWR X
.ends

* Black-box entry subcircuit for sky130_fd_sc_hd__dlymetal6s4s_1 abstract view
.subckt sky130_fd_sc_hd__dlymetal6s4s_1 A VGND VNB VPB VPWR X
.ends

* Black-box entry subcircuit for sky130_fd_sc_hd__a21boi_2 abstract view
.subckt sky130_fd_sc_hd__a21boi_2 A1 A2 B1_N VGND VNB VPB VPWR Y
.ends

* Black-box entry subcircuit for sky130_fd_sc_hd__a21boi_4 abstract view
.subckt sky130_fd_sc_hd__a21boi_4 A1 A2 B1_N VGND VNB VPB VPWR Y
.ends

* Black-box entry subcircuit for sky130_fd_sc_hd__nand4_1 abstract view
.subckt sky130_fd_sc_hd__nand4_1 A B C D VGND VNB VPB VPWR Y
.ends

* Black-box entry subcircuit for sky130_fd_sc_hd__and4b_1 abstract view
.subckt sky130_fd_sc_hd__and4b_1 A_N B C D VGND VNB VPB VPWR X
.ends

* Black-box entry subcircuit for sky130_fd_sc_hd__a2bb2o_4 abstract view
.subckt sky130_fd_sc_hd__a2bb2o_4 A1_N A2_N B1 B2 VGND VNB VPB VPWR X
.ends

* Black-box entry subcircuit for sky130_fd_sc_hd__nor3b_1 abstract view
.subckt sky130_fd_sc_hd__nor3b_1 A B C_N VGND VNB VPB VPWR Y
.ends

* Black-box entry subcircuit for sky130_fd_sc_hd__o41ai_2 abstract view
.subckt sky130_fd_sc_hd__o41ai_2 A1 A2 A3 A4 B1 VGND VNB VPB VPWR Y
.ends

* Black-box entry subcircuit for sky130_fd_sc_hd__o31ai_1 abstract view
.subckt sky130_fd_sc_hd__o31ai_1 A1 A2 A3 B1 VGND VNB VPB VPWR Y
.ends

* Black-box entry subcircuit for sky130_fd_sc_hd__a2bb2o_2 abstract view
.subckt sky130_fd_sc_hd__a2bb2o_2 A1_N A2_N B1 B2 VGND VNB VPB VPWR X
.ends

* Black-box entry subcircuit for sky130_fd_sc_hd__a2111o_1 abstract view
.subckt sky130_fd_sc_hd__a2111o_1 A1 A2 B1 C1 D1 VGND VNB VPB VPWR X
.ends

* Black-box entry subcircuit for sky130_fd_sc_hd__o311ai_4 abstract view
.subckt sky130_fd_sc_hd__o311ai_4 A1 A2 A3 B1 C1 VGND VNB VPB VPWR Y
.ends

.subckt compute_core VGND VPWR clk pixel_in[0] pixel_in[1] pixel_in[2] pixel_in[3]
+ pixel_in[4] pixel_in[5] pixel_in[6] pixel_in[7] result_data[0] result_data[100]
+ result_data[101] result_data[102] result_data[103] result_data[104] result_data[105]
+ result_data[106] result_data[107] result_data[108] result_data[109] result_data[10]
+ result_data[110] result_data[111] result_data[112] result_data[113] result_data[114]
+ result_data[115] result_data[116] result_data[117] result_data[118] result_data[119]
+ result_data[11] result_data[120] result_data[121] result_data[122] result_data[123]
+ result_data[124] result_data[125] result_data[126] result_data[127] result_data[12]
+ result_data[13] result_data[14] result_data[15] result_data[16] result_data[17]
+ result_data[18] result_data[19] result_data[1] result_data[20] result_data[21] result_data[22]
+ result_data[23] result_data[24] result_data[25] result_data[26] result_data[27]
+ result_data[28] result_data[29] result_data[2] result_data[30] result_data[31] result_data[32]
+ result_data[33] result_data[34] result_data[35] result_data[36] result_data[37]
+ result_data[38] result_data[39] result_data[3] result_data[40] result_data[41] result_data[42]
+ result_data[43] result_data[44] result_data[45] result_data[46] result_data[47]
+ result_data[48] result_data[49] result_data[4] result_data[50] result_data[51] result_data[52]
+ result_data[53] result_data[54] result_data[55] result_data[56] result_data[57]
+ result_data[58] result_data[59] result_data[5] result_data[60] result_data[61] result_data[62]
+ result_data[63] result_data[64] result_data[65] result_data[66] result_data[67]
+ result_data[68] result_data[69] result_data[6] result_data[70] result_data[71] result_data[72]
+ result_data[73] result_data[74] result_data[75] result_data[76] result_data[77]
+ result_data[78] result_data[79] result_data[7] result_data[80] result_data[81] result_data[82]
+ result_data[83] result_data[84] result_data[85] result_data[86] result_data[87]
+ result_data[88] result_data[89] result_data[8] result_data[90] result_data[91] result_data[92]
+ result_data[93] result_data[94] result_data[95] result_data[96] result_data[97]
+ result_data[98] result_data[99] result_data[9] result_valid rst valid_in weight_addr[0]
+ weight_addr[1] weight_din[0] weight_din[1] weight_din[2] weight_din[3] weight_din[4]
+ weight_din[5] weight_din[6] weight_din[7] weight_wr
XFILLER_39_211 VGND VGND VPWR VPWR sky130_fd_sc_hd__fill_1
X_7963_ _3356_ _3357_ VGND VGND VPWR VPWR _3358_ sky130_fd_sc_hd__xnor2_2
XFILLER_67_597 VPWR VGND VPWR VGND sky130_ef_sc_hd__decap_12
XPHY_EDGE_ROW_6_Left_124 VGND VGND VPWR VPWR sky130_fd_sc_hd__decap_3
XFILLER_27_428 VGND VGND VPWR VPWR sky130_fd_sc_hd__decap_6
X_6914_ _2383_ _2322_ VGND VGND VPWR VPWR _2384_ sky130_fd_sc_hd__xnor2_2
X_7894_ _3271_ _3278_ _3270_ VGND VGND VPWR VPWR _3290_ sky130_fd_sc_hd__a21bo_1
XFILLER_82_589 VGND VGND VPWR VPWR sky130_fd_sc_hd__fill_2
XTAP_TAPCELL_ROW_81_1226 VGND VPWR sky130_fd_sc_hd__tapvpwrvgnd_1
X_6845_ net424 _2316_ VGND VGND VPWR VPWR _0299_ sky130_fd_sc_hd__nor2_1
XFILLER_52_29 VPWR VGND VPWR VGND sky130_ef_sc_hd__decap_12
XTAP_TAPCELL_ROW_61_982 VGND VPWR sky130_fd_sc_hd__tapvpwrvgnd_1
X_6776_ _2229_ _2231_ _2249_ VGND VGND VPWR VPWR _2250_ sky130_fd_sc_hd__a21o_1
XFILLER_50_475 VGND VGND VPWR VPWR sky130_fd_sc_hd__fill_1
XTAP_TAPCELL_ROW_33_651 VGND VPWR sky130_fd_sc_hd__tapvpwrvgnd_1
X_8515_ _3855_ _3857_ net597 _3893_ VGND VGND VPWR VPWR _3895_ sky130_fd_sc_hd__o211ai_1
X_5727_ pe_array\[0\].u_pe.accum_reg\[3\] net490 net356 VGND VGND VPWR VPWR _1269_
+ sky130_fd_sc_hd__and3_1
XFILLER_22_188 VGND VGND VPWR VPWR sky130_fd_sc_hd__decap_8
X_8446_ pe_array\[2\].u_pe.accum_reg\[19\] net441 net315 VGND VGND VPWR VPWR _3828_
+ sky130_fd_sc_hd__and3_1
X_5658_ net965 net363 VGND VGND VPWR VPWR _0199_ sky130_fd_sc_hd__and2_1
XTAP_TAPCELL_ROW_79_1199 VGND VPWR sky130_fd_sc_hd__tapvpwrvgnd_1
X_8377_ _3693_ _3726_ VGND VGND VPWR VPWR _3762_ sky130_fd_sc_hd__nand2b_4
X_5589_ net938 net373 VGND VGND VPWR VPWR _0130_ sky130_fd_sc_hd__and2_1
X_4609_ _4333_ _4334_ net536 _4371_ VGND VGND VPWR VPWR _4372_ sky130_fd_sc_hd__o211ai_2
XFILLER_89_111 VGND VGND VPWR VPWR sky130_fd_sc_hd__fill_1
X_7328_ _2786_ _2787_ VGND VGND VPWR VPWR _2788_ sky130_fd_sc_hd__nor2_1
Xhold384 pe_accum\[0\]\[26\] VGND VGND VPWR VPWR net899 sky130_fd_sc_hd__dlygate4sd3_1
Xhold395 pe_accum\[0\]\[25\] VGND VGND VPWR VPWR net910 sky130_fd_sc_hd__dlygate4sd3_1
XTAP_TAPCELL_ROW_92_1355 VGND VPWR sky130_fd_sc_hd__tapvpwrvgnd_1
XFILLER_89_133 VGND VGND VPWR VPWR sky130_fd_sc_hd__fill_1
X_7259_ _2718_ _2719_ _2699_ VGND VGND VPWR VPWR _2721_ sky130_fd_sc_hd__a21o_1
XFILLER_104_477 VPWR VGND VPWR VGND sky130_ef_sc_hd__decap_12
XTAP_TAPCELL_ROW_5_310 VGND VPWR sky130_fd_sc_hd__tapvpwrvgnd_1
XFILLER_85_383 VGND VGND VPWR VPWR sky130_fd_sc_hd__decap_8
XFILLER_45_214 VGND VGND VPWR VPWR sky130_fd_sc_hd__fill_2
XFILLER_93_69 VGND VGND VPWR VPWR sky130_fd_sc_hd__fill_2
XFILLER_14_601 VPWR VGND VPWR VGND sky130_ef_sc_hd__decap_12
XFILLER_26_74 VGND VGND VPWR VPWR sky130_fd_sc_hd__decap_8
XFILLER_53_291 VGND VGND VPWR VPWR sky130_fd_sc_hd__decap_8
XFILLER_13_133 VGND VGND VPWR VPWR sky130_fd_sc_hd__decap_6
XFILLER_13_111 VGND VGND VPWR VPWR sky130_fd_sc_hd__fill_1
XFILLER_14_645 VPWR VGND VPWR VGND sky130_ef_sc_hd__decap_12
XFILLER_26_85 VPWR VGND VPWR VGND sky130_ef_sc_hd__decap_12
XFILLER_13_166 VGND VGND VPWR VPWR sky130_fd_sc_hd__fill_2
XFILLER_13_144 VGND VGND VPWR VPWR sky130_fd_sc_hd__decap_6
XTAP_TAPCELL_ROW_101_1462 VGND VPWR sky130_fd_sc_hd__tapvpwrvgnd_1
XFILLER_13_199 VPWR VGND VPWR VGND sky130_ef_sc_hd__decap_12
XTAP_TAPCELL_ROW_11_389 VGND VPWR sky130_fd_sc_hd__tapvpwrvgnd_1
Xrebuffer7 net523 VGND VGND VPWR VPWR net522 sky130_fd_sc_hd__buf_1
XFILLER_107_293 VPWR VGND VPWR VGND sky130_ef_sc_hd__decap_12
XPHY_EDGE_ROW_79_Left_197 VGND VGND VPWR VPWR sky130_fd_sc_hd__decap_3
XFILLER_3_89 VGND VGND VPWR VPWR sky130_fd_sc_hd__decap_3
XFILLER_95_158 VGND VGND VPWR VPWR sky130_fd_sc_hd__fill_2
XFILLER_76_361 VGND VGND VPWR VPWR sky130_fd_sc_hd__decap_3
XFILLER_36_214 VGND VGND VPWR VPWR sky130_fd_sc_hd__fill_1
XFILLER_91_353 VGND VGND VPWR VPWR sky130_fd_sc_hd__fill_2
XFILLER_64_545 VPWR VGND VPWR VGND sky130_ef_sc_hd__decap_12
XFILLER_24_409 VGND VGND VPWR VPWR sky130_fd_sc_hd__fill_2
XFILLER_64_589 VPWR VGND VPWR VGND sky130_ef_sc_hd__decap_12
XTAP_TAPCELL_ROW_19_478 VGND VPWR sky130_fd_sc_hd__tapvpwrvgnd_1
X_4960_ _0702_ _0703_ _0704_ VGND VGND VPWR VPWR _0705_ sky130_fd_sc_hd__and3_1
XFILLER_32_442 VGND VGND VPWR VPWR sky130_fd_sc_hd__decap_6
X_4891_ _0503_ _0637_ _0551_ _0636_ _0592_ VGND VGND VPWR VPWR _0638_ sky130_fd_sc_hd__a311oi_2
X_6630_ _2109_ _2112_ _2144_ VGND VGND VPWR VPWR _2146_ sky130_fd_sc_hd__nor3_1
X_6561_ _1683_ _2050_ _2049_ VGND VGND VPWR VPWR _2079_ sky130_fd_sc_hd__a21oi_1
XFILLER_20_648 VGND VGND VPWR VPWR sky130_fd_sc_hd__fill_2
XTAP_TAPCELL_ROW_30_610 VGND VPWR sky130_fd_sc_hd__tapvpwrvgnd_1
X_8300_ _3684_ _3685_ _3686_ VGND VGND VPWR VPWR _3687_ sky130_fd_sc_hd__and3_1
X_5512_ net957 net246 _1216_ net363 VGND VGND VPWR VPWR _0066_ sky130_fd_sc_hd__o211a_1
X_6492_ pe_array\[0\].u_pe.accum_reg\[25\] net612 net357 VGND VGND VPWR VPWR _2012_
+ sky130_fd_sc_hd__and3_1
X_9280_ clknet_leaf_5_clk _0392_ VGND VGND VPWR VPWR pe_array\[2\].u_pe.accum_reg\[22\]
+ sky130_fd_sc_hd__dfxtp_1
X_8231_ _3619_ _3533_ _3618_ _3575_ VGND VGND VPWR VPWR _3620_ sky130_fd_sc_hd__a211o_4
X_5443_ _1141_ _1144_ _1170_ VGND VGND VPWR VPWR _1172_ sky130_fd_sc_hd__nor3_1
X_8162_ _3420_ _3550_ _3422_ VGND VGND VPWR VPWR _3552_ sky130_fd_sc_hd__o21bai_4
X_5374_ net208 _1104_ VGND VGND VPWR VPWR _1105_ sky130_fd_sc_hd__and2_1
XFILLER_113_230 VGND VGND VPWR VPWR sky130_fd_sc_hd__decap_6
X_7113_ net464 net452 net328 net326 VGND VGND VPWR VPWR _2578_ sky130_fd_sc_hd__and4_1
XFILLER_113_252 VGND VGND VPWR VPWR sky130_fd_sc_hd__fill_2
XFILLER_101_414 VGND VGND VPWR VPWR sky130_fd_sc_hd__decap_3
XFILLER_87_615 VGND VGND VPWR VPWR sky130_fd_sc_hd__fill_1
XFILLER_86_114 VPWR VGND VPWR VGND sky130_ef_sc_hd__decap_12
X_8093_ _3450_ _3484_ VGND VGND VPWR VPWR _3485_ sky130_fd_sc_hd__and2_1
XFILLER_101_447 VGND VGND VPWR VPWR sky130_fd_sc_hd__fill_1
X_7044_ _2509_ _2508_ _2502_ VGND VGND VPWR VPWR _2511_ sky130_fd_sc_hd__a21o_1
XFILLER_67_383 VGND VGND VPWR VPWR sky130_fd_sc_hd__decap_8
XTAP_TAPCELL_ROW_38_710 VGND VPWR sky130_fd_sc_hd__tapvpwrvgnd_1
X_8995_ clknet_leaf_26_clk _0107_ VGND VGND VPWR VPWR net63 sky130_fd_sc_hd__dfxtp_1
XFILLER_103_79 VPWR VGND VPWR VGND sky130_ef_sc_hd__decap_12
X_7946_ _3325_ _3339_ _3340_ VGND VGND VPWR VPWR _3341_ sky130_fd_sc_hd__nand3_1
XFILLER_63_39 VPWR VGND VPWR VGND sky130_ef_sc_hd__decap_12
X_7877_ net486 net478 net323 net324 VGND VGND VPWR VPWR _3274_ sky130_fd_sc_hd__and4_1
XFILLER_23_431 VGND VGND VPWR VPWR sky130_fd_sc_hd__decap_6
X_6828_ _2297_ _2298_ _2291_ VGND VGND VPWR VPWR _2300_ sky130_fd_sc_hd__a21o_1
XFILLER_11_615 VGND VGND VPWR VPWR sky130_fd_sc_hd__fill_1
XFILLER_109_503 VGND VGND VPWR VPWR sky130_fd_sc_hd__fill_1
X_6759_ _2220_ _2233_ VGND VGND VPWR VPWR _2234_ sky130_fd_sc_hd__nor2_1
XFILLER_6_107 VGND VGND VPWR VPWR sky130_fd_sc_hd__fill_1
X_8429_ _3809_ _3810_ net164 VGND VGND VPWR VPWR _3812_ sky130_fd_sc_hd__o21ai_1
XFILLER_77_125 VGND VGND VPWR VPWR sky130_fd_sc_hd__decap_3
XFILLER_92_106 VGND VGND VPWR VPWR sky130_fd_sc_hd__decap_6
XFILLER_77_158 VGND VGND VPWR VPWR sky130_fd_sc_hd__decap_8
XFILLER_46_567 VGND VGND VPWR VPWR sky130_fd_sc_hd__decap_4
XFILLER_61_515 VGND VGND VPWR VPWR sky130_fd_sc_hd__decap_8
XFILLER_46_589 VGND VGND VPWR VPWR sky130_fd_sc_hd__decap_4
XFILLER_61_559 VGND VGND VPWR VPWR sky130_fd_sc_hd__fill_1
XTAP_TAPCELL_ROW_16_448 VGND VPWR sky130_fd_sc_hd__tapvpwrvgnd_1
XFILLER_26_280 VGND VGND VPWR VPWR sky130_fd_sc_hd__fill_1
XTAP_TAPCELL_ROW_44_779 VGND VPWR sky130_fd_sc_hd__tapvpwrvgnd_1
XFILLER_10_670 VGND VGND VPWR VPWR sky130_fd_sc_hd__decap_8
XFILLER_6_641 VGND VGND VPWR VPWR sky130_fd_sc_hd__decap_3
XFILLER_5_140 VGND VGND VPWR VPWR sky130_fd_sc_hd__fill_1
XTAP_TAPCELL_ROW_114_1620 VGND VPWR sky130_fd_sc_hd__tapvpwrvgnd_1
XPHY_EDGE_ROW_87_Left_205 VGND VGND VPWR VPWR sky130_fd_sc_hd__decap_3
XFILLER_69_604 VPWR VGND VPWR VGND sky130_ef_sc_hd__decap_12
X_5090_ _0828_ _0829_ _0830_ VGND VGND VPWR VPWR _0831_ sky130_fd_sc_hd__and3_1
XFILLER_110_277 VPWR VGND VPWR VGND sky130_ef_sc_hd__decap_12
X_8780_ _4151_ VGND VGND VPWR VPWR _4152_ sky130_fd_sc_hd__inv_2
X_5992_ net455 net361 pe_array\[0\].u_pe.accum_reg\[10\] VGND VGND VPWR VPWR _1527_
+ sky130_fd_sc_hd__a21oi_1
X_7800_ net18 _3206_ _3207_ net292 VGND VGND VPWR VPWR _0363_ sky130_fd_sc_hd__a22o_1
XFILLER_52_515 VPWR VGND VPWR VGND sky130_ef_sc_hd__decap_12
XPHY_EDGE_ROW_96_Left_214 VGND VGND VPWR VPWR sky130_fd_sc_hd__decap_3
XFILLER_91_183 VGND VGND VPWR VPWR sky130_fd_sc_hd__fill_1
XTAP_TAPCELL_ROW_65_1029 VGND VPWR sky130_fd_sc_hd__tapvpwrvgnd_1
X_7731_ net226 _2221_ VGND VGND VPWR VPWR _3175_ sky130_fd_sc_hd__nand2_1
XFILLER_52_559 VGND VGND VPWR VPWR sky130_fd_sc_hd__fill_1
X_4943_ net186 _0599_ _0647_ VGND VGND VPWR VPWR _0688_ sky130_fd_sc_hd__mux2_4
X_7662_ _3108_ _3109_ VGND VGND VPWR VPWR _3110_ sky130_fd_sc_hd__nor2_1
X_6613_ pe_array\[0\].u_pe.accum_reg\[29\] _1393_ VGND VGND VPWR VPWR _2129_ sky130_fd_sc_hd__nor2_1
X_4874_ _0618_ _0619_ _0620_ VGND VGND VPWR VPWR _0621_ sky130_fd_sc_hd__nand3_4
X_7593_ pe_array\[1\].u_pe.accum_reg\[27\] net552 net341 VGND VGND VPWR VPWR _3043_
+ sky130_fd_sc_hd__and3_1
X_6544_ net409 pe_array\[0\].u_pe.accum_reg\[26\] net239 _2062_ VGND VGND VPWR VPWR
+ _2063_ sky130_fd_sc_hd__o2bb2a_1
X_6475_ _1995_ _1994_ VGND VGND VPWR VPWR _1996_ sky130_fd_sc_hd__and2b_1
X_9263_ clknet_3_4__leaf_clk _0375_ VGND VGND VPWR VPWR pe_array\[2\].u_pe.accum_reg\[5\]
+ sky130_fd_sc_hd__dfxtp_1
XFILLER_106_517 VGND VGND VPWR VPWR sky130_fd_sc_hd__decap_3
X_8214_ net675 _3601_ _3602_ VGND VGND VPWR VPWR _3603_ sky130_fd_sc_hd__nand3_4
X_5426_ net400 pe_array\[3\].u_pe.accum_reg\[29\] net258 _1155_ VGND VGND VPWR VPWR
+ _1156_ sky130_fd_sc_hd__o2bb2a_4
XTAP_TAPCELL_ROW_76_1169 VGND VPWR sky130_fd_sc_hd__tapvpwrvgnd_1
X_9194_ clknet_leaf_44_clk _0306_ VGND VGND VPWR VPWR pe_array\[1\].u_pe.accum_reg\[12\]
+ sky130_fd_sc_hd__dfxtp_1
XFILLER_99_261 VGND VGND VPWR VPWR sky130_fd_sc_hd__decap_3
X_8145_ _3534_ _3535_ VGND VGND VPWR VPWR _3536_ sky130_fd_sc_hd__or2_4
X_5357_ _1088_ _1087_ VGND VGND VPWR VPWR _1089_ sky130_fd_sc_hd__xnor2_2
X_8076_ net261 _3466_ _3467_ VGND VGND VPWR VPWR _3468_ sky130_fd_sc_hd__nor3_1
XFILLER_59_125 VGND VGND VPWR VPWR sky130_fd_sc_hd__decap_3
X_5288_ _1021_ _1020_ VGND VGND VPWR VPWR _1022_ sky130_fd_sc_hd__and2b_1
XFILLER_59_169 VGND VGND VPWR VPWR sky130_fd_sc_hd__decap_3
X_7027_ _2488_ _2493_ VGND VGND VPWR VPWR _2494_ sky130_fd_sc_hd__nand2b_1
XFILLER_101_277 VGND VGND VPWR VPWR sky130_fd_sc_hd__decap_3
XFILLER_74_139 VGND VGND VPWR VPWR sky130_fd_sc_hd__fill_1
XFILLER_68_681 VPWR VGND VPWR VGND sky130_ef_sc_hd__decap_12
XFILLER_28_501 VGND VGND VPWR VPWR sky130_fd_sc_hd__decap_3
X_8978_ clknet_leaf_22_clk _0090_ VGND VGND VPWR VPWR net94 sky130_fd_sc_hd__dfxtp_1
XFILLER_83_673 VPWR VGND VPWR VGND sky130_ef_sc_hd__decap_12
XFILLER_82_150 VGND VGND VPWR VPWR sky130_fd_sc_hd__decap_6
X_7929_ _3289_ _3317_ _3319_ _3318_ VGND VGND VPWR VPWR _3324_ sky130_fd_sc_hd__o31ai_2
XTAP_TAPCELL_ROW_87_1298 VGND VPWR sky130_fd_sc_hd__tapvpwrvgnd_1
XFILLER_30_209 VGND VGND VPWR VPWR sky130_fd_sc_hd__fill_1
XFILLER_70_389 VGND VGND VPWR VPWR sky130_fd_sc_hd__decap_8
XTAP_TAPCELL_ROW_13_407 VGND VPWR sky130_fd_sc_hd__tapvpwrvgnd_1
XTAP_TAPCELL_ROW_41_749 VGND VPWR sky130_fd_sc_hd__tapvpwrvgnd_1
XFILLER_7_405 VPWR VGND VPWR VGND sky130_ef_sc_hd__decap_12
XFILLER_7_449 VPWR VGND VPWR VGND sky130_ef_sc_hd__decap_12
XFILLER_78_467 VGND VGND VPWR VPWR sky130_fd_sc_hd__decap_8
XFILLER_38_309 VPWR VGND VPWR VGND sky130_ef_sc_hd__decap_12
Xfanout491 net4 VGND VGND VPWR VPWR net491 sky130_fd_sc_hd__clkbuf_2
Xfanout480 net482 VGND VGND VPWR VPWR net480 sky130_fd_sc_hd__buf_2
XFILLER_48_83 VGND VGND VPWR VPWR sky130_fd_sc_hd__fill_1
XTAP_TAPCELL_ROW_49_838 VGND VPWR sky130_fd_sc_hd__tapvpwrvgnd_1
XFILLER_74_673 VPWR VGND VPWR VGND sky130_ef_sc_hd__decap_12
XFILLER_0_57 VPWR VGND VPWR VGND sky130_ef_sc_hd__decap_12
XFILLER_64_71 VGND VGND VPWR VPWR sky130_fd_sc_hd__decap_6
XFILLER_9_55 VGND VGND VPWR VPWR sky130_fd_sc_hd__fill_1
XPHY_EDGE_ROW_104_Right_104 VGND VGND VPWR VPWR sky130_fd_sc_hd__decap_3
X_4590_ net418 _4353_ VGND VGND VPWR VPWR _0017_ sky130_fd_sc_hd__nor2_1
X_6260_ _1784_ _1785_ _1752_ _1754_ VGND VGND VPWR VPWR _1788_ sky130_fd_sc_hd__a211o_1
XFILLER_50_3 VPWR VGND VPWR VGND sky130_ef_sc_hd__decap_12
X_6191_ net278 _1719_ _1720_ VGND VGND VPWR VPWR _1721_ sky130_fd_sc_hd__nor3_1
X_5211_ _0890_ _0920_ _0892_ VGND VGND VPWR VPWR _0948_ sky130_fd_sc_hd__a21o_1
X_5142_ _0850_ _0852_ VGND VGND VPWR VPWR _0881_ sky130_fd_sc_hd__and2_1
XFILLER_96_253 VGND VGND VPWR VPWR sky130_fd_sc_hd__decap_6
XFILLER_96_242 VGND VGND VPWR VPWR sky130_fd_sc_hd__decap_8
XFILLER_57_607 VGND VGND VPWR VPWR sky130_fd_sc_hd__decap_3
XFILLER_111_597 VPWR VGND VPWR VGND sky130_ef_sc_hd__decap_12
X_5073_ net414 _0814_ VGND VGND VPWR VPWR _0029_ sky130_fd_sc_hd__nor2_1
X_8901_ clknet_leaf_53_clk _0013_ VGND VGND VPWR VPWR pe_array\[3\].u_pe.accum_reg\[1\]
+ sky130_fd_sc_hd__dfxtp_1
X_8832_ net214 _3287_ VGND VGND VPWR VPWR _4197_ sky130_fd_sc_hd__nand2_1
XFILLER_71_109 VGND VGND VPWR VPWR sky130_fd_sc_hd__decap_3
XFILLER_65_673 VGND VGND VPWR VPWR sky130_fd_sc_hd__decap_8
XFILLER_25_515 VPWR VGND VPWR VGND sky130_ef_sc_hd__decap_12
XFILLER_80_632 VPWR VGND VPWR VGND sky130_ef_sc_hd__decap_12
XFILLER_64_194 VGND VGND VPWR VPWR sky130_fd_sc_hd__fill_2
XFILLER_25_559 VGND VGND VPWR VPWR sky130_fd_sc_hd__fill_1
XFILLER_37_397 VGND VGND VPWR VPWR sky130_fd_sc_hd__fill_1
X_8763_ net192 _4133_ VGND VGND VPWR VPWR _4135_ sky130_fd_sc_hd__or2_1
X_5975_ _1470_ _1471_ _1469_ VGND VGND VPWR VPWR _1510_ sky130_fd_sc_hd__a21oi_1
XFILLER_40_518 VGND VGND VPWR VPWR sky130_fd_sc_hd__decap_8
X_8694_ pe_array\[2\].u_pe.accum_reg\[27\] _3508_ VGND VGND VPWR VPWR _4068_ sky130_fd_sc_hd__nor2_1
XFILLER_80_698 VGND VGND VPWR VPWR sky130_fd_sc_hd__fill_2
X_4926_ _0629_ _0627_ _0670_ _0671_ VGND VGND VPWR VPWR _0672_ sky130_fd_sc_hd__a211oi_4
X_7714_ _3127_ _3153_ _3156_ VGND VGND VPWR VPWR _3160_ sky130_fd_sc_hd__a21o_1
X_7645_ net156 _3093_ VGND VGND VPWR VPWR _3094_ sky130_fd_sc_hd__xnor2_1
X_4857_ net469 _4230_ VGND VGND VPWR VPWR _0604_ sky130_fd_sc_hd__nor2_1
XFILLER_60_29 VPWR VGND VPWR VGND sky130_ef_sc_hd__decap_12
X_7576_ _3026_ _3025_ VGND VGND VPWR VPWR _3027_ sky130_fd_sc_hd__and2b_1
X_9315_ clknet_leaf_7_clk _0427_ VGND VGND VPWR VPWR pe_accum\[2\]\[25\] sky130_fd_sc_hd__dfxtp_1
X_6527_ _2043_ _2044_ VGND VGND VPWR VPWR _2046_ sky130_fd_sc_hd__xnor2_1
X_4788_ _0492_ _0494_ _0534_ _0536_ VGND VGND VPWR VPWR _0537_ sky130_fd_sc_hd__a211oi_2
XFILLER_106_314 VPWR VGND VPWR VGND sky130_ef_sc_hd__decap_12
XFILLER_109_89 VGND VGND VPWR VPWR sky130_fd_sc_hd__fill_1
X_6458_ _1893_ _1978_ VGND VGND VPWR VPWR _1979_ sky130_fd_sc_hd__nor2_2
XFILLER_69_38 VGND VGND VPWR VPWR sky130_fd_sc_hd__fill_2
X_9246_ clknet_leaf_54_clk _0358_ VGND VGND VPWR VPWR pe_array\[3\].u_pe.weight_in\[0\]
+ sky130_fd_sc_hd__dfxtp_1
X_6389_ _1910_ _1911_ VGND VGND VPWR VPWR _1913_ sky130_fd_sc_hd__xnor2_1
X_9177_ clknet_leaf_20_clk _0289_ VGND VGND VPWR VPWR pe_accum\[0\]\[31\] sky130_fd_sc_hd__dfxtp_1
X_5409_ _1137_ _1138_ VGND VGND VPWR VPWR _1139_ sky130_fd_sc_hd__or2_1
X_8128_ _3505_ _3517_ _3518_ VGND VGND VPWR VPWR _3519_ sky130_fd_sc_hd__nand3_2
XFILLER_0_669 VGND VGND VPWR VPWR sky130_fd_sc_hd__decap_3
XFILLER_102_586 VGND VGND VPWR VPWR sky130_fd_sc_hd__fill_2
XTAP_TAPCELL_ROW_89_1327 VGND VPWR sky130_fd_sc_hd__tapvpwrvgnd_1
XTAP_TAPCELL_ROW_89_1316 VGND VPWR sky130_fd_sc_hd__tapvpwrvgnd_1
X_8059_ net477 _3422_ _3417_ VGND VGND VPWR VPWR _3451_ sky130_fd_sc_hd__a21o_1
XFILLER_48_629 VGND VGND VPWR VPWR sky130_fd_sc_hd__fill_1
XFILLER_90_418 VGND VGND VPWR VPWR sky130_fd_sc_hd__fill_2
XTAP_TAPCELL_ROW_46_808 VGND VPWR sky130_fd_sc_hd__tapvpwrvgnd_1
XFILLER_18_97 VGND VGND VPWR VPWR sky130_fd_sc_hd__decap_3
XFILLER_16_559 VPWR VGND VPWR VGND sky130_ef_sc_hd__decap_12
XTAP_TAPCELL_ROW_54_896 VGND VPWR sky130_fd_sc_hd__tapvpwrvgnd_1
XTAP_TAPCELL_ROW_26_565 VGND VPWR sky130_fd_sc_hd__tapvpwrvgnd_1
XFILLER_43_378 VPWR VGND VPWR VGND sky130_ef_sc_hd__decap_12
XFILLER_70_197 VGND VGND VPWR VPWR sky130_fd_sc_hd__decap_6
XFILLER_24_592 VPWR VGND VPWR VGND sky130_ef_sc_hd__decap_12
XFILLER_34_85 VGND VGND VPWR VPWR sky130_fd_sc_hd__fill_1
XFILLER_98_518 VPWR VGND VPWR VGND sky130_ef_sc_hd__decap_12
XFILLER_3_441 VGND VGND VPWR VPWR sky130_fd_sc_hd__decap_6
XFILLER_105_391 VGND VGND VPWR VPWR sky130_fd_sc_hd__fill_1
XFILLER_78_253 VGND VGND VPWR VPWR sky130_fd_sc_hd__decap_8
XTAP_TAPCELL_ROW_109_1563 VGND VPWR sky130_fd_sc_hd__tapvpwrvgnd_1
XFILLER_93_278 VGND VGND VPWR VPWR sky130_fd_sc_hd__fill_2
XFILLER_34_356 VGND VGND VPWR VPWR sky130_fd_sc_hd__decap_4
XFILLER_98_3 VPWR VGND VPWR VGND sky130_ef_sc_hd__decap_12
X_5760_ _1292_ _1300_ VGND VGND VPWR VPWR _1301_ sky130_fd_sc_hd__xor2_1
XFILLER_22_529 VGND VGND VPWR VPWR sky130_fd_sc_hd__decap_3
X_5691_ net1029 _1236_ net392 VGND VGND VPWR VPWR _1238_ sky130_fd_sc_hd__o21ai_1
X_4711_ _4433_ _0460_ VGND VGND VPWR VPWR _0462_ sky130_fd_sc_hd__xnor2_1
X_7430_ _2883_ _2884_ _2852_ _2853_ VGND VGND VPWR VPWR _2886_ sky130_fd_sc_hd__a211o_1
X_4642_ net299 net477 pe_array\[3\].u_pe.weight_in\[7\] VGND VGND VPWR VPWR _4404_
+ sky130_fd_sc_hd__a21o_1
XFILLER_116_601 VPWR VGND VPWR VGND sky130_ef_sc_hd__decap_12
X_7361_ _2818_ _2763_ _2819_ VGND VGND VPWR VPWR _2820_ sky130_fd_sc_hd__o21ba_4
X_4573_ net584 _4305_ _4335_ _4336_ VGND VGND VPWR VPWR _4337_ sky130_fd_sc_hd__o211ai_2
XFILLER_116_645 VPWR VGND VPWR VGND sky130_ef_sc_hd__decap_12
XFILLER_115_111 VGND VGND VPWR VPWR sky130_fd_sc_hd__fill_1
X_6312_ _1804_ _1776_ _1805_ VGND VGND VPWR VPWR _1839_ sky130_fd_sc_hd__a21oi_4
X_9100_ clknet_leaf_59_clk _0212_ VGND VGND VPWR VPWR net51 sky130_fd_sc_hd__dfxtp_1
X_7292_ _2749_ _2750_ _2751_ VGND VGND VPWR VPWR _2753_ sky130_fd_sc_hd__nand3_1
XFILLER_115_166 VGND VGND VPWR VPWR sky130_fd_sc_hd__fill_2
X_6243_ _1718_ _1736_ _1735_ VGND VGND VPWR VPWR _1772_ sky130_fd_sc_hd__a21bo_1
XTAP_TAPCELL_ROW_73_1128 VGND VPWR sky130_fd_sc_hd__tapvpwrvgnd_1
X_9031_ clknet_leaf_42_clk _0143_ VGND VGND VPWR VPWR net102 sky130_fd_sc_hd__dfxtp_1
X_6174_ _1702_ _1703_ _1678_ VGND VGND VPWR VPWR _1705_ sky130_fd_sc_hd__a21o_1
XFILLER_111_361 VGND VGND VPWR VPWR sky130_fd_sc_hd__decap_6
XFILLER_97_573 VPWR VGND VPWR VGND sky130_ef_sc_hd__decap_12
XFILLER_57_415 VGND VGND VPWR VPWR sky130_fd_sc_hd__decap_8
X_5125_ _0863_ _0864_ VGND VGND VPWR VPWR _0865_ sky130_fd_sc_hd__or2_4
XFILLER_111_383 VGND VGND VPWR VPWR sky130_fd_sc_hd__decap_8
X_5056_ _0794_ _0795_ _0796_ VGND VGND VPWR VPWR _0798_ sky130_fd_sc_hd__a21oi_1
XFILLER_44_109 VGND VGND VPWR VPWR sky130_fd_sc_hd__fill_1
XFILLER_25_301 VGND VGND VPWR VPWR sky130_fd_sc_hd__fill_1
X_8815_ _4183_ _4184_ VGND VGND VPWR VPWR _4185_ sky130_fd_sc_hd__xnor2_1
XTAP_TAPCELL_ROW_84_1257 VGND VPWR sky130_fd_sc_hd__tapvpwrvgnd_1
XFILLER_53_665 VGND VGND VPWR VPWR sky130_fd_sc_hd__fill_1
XFILLER_25_356 VGND VGND VPWR VPWR sky130_fd_sc_hd__decap_6
XFILLER_111_57 VPWR VGND VPWR VGND sky130_ef_sc_hd__decap_12
X_8746_ _4083_ _4118_ VGND VGND VPWR VPWR _4119_ sky130_fd_sc_hd__and2_1
XFILLER_80_495 VGND VGND VPWR VPWR sky130_fd_sc_hd__decap_4
X_5958_ _1476_ _1493_ _1492_ VGND VGND VPWR VPWR _1494_ sky130_fd_sc_hd__and3_1
XFILLER_40_326 VGND VGND VPWR VPWR sky130_fd_sc_hd__decap_6
XTAP_TAPCELL_ROW_23_524 VGND VPWR sky130_fd_sc_hd__tapvpwrvgnd_1
XTAP_TAPCELL_ROW_23_535 VGND VPWR sky130_fd_sc_hd__tapvpwrvgnd_1
X_4909_ net284 _0653_ _0654_ VGND VGND VPWR VPWR _0655_ sky130_fd_sc_hd__nor3_1
X_8677_ _4050_ _4051_ VGND VGND VPWR VPWR _4052_ sky130_fd_sc_hd__nor2_1
X_5889_ _1424_ _1425_ VGND VGND VPWR VPWR _1426_ sky130_fd_sc_hd__nor2_1
XTAP_TAPCELL_ROW_51_866 VGND VPWR sky130_fd_sc_hd__tapvpwrvgnd_1
X_7628_ pe_array\[1\].u_pe.accum_reg\[28\] _2367_ VGND VGND VPWR VPWR _3077_ sky130_fd_sc_hd__nor2_1
X_7559_ _3008_ _3009_ VGND VGND VPWR VPWR _3011_ sky130_fd_sc_hd__xnor2_1
XFILLER_107_656 VPWR VGND VPWR VGND sky130_ef_sc_hd__decap_12
XFILLER_106_133 VGND VGND VPWR VPWR sky130_fd_sc_hd__decap_6
XFILLER_106_122 VGND VGND VPWR VPWR sky130_fd_sc_hd__decap_8
XFILLER_20_21 VGND VGND VPWR VPWR sky130_fd_sc_hd__fill_1
XTAP_TAPCELL_ROW_95_1397 VGND VPWR sky130_fd_sc_hd__tapvpwrvgnd_1
X_9229_ clknet_leaf_50_clk _0341_ VGND VGND VPWR VPWR pe_accum\[1\]\[15\] sky130_fd_sc_hd__dfxtp_1
XFILLER_88_551 VPWR VGND VPWR VGND sky130_ef_sc_hd__decap_12
XFILLER_0_433 VPWR VGND VPWR VGND sky130_ef_sc_hd__decap_12
XFILLER_75_201 VPWR VGND VPWR VGND sky130_ef_sc_hd__decap_12
XFILLER_0_477 VPWR VGND VPWR VGND sky130_ef_sc_hd__decap_12
XFILLER_48_415 VGND VGND VPWR VPWR sky130_fd_sc_hd__decap_4
XFILLER_29_63 VGND VGND VPWR VPWR sky130_fd_sc_hd__decap_6
XFILLER_29_85 VGND VGND VPWR VPWR sky130_fd_sc_hd__fill_1
XTAP_TAPCELL_ROW_59_966 VGND VPWR sky130_fd_sc_hd__tapvpwrvgnd_1
XFILLER_90_226 VGND VGND VPWR VPWR sky130_fd_sc_hd__decap_8
XFILLER_75_289 VGND VGND VPWR VPWR sky130_fd_sc_hd__decap_8
XFILLER_56_492 VPWR VGND VPWR VGND sky130_ef_sc_hd__decap_12
XTAP_TAPCELL_ROW_3_293 VGND VPWR sky130_fd_sc_hd__tapvpwrvgnd_1
XFILLER_16_345 VPWR VGND VPWR VGND sky130_ef_sc_hd__decap_12
XFILLER_45_51 VGND VGND VPWR VPWR sky130_fd_sc_hd__decap_4
XFILLER_16_389 VPWR VGND VPWR VGND sky130_ef_sc_hd__decap_12
XFILLER_31_337 VGND VGND VPWR VPWR sky130_fd_sc_hd__decap_8
XFILLER_31_359 VGND VGND VPWR VPWR sky130_fd_sc_hd__decap_4
XPHY_EDGE_ROW_51_Left_169 VGND VGND VPWR VPWR sky130_fd_sc_hd__decap_3
XFILLER_12_595 VGND VGND VPWR VPWR sky130_fd_sc_hd__fill_1
XFILLER_12_584 VGND VGND VPWR VPWR sky130_fd_sc_hd__decap_4
XFILLER_8_533 VPWR VGND VPWR VGND sky130_ef_sc_hd__decap_12
XANTENNA_5 net18 VGND VGND VPWR VPWR sky130_fd_sc_hd__diode_2
XFILLER_113_615 VGND VGND VPWR VPWR sky130_fd_sc_hd__fill_1
XFILLER_3_260 VGND VGND VPWR VPWR sky130_fd_sc_hd__decap_3
XPHY_EDGE_ROW_60_Left_178 VGND VGND VPWR VPWR sky130_fd_sc_hd__decap_3
XFILLER_66_201 VGND VGND VPWR VPWR sky130_fd_sc_hd__fill_2
XFILLER_13_3 VPWR VGND VPWR VGND sky130_ef_sc_hd__decap_12
XFILLER_94_576 VPWR VGND VPWR VGND sky130_ef_sc_hd__decap_12
Xrebuffer17 _0438_ VGND VGND VPWR VPWR net532 sky130_fd_sc_hd__buf_6
XFILLER_54_429 VPWR VGND VPWR VGND sky130_ef_sc_hd__decap_12
Xrebuffer28 net541 VGND VGND VPWR VPWR net543 sky130_fd_sc_hd__dlygate4sd1_1
XFILLER_35_610 VGND VGND VPWR VPWR sky130_fd_sc_hd__decap_6
XFILLER_35_621 VGND VGND VPWR VPWR sky130_fd_sc_hd__fill_1
X_6930_ net495 net487 net329 net327 VGND VGND VPWR VPWR _2399_ sky130_fd_sc_hd__and4_1
Xrebuffer39 net555 VGND VGND VPWR VPWR net554 sky130_fd_sc_hd__dlygate4sd1_1
XFILLER_62_440 VPWR VGND VPWR VGND sky130_ef_sc_hd__decap_12
X_6861_ pe_array\[1\].u_pe.accum_reg\[6\] net465 net343 VGND VGND VPWR VPWR _2332_
+ sky130_fd_sc_hd__and3_1
XFILLER_34_120 VPWR VGND VPWR VGND sky130_ef_sc_hd__decap_12
XFILLER_35_643 VGND VGND VPWR VPWR sky130_fd_sc_hd__fill_2
X_8600_ _3758_ _3794_ _3976_ _3879_ VGND VGND VPWR VPWR _3977_ sky130_fd_sc_hd__nor4_4
X_5812_ net497 net348 VGND VGND VPWR VPWR _1351_ sky130_fd_sc_hd__nand2_1
X_6792_ _2263_ _2264_ net489 net336 VGND VGND VPWR VPWR _2265_ sky130_fd_sc_hd__and4bb_1
XFILLER_50_613 VPWR VGND VPWR VGND sky130_ef_sc_hd__decap_12
X_8531_ _3908_ _3909_ VGND VGND VPWR VPWR _3911_ sky130_fd_sc_hd__xor2_2
X_5743_ _1264_ _1282_ VGND VGND VPWR VPWR _1285_ sky130_fd_sc_hd__nor2_1
XFILLER_34_197 VGND VGND VPWR VPWR sky130_fd_sc_hd__decap_4
Xrebuffer129 net453 VGND VGND VPWR VPWR net644 sky130_fd_sc_hd__buf_6
X_8462_ _3840_ _3841_ _3842_ VGND VGND VPWR VPWR _3844_ sky130_fd_sc_hd__a21o_1
X_5674_ net422 _1230_ VGND VGND VPWR VPWR _1231_ sky130_fd_sc_hd__nor2_2
XFILLER_108_409 VGND VGND VPWR VPWR sky130_fd_sc_hd__decap_3
X_8393_ _3773_ _3774_ _3732_ _3734_ VGND VGND VPWR VPWR _3777_ sky130_fd_sc_hd__a211o_1
X_7413_ _2867_ _2868_ VGND VGND VPWR VPWR _2870_ sky130_fd_sc_hd__xor2_2
X_4625_ _4386_ _4387_ VGND VGND VPWR VPWR _4388_ sky130_fd_sc_hd__xor2_1
Xhold511 pe_array\[0\].u_pe.accum_reg\[1\] VGND VGND VPWR VPWR net1026 sky130_fd_sc_hd__dlygate4sd3_1
Xhold500 pe_accum\[3\]\[1\] VGND VGND VPWR VPWR net1015 sky130_fd_sc_hd__dlygate4sd3_1
X_7344_ net195 _2774_ _2772_ VGND VGND VPWR VPWR _2803_ sky130_fd_sc_hd__a21o_1
X_4556_ _4319_ _4320_ VGND VGND VPWR VPWR _4321_ sky130_fd_sc_hd__xnor2_1
XFILLER_116_497 VGND VGND VPWR VPWR sky130_fd_sc_hd__fill_1
XFILLER_116_475 VGND VGND VPWR VPWR sky130_fd_sc_hd__fill_1
XFILLER_104_637 VGND VGND VPWR VPWR sky130_fd_sc_hd__decap_6
XFILLER_89_337 VGND VGND VPWR VPWR sky130_fd_sc_hd__fill_1
X_7275_ _2703_ _2704_ _2734_ _2735_ VGND VGND VPWR VPWR _2736_ sky130_fd_sc_hd__o211a_1
X_4487_ net509 net305 net592 net306 VGND VGND VPWR VPWR _4255_ sky130_fd_sc_hd__a22o_1
XFILLER_104_659 VGND VGND VPWR VPWR sky130_fd_sc_hd__fill_1
X_6226_ _1752_ net278 _1753_ VGND VGND VPWR VPWR _1755_ sky130_fd_sc_hd__or3_4
X_9014_ clknet_leaf_41_clk _0126_ VGND VGND VPWR VPWR net84 sky130_fd_sc_hd__dfxtp_1
XFILLER_112_681 VPWR VGND VPWR VGND sky130_ef_sc_hd__decap_12
X_6157_ net277 _1686_ _1687_ VGND VGND VPWR VPWR _1688_ sky130_fd_sc_hd__nor3_1
XFILLER_85_521 VGND VGND VPWR VPWR sky130_fd_sc_hd__fill_2
X_5108_ net282 _0845_ _0846_ VGND VGND VPWR VPWR _0848_ sky130_fd_sc_hd__or3_4
X_6088_ _1618_ _1619_ _1620_ VGND VGND VPWR VPWR _1621_ sky130_fd_sc_hd__nand3_2
XTAP_TAPCELL_ROW_56_925 VGND VPWR sky130_fd_sc_hd__tapvpwrvgnd_1
X_5039_ net581 _0780_ VGND VGND VPWR VPWR _0782_ sky130_fd_sc_hd__nor2_4
XFILLER_82_27 VGND VGND VPWR VPWR sky130_fd_sc_hd__fill_1
XTAP_TAPCELL_ROW_0_241 VGND VPWR sky130_fd_sc_hd__tapvpwrvgnd_1
XTAP_TAPCELL_ROW_0_252 VGND VPWR sky130_fd_sc_hd__tapvpwrvgnd_1
XFILLER_25_142 VGND VGND VPWR VPWR sky130_fd_sc_hd__fill_1
XFILLER_80_270 VGND VGND VPWR VPWR sky130_fd_sc_hd__decap_8
XFILLER_53_484 VGND VGND VPWR VPWR sky130_fd_sc_hd__decap_4
XTAP_TAPCELL_ROW_36_682 VGND VPWR sky130_fd_sc_hd__tapvpwrvgnd_1
X_8729_ _4100_ _4101_ VGND VGND VPWR VPWR _4102_ sky130_fd_sc_hd__and2_1
XFILLER_15_98 VGND VGND VPWR VPWR sky130_fd_sc_hd__decap_8
XTAP_TAPCELL_ROW_97_1415 VGND VPWR sky130_fd_sc_hd__tapvpwrvgnd_1
XFILLER_5_514 VPWR VGND VPWR VGND sky130_ef_sc_hd__decap_12
XFILLER_31_53 VGND VGND VPWR VPWR sky130_fd_sc_hd__decap_3
XFILLER_5_569 VGND VGND VPWR VPWR sky130_fd_sc_hd__decap_8
Xoutput42 net42 VGND VGND VPWR VPWR result_data[118] sky130_fd_sc_hd__buf_2
Xoutput31 net31 VGND VGND VPWR VPWR result_data[108] sky130_fd_sc_hd__buf_2
Xoutput64 net64 VGND VGND VPWR VPWR result_data[22] sky130_fd_sc_hd__buf_2
Xoutput53 net53 VGND VGND VPWR VPWR result_data[12] sky130_fd_sc_hd__buf_2
Xoutput75 net75 VGND VGND VPWR VPWR result_data[32] sky130_fd_sc_hd__buf_2
XTAP_TAPCELL_ROW_8_352 VGND VPWR sky130_fd_sc_hd__tapvpwrvgnd_1
XFILLER_88_370 VGND VGND VPWR VPWR sky130_fd_sc_hd__fill_2
Xoutput97 net97 VGND VGND VPWR VPWR result_data[52] sky130_fd_sc_hd__buf_2
Xoutput86 net86 VGND VGND VPWR VPWR result_data[42] sky130_fd_sc_hd__buf_2
XFILLER_88_392 VGND VGND VPWR VPWR sky130_fd_sc_hd__decap_3
XFILLER_48_212 VGND VGND VPWR VPWR sky130_fd_sc_hd__decap_8
XFILLER_102_191 VGND VGND VPWR VPWR sky130_fd_sc_hd__fill_1
XFILLER_76_587 VGND VGND VPWR VPWR sky130_fd_sc_hd__fill_1
XFILLER_48_256 VGND VGND VPWR VPWR sky130_fd_sc_hd__fill_1
XFILLER_56_83 VGND VGND VPWR VPWR sky130_fd_sc_hd__fill_1
XFILLER_29_470 VGND VGND VPWR VPWR sky130_fd_sc_hd__fill_1
XTAP_TAPCELL_ROW_106_1522 VGND VPWR sky130_fd_sc_hd__tapvpwrvgnd_1
XFILLER_91_579 VPWR VGND VPWR VGND sky130_ef_sc_hd__decap_12
XFILLER_16_153 VPWR VGND VPWR VGND sky130_ef_sc_hd__decap_12
XFILLER_32_613 VGND VGND VPWR VPWR sky130_fd_sc_hd__decap_4
XFILLER_16_197 VPWR VGND VPWR VGND sky130_ef_sc_hd__decap_12
XFILLER_32_657 VGND VGND VPWR VPWR sky130_fd_sc_hd__fill_1
XFILLER_72_93 VGND VGND VPWR VPWR sky130_fd_sc_hd__fill_1
XFILLER_117_217 VGND VGND VPWR VPWR sky130_fd_sc_hd__decap_3
XFILLER_8_363 VGND VGND VPWR VPWR sky130_fd_sc_hd__fill_1
XFILLER_8_341 VGND VGND VPWR VPWR sky130_fd_sc_hd__fill_1
XTAP_TAPCELL_ROW_117_1673 VGND VPWR sky130_fd_sc_hd__tapvpwrvgnd_1
XTAP_TAPCELL_ROW_117_1662 VGND VPWR sky130_fd_sc_hd__tapvpwrvgnd_1
X_5390_ _1084_ _1119_ VGND VGND VPWR VPWR _1121_ sky130_fd_sc_hd__xor2_1
XFILLER_113_412 VPWR VGND VPWR VGND sky130_ef_sc_hd__decap_12
XFILLER_99_646 VGND VGND VPWR VPWR sky130_fd_sc_hd__decap_4
XFILLER_98_112 VGND VGND VPWR VPWR sky130_fd_sc_hd__fill_1
XFILLER_99_657 VGND VGND VPWR VPWR sky130_fd_sc_hd__decap_6
Xfanout309 pe_array\[2\].u_pe.weight_in\[6\] VGND VGND VPWR VPWR net309 sky130_fd_sc_hd__clkbuf_2
X_7060_ _2435_ _2436_ _2434_ VGND VGND VPWR VPWR _2527_ sky130_fd_sc_hd__o21a_1
XFILLER_98_189 VGND VGND VPWR VPWR sky130_fd_sc_hd__decap_6
XFILLER_86_329 VGND VGND VPWR VPWR sky130_fd_sc_hd__fill_1
X_6011_ _1497_ _1499_ VGND VGND VPWR VPWR _1546_ sky130_fd_sc_hd__nand2_1
XFILLER_39_223 VGND VGND VPWR VPWR sky130_fd_sc_hd__fill_1
XFILLER_27_407 VGND VGND VPWR VPWR sky130_fd_sc_hd__decap_6
XFILLER_94_373 VGND VGND VPWR VPWR sky130_fd_sc_hd__fill_2
X_7962_ _3285_ _3316_ _3315_ VGND VGND VPWR VPWR _3357_ sky130_fd_sc_hd__o21ai_1
XFILLER_39_278 VGND VGND VPWR VPWR sky130_fd_sc_hd__fill_2
XFILLER_35_440 VGND VGND VPWR VPWR sky130_fd_sc_hd__decap_8
X_6913_ _2381_ _2380_ VGND VGND VPWR VPWR _2383_ sky130_fd_sc_hd__xor2_2
X_7893_ _3241_ _3258_ _3286_ VGND VGND VPWR VPWR _3289_ sky130_fd_sc_hd__or3_1
XTAP_TAPCELL_ROW_81_1227 VGND VPWR sky130_fd_sc_hd__tapvpwrvgnd_1
X_6844_ net406 pe_array\[1\].u_pe.accum_reg\[5\] net231 _2315_ VGND VGND VPWR VPWR
+ _2316_ sky130_fd_sc_hd__o2bb2a_1
XFILLER_52_19 VGND VGND VPWR VPWR sky130_fd_sc_hd__decap_8
XFILLER_50_421 VPWR VGND VPWR VGND sky130_ef_sc_hd__decap_12
XFILLER_23_657 VGND VGND VPWR VPWR sky130_fd_sc_hd__decap_6
X_6775_ _2245_ _2248_ VGND VGND VPWR VPWR _2249_ sky130_fd_sc_hd__xnor2_1
XFILLER_10_307 VGND VGND VPWR VPWR sky130_fd_sc_hd__fill_1
XFILLER_22_145 VGND VGND VPWR VPWR sky130_fd_sc_hd__fill_2
XTAP_TAPCELL_ROW_33_652 VGND VPWR sky130_fd_sc_hd__tapvpwrvgnd_1
X_8514_ _3855_ _3857_ _3892_ _3893_ VGND VGND VPWR VPWR _3894_ sky130_fd_sc_hd__o211a_1
X_5726_ net490 net356 pe_array\[0\].u_pe.accum_reg\[3\] VGND VGND VPWR VPWR _1268_
+ sky130_fd_sc_hd__a21oi_1
XTAP_TAPCELL_ROW_61_983 VGND VPWR sky130_fd_sc_hd__tapvpwrvgnd_1
X_8445_ net441 net315 pe_array\[2\].u_pe.accum_reg\[19\] VGND VGND VPWR VPWR _3827_
+ sky130_fd_sc_hd__a21oi_1
XPHY_EDGE_ROW_107_Left_225 VGND VGND VPWR VPWR sky130_fd_sc_hd__decap_3
X_5657_ net905 net369 VGND VGND VPWR VPWR _0198_ sky130_fd_sc_hd__and2_1
X_8376_ _3656_ _3615_ _3655_ VGND VGND VPWR VPWR _3761_ sky130_fd_sc_hd__o21a_1
X_5588_ net976 net376 VGND VGND VPWR VPWR _0129_ sky130_fd_sc_hd__and2_1
X_4608_ _4367_ _4368_ net302 net477 VGND VGND VPWR VPWR _4371_ sky130_fd_sc_hd__a2bb2o_1
XFILLER_2_528 VGND VGND VPWR VPWR sky130_fd_sc_hd__decap_4
X_7327_ _2747_ _2749_ VGND VGND VPWR VPWR _2787_ sky130_fd_sc_hd__and2_1
X_4539_ pe_array\[3\].u_pe.accum_reg\[4\] net500 net300 VGND VGND VPWR VPWR _4304_
+ sky130_fd_sc_hd__and3_4
Xhold385 pe_accum\[0\]\[1\] VGND VGND VPWR VPWR net900 sky130_fd_sc_hd__dlygate4sd3_1
XTAP_TAPCELL_ROW_92_1356 VGND VPWR sky130_fd_sc_hd__tapvpwrvgnd_1
Xhold396 pe_accum\[1\]\[2\] VGND VGND VPWR VPWR net911 sky130_fd_sc_hd__dlygate4sd3_1
X_7258_ _2699_ _2718_ _2719_ VGND VGND VPWR VPWR _2720_ sky130_fd_sc_hd__nand3_1
XFILLER_104_489 VPWR VGND VPWR VGND sky130_ef_sc_hd__decap_12
X_6209_ _1702_ _1704_ VGND VGND VPWR VPWR _1739_ sky130_fd_sc_hd__nand2_1
XTAP_TAPCELL_ROW_5_311 VGND VPWR sky130_fd_sc_hd__tapvpwrvgnd_1
X_7189_ _2607_ _2650_ _2651_ VGND VGND VPWR VPWR _2653_ sky130_fd_sc_hd__nand3_1
XPHY_EDGE_ROW_116_Left_234 VGND VGND VPWR VPWR sky130_fd_sc_hd__decap_3
Xclkbuf_3_6__f_clk clknet_0_clk VGND VGND VPWR VPWR clknet_3_6__leaf_clk sky130_fd_sc_hd__clkbuf_16
XFILLER_14_613 VPWR VGND VPWR VGND sky130_ef_sc_hd__decap_12
XFILLER_26_462 VGND VGND VPWR VPWR sky130_fd_sc_hd__fill_1
XFILLER_81_590 VGND VGND VPWR VPWR sky130_fd_sc_hd__decap_8
XFILLER_53_281 VGND VGND VPWR VPWR sky130_fd_sc_hd__decap_3
XFILLER_14_657 VGND VGND VPWR VPWR sky130_fd_sc_hd__decap_6
XFILLER_26_97 VGND VGND VPWR VPWR sky130_fd_sc_hd__decap_8
XTAP_TAPCELL_ROW_101_1463 VGND VPWR sky130_fd_sc_hd__tapvpwrvgnd_1
XFILLER_13_189 VGND VGND VPWR VPWR sky130_fd_sc_hd__decap_6
XFILLER_42_41 VPWR VGND VPWR VGND sky130_ef_sc_hd__decap_12
XFILLER_42_85 VGND VGND VPWR VPWR sky130_fd_sc_hd__fill_2
Xrebuffer8 _2475_ VGND VGND VPWR VPWR net523 sky130_fd_sc_hd__buf_1
XFILLER_1_561 VPWR VGND VPWR VGND sky130_ef_sc_hd__decap_12
XTAP_TAPCELL_ROW_112_1592 VGND VPWR sky130_fd_sc_hd__tapvpwrvgnd_1
XFILLER_3_57 VPWR VGND VPWR VGND sky130_ef_sc_hd__decap_12
XFILLER_76_373 VGND VGND VPWR VPWR sky130_fd_sc_hd__fill_2
XFILLER_64_513 VGND VGND VPWR VPWR sky130_fd_sc_hd__fill_1
XFILLER_49_587 VPWR VGND VPWR VGND sky130_ef_sc_hd__decap_12
XFILLER_64_557 VGND VGND VPWR VPWR sky130_fd_sc_hd__decap_8
XFILLER_91_387 VGND VGND VPWR VPWR sky130_fd_sc_hd__fill_2
XFILLER_91_376 VGND VGND VPWR VPWR sky130_fd_sc_hd__fill_1
XTAP_TAPCELL_ROW_67_1060 VGND VPWR sky130_fd_sc_hd__tapvpwrvgnd_1
XTAP_TAPCELL_ROW_19_479 VGND VPWR sky130_fd_sc_hd__tapvpwrvgnd_1
XFILLER_17_484 VGND VGND VPWR VPWR sky130_fd_sc_hd__fill_2
X_4890_ _0545_ _0546_ _0591_ _0592_ VGND VGND VPWR VPWR _0637_ sky130_fd_sc_hd__nor4_4
XFILLER_32_465 VGND VGND VPWR VPWR sky130_fd_sc_hd__decap_8
X_6560_ _2076_ _2077_ VGND VGND VPWR VPWR _2078_ sky130_fd_sc_hd__and2b_1
XFILLER_80_3 VGND VGND VPWR VPWR sky130_fd_sc_hd__fill_1
XTAP_TAPCELL_ROW_30_611 VGND VPWR sky130_fd_sc_hd__tapvpwrvgnd_1
X_5511_ _0952_ net246 VGND VGND VPWR VPWR _1216_ sky130_fd_sc_hd__nand2_1
X_6491_ net431 _2011_ VGND VGND VPWR VPWR _0250_ sky130_fd_sc_hd__nor2_1
X_8230_ _3532_ _3576_ VGND VGND VPWR VPWR _3619_ sky130_fd_sc_hd__and2_4
X_5442_ _1141_ _1144_ _1170_ VGND VGND VPWR VPWR _1171_ sky130_fd_sc_hd__o21a_1
X_8161_ _3420_ _3550_ _3422_ VGND VGND VPWR VPWR _3551_ sky130_fd_sc_hd__o21ba_4
X_5373_ _1101_ _1102_ VGND VGND VPWR VPWR _1104_ sky130_fd_sc_hd__xor2_1
X_8092_ _3482_ _3483_ VGND VGND VPWR VPWR _3484_ sky130_fd_sc_hd__nor2_1
X_7112_ net452 net328 net326 net464 VGND VGND VPWR VPWR _2577_ sky130_fd_sc_hd__a22oi_1
XFILLER_99_487 VPWR VGND VPWR VGND sky130_ef_sc_hd__decap_12
X_7043_ _2502_ net547 _2508_ VGND VGND VPWR VPWR _2510_ sky130_fd_sc_hd__nand3_2
XFILLER_113_297 VGND VGND VPWR VPWR sky130_fd_sc_hd__decap_8
XFILLER_87_649 VPWR VGND VPWR VGND sky130_ef_sc_hd__decap_12
XFILLER_86_126 VGND VGND VPWR VPWR sky130_fd_sc_hd__decap_6
XFILLER_47_19 VPWR VGND VPWR VGND sky130_ef_sc_hd__decap_12
XTAP_TAPCELL_ROW_38_711 VGND VPWR sky130_fd_sc_hd__tapvpwrvgnd_1
X_8994_ clknet_leaf_26_clk _0106_ VGND VGND VPWR VPWR net62 sky130_fd_sc_hd__dfxtp_1
XFILLER_94_181 VPWR VGND VPWR VGND sky130_ef_sc_hd__decap_12
XFILLER_82_365 VGND VGND VPWR VPWR sky130_fd_sc_hd__fill_2
X_7945_ _3331_ _3332_ _3338_ VGND VGND VPWR VPWR _3340_ sky130_fd_sc_hd__a21o_1
XFILLER_70_516 VGND VGND VPWR VPWR sky130_fd_sc_hd__fill_1
X_7876_ net512 pe_array\[2\].u_pe.weight_in\[4\] VGND VGND VPWR VPWR _3273_ sky130_fd_sc_hd__nand2_1
XFILLER_23_410 VGND VGND VPWR VPWR sky130_fd_sc_hd__fill_1
XFILLER_35_281 VPWR VGND VPWR VGND sky130_ef_sc_hd__decap_12
X_6827_ _2291_ _2297_ _2298_ VGND VGND VPWR VPWR _2299_ sky130_fd_sc_hd__nand3_1
XFILLER_50_251 VGND VGND VPWR VPWR sky130_fd_sc_hd__fill_1
X_6758_ _2231_ _2232_ VGND VGND VPWR VPWR _2233_ sky130_fd_sc_hd__nand2_1
X_6689_ _0085_ _1250_ _1251_ net233 net900 VGND VGND VPWR VPWR _0259_ sky130_fd_sc_hd__a32o_1
X_5709_ net428 _1252_ VGND VGND VPWR VPWR _0227_ sky130_fd_sc_hd__nor2_1
X_8428_ net161 _3809_ _3810_ VGND VGND VPWR VPWR _3811_ sky130_fd_sc_hd__or3_1
X_8359_ _3740_ _3741_ _3742_ VGND VGND VPWR VPWR _3744_ sky130_fd_sc_hd__a21oi_1
XFILLER_104_253 VGND VGND VPWR VPWR sky130_fd_sc_hd__decap_3
XFILLER_58_395 VGND VGND VPWR VPWR sky130_fd_sc_hd__decap_8
XFILLER_46_546 VGND VGND VPWR VPWR sky130_fd_sc_hd__decap_4
XFILLER_61_505 VGND VGND VPWR VPWR sky130_fd_sc_hd__fill_1
XFILLER_14_421 VPWR VGND VPWR VGND sky130_ef_sc_hd__decap_12
XFILLER_53_51 VGND VGND VPWR VPWR sky130_fd_sc_hd__decap_4
XTAP_TAPCELL_ROW_16_449 VGND VPWR sky130_fd_sc_hd__tapvpwrvgnd_1
XFILLER_41_251 VGND VGND VPWR VPWR sky130_fd_sc_hd__decap_6
XTAP_TAPCELL_ROW_114_1621 VGND VPWR sky130_fd_sc_hd__tapvpwrvgnd_1
XFILLER_52_7 VPWR VGND VPWR VGND sky130_ef_sc_hd__decap_12
XFILLER_5_152 VGND VGND VPWR VPWR sky130_fd_sc_hd__decap_4
XFILLER_110_289 VPWR VGND VPWR VGND sky130_ef_sc_hd__decap_12
XFILLER_77_671 VGND VGND VPWR VPWR sky130_fd_sc_hd__fill_1
XFILLER_37_524 VPWR VGND VPWR VGND sky130_ef_sc_hd__decap_12
XFILLER_49_384 VGND VGND VPWR VPWR sky130_fd_sc_hd__fill_2
XFILLER_64_321 VPWR VGND VPWR VGND sky130_ef_sc_hd__decap_12
X_5991_ pe_array\[0\].u_pe.accum_reg\[10\] net455 net361 VGND VGND VPWR VPWR _1526_
+ sky130_fd_sc_hd__and3_1
XFILLER_64_376 VPWR VGND VPWR VGND sky130_ef_sc_hd__decap_12
XFILLER_64_365 VGND VGND VPWR VPWR sky130_fd_sc_hd__decap_4
XFILLER_52_527 VGND VGND VPWR VPWR sky130_fd_sc_hd__decap_4
XFILLER_37_579 VPWR VGND VPWR VGND sky130_ef_sc_hd__decap_12
X_7730_ net1009 net226 _3174_ net390 VGND VGND VPWR VPWR _0326_ sky130_fd_sc_hd__o211a_1
XFILLER_17_281 VGND VGND VPWR VPWR sky130_fd_sc_hd__decap_8
X_4942_ _0601_ _0685_ VGND VGND VPWR VPWR _0687_ sky130_fd_sc_hd__xnor2_1
X_7661_ _3106_ _3107_ net272 VGND VGND VPWR VPWR _3109_ sky130_fd_sc_hd__o21a_1
X_6612_ net429 _2128_ VGND VGND VPWR VPWR _0254_ sky130_fd_sc_hd__nor2_1
XFILLER_60_560 VPWR VGND VPWR VGND sky130_ef_sc_hd__decap_12
X_4873_ net207 _0576_ _0574_ VGND VGND VPWR VPWR _0620_ sky130_fd_sc_hd__a21o_1
X_7592_ _3042_ net424 VGND VGND VPWR VPWR _0320_ sky130_fd_sc_hd__nor2_1
X_6543_ _2060_ _2061_ VGND VGND VPWR VPWR _2062_ sky130_fd_sc_hd__xnor2_2
X_6474_ net198 _1958_ _1957_ VGND VGND VPWR VPWR _1995_ sky130_fd_sc_hd__o21ba_1
X_9262_ clknet_leaf_14_clk _0374_ VGND VGND VPWR VPWR pe_array\[2\].u_pe.accum_reg\[4\]
+ sky130_fd_sc_hd__dfxtp_1
X_8213_ net190 _3560_ _3558_ VGND VGND VPWR VPWR _3602_ sky130_fd_sc_hd__a21o_1
XPHY_EDGE_ROW_12_Right_12 VGND VGND VPWR VPWR sky130_fd_sc_hd__decap_3
X_5425_ _1153_ _1154_ VGND VGND VPWR VPWR _1155_ sky130_fd_sc_hd__xnor2_2
X_9193_ clknet_leaf_38_clk _0305_ VGND VGND VPWR VPWR pe_array\[1\].u_pe.accum_reg\[11\]
+ sky130_fd_sc_hd__dfxtp_1
XFILLER_114_540 VPWR VGND VPWR VGND sky130_ef_sc_hd__decap_12
XFILLER_99_240 VGND VGND VPWR VPWR sky130_fd_sc_hd__fill_2
X_8144_ _3490_ _3532_ _3533_ VGND VGND VPWR VPWR _3535_ sky130_fd_sc_hd__nor3_1
XFILLER_58_29 VPWR VGND VPWR VGND sky130_ef_sc_hd__decap_12
X_5356_ _1061_ _1059_ VGND VGND VPWR VPWR _1088_ sky130_fd_sc_hd__nor2_2
X_8075_ pe_array\[2\].u_pe.accum_reg\[9\] net462 net317 VGND VGND VPWR VPWR _3467_
+ sky130_fd_sc_hd__and3_1
X_5287_ _0567_ _0994_ _0992_ VGND VGND VPWR VPWR _1021_ sky130_fd_sc_hd__a21oi_1
X_7026_ _2491_ _2492_ VGND VGND VPWR VPWR _2493_ sky130_fd_sc_hd__xnor2_1
XFILLER_68_693 VGND VGND VPWR VPWR sky130_fd_sc_hd__decap_6
XFILLER_67_192 VGND VGND VPWR VPWR sky130_fd_sc_hd__decap_3
X_8977_ clknet_leaf_22_clk _0089_ VGND VGND VPWR VPWR net83 sky130_fd_sc_hd__dfxtp_1
XFILLER_83_685 VPWR VGND VPWR VGND sky130_ef_sc_hd__decap_12
XPHY_EDGE_ROW_21_Right_21 VGND VGND VPWR VPWR sky130_fd_sc_hd__decap_3
XFILLER_43_505 VGND VGND VPWR VPWR sky130_fd_sc_hd__fill_1
XTAP_TAPCELL_ROW_87_1299 VGND VPWR sky130_fd_sc_hd__tapvpwrvgnd_1
X_7928_ net421 _3323_ VGND VGND VPWR VPWR _0375_ sky130_fd_sc_hd__nor2_1
XFILLER_82_195 VGND VGND VPWR VPWR sky130_fd_sc_hd__fill_1
XFILLER_70_335 VGND VGND VPWR VPWR sky130_fd_sc_hd__fill_2
XFILLER_43_538 VGND VGND VPWR VPWR sky130_fd_sc_hd__decap_3
X_7859_ _3235_ _3256_ VGND VGND VPWR VPWR _3257_ sky130_fd_sc_hd__xnor2_1
XTAP_TAPCELL_ROW_13_408 VGND VPWR sky130_fd_sc_hd__tapvpwrvgnd_1
XFILLER_23_251 VGND VGND VPWR VPWR sky130_fd_sc_hd__decap_6
XFILLER_7_417 VPWR VGND VPWR VGND sky130_ef_sc_hd__decap_12
XPHY_EDGE_ROW_30_Right_30 VGND VGND VPWR VPWR sky130_fd_sc_hd__decap_3
XFILLER_78_402 VGND VGND VPWR VPWR sky130_fd_sc_hd__decap_6
XFILLER_78_446 VGND VGND VPWR VPWR sky130_fd_sc_hd__decap_3
XFILLER_65_129 VPWR VGND VPWR VGND sky130_ef_sc_hd__decap_12
Xfanout481 net482 VGND VGND VPWR VPWR net481 sky130_fd_sc_hd__clkbuf_2
XFILLER_59_660 VPWR VGND VPWR VGND sky130_ef_sc_hd__decap_12
Xfanout470 net471 VGND VGND VPWR VPWR net470 sky130_fd_sc_hd__buf_2
Xfanout492 net499 VGND VGND VPWR VPWR net492 sky130_fd_sc_hd__buf_2
XTAP_TAPCELL_ROW_49_839 VGND VPWR sky130_fd_sc_hd__tapvpwrvgnd_1
XFILLER_74_630 VGND VGND VPWR VPWR sky130_fd_sc_hd__fill_2
XFILLER_74_685 VGND VGND VPWR VPWR sky130_fd_sc_hd__decap_8
XFILLER_0_69 VPWR VGND VPWR VGND sky130_ef_sc_hd__decap_12
XTAP_TAPCELL_ROW_29_596 VGND VPWR sky130_fd_sc_hd__tapvpwrvgnd_1
XFILLER_34_549 VGND VGND VPWR VPWR sky130_fd_sc_hd__fill_2
XFILLER_61_368 VGND VGND VPWR VPWR sky130_fd_sc_hd__fill_1
XFILLER_14_251 VGND VGND VPWR VPWR sky130_fd_sc_hd__fill_1
XFILLER_80_93 VGND VGND VPWR VPWR sky130_fd_sc_hd__fill_1
XFILLER_80_82 VGND VGND VPWR VPWR sky130_fd_sc_hd__fill_2
XFILLER_10_490 VPWR VGND VPWR VGND sky130_ef_sc_hd__decap_12
X_5210_ _0919_ _0945_ VGND VGND VPWR VPWR _0947_ sky130_fd_sc_hd__xnor2_2
XFILLER_89_80 VGND VGND VPWR VPWR sky130_fd_sc_hd__decap_3
X_6190_ pe_array\[0\].u_pe.accum_reg\[15\] net457 net360 VGND VGND VPWR VPWR _1720_
+ sky130_fd_sc_hd__and3_1
XFILLER_43_3 VPWR VGND VPWR VGND sky130_ef_sc_hd__decap_12
X_5141_ net205 _0879_ VGND VGND VPWR VPWR _0880_ sky130_fd_sc_hd__xnor2_1
XFILLER_69_457 VGND VGND VPWR VPWR sky130_fd_sc_hd__decap_3
X_5072_ net397 pe_array\[3\].u_pe.accum_reg\[17\] net256 _0813_ VGND VGND VPWR VPWR
+ _0814_ sky130_fd_sc_hd__o2bb2a_4
XFILLER_84_405 VGND VGND VPWR VPWR sky130_fd_sc_hd__fill_2
X_8900_ clknet_leaf_57_clk _0012_ VGND VGND VPWR VPWR pe_array\[3\].u_pe.accum_reg\[0\]
+ sky130_fd_sc_hd__dfxtp_1
XFILLER_84_449 VGND VGND VPWR VPWR sky130_fd_sc_hd__fill_1
XFILLER_65_641 VPWR VGND VPWR VGND sky130_ef_sc_hd__decap_12
XFILLER_37_332 VGND VGND VPWR VPWR sky130_fd_sc_hd__decap_4
X_8831_ net968 net214 _4196_ net388 VGND VGND VPWR VPWR _0405_ sky130_fd_sc_hd__o211a_1
X_8762_ _3551_ _4133_ VGND VGND VPWR VPWR _4134_ sky130_fd_sc_hd__nand2_1
XFILLER_25_527 VPWR VGND VPWR VGND sky130_ef_sc_hd__decap_12
X_5974_ net432 _1509_ VGND VGND VPWR VPWR _0235_ sky130_fd_sc_hd__nor2_1
X_7713_ _3159_ net426 VGND VGND VPWR VPWR _0324_ sky130_fd_sc_hd__nor2_1
XFILLER_100_15 VPWR VGND VPWR VGND sky130_ef_sc_hd__decap_12
X_8693_ pe_array\[2\].u_pe.accum_reg\[27\] net563 net318 VGND VGND VPWR VPWR _4067_
+ sky130_fd_sc_hd__and3_1
X_4925_ _0668_ _0669_ _0606_ _0608_ VGND VGND VPWR VPWR _0671_ sky130_fd_sc_hd__o211a_1
XFILLER_60_19 VGND VGND VPWR VPWR sky130_fd_sc_hd__decap_8
X_4856_ _4229_ _0602_ _0600_ VGND VGND VPWR VPWR _0603_ sky130_fd_sc_hd__o21a_1
XFILLER_20_210 VPWR VGND VPWR VGND sky130_ef_sc_hd__decap_12
X_7644_ _3090_ _3091_ VGND VGND VPWR VPWR _3093_ sky130_fd_sc_hd__xnor2_1
XFILLER_20_243 VGND VGND VPWR VPWR sky130_fd_sc_hd__fill_1
X_7575_ net197 _2997_ _2996_ VGND VGND VPWR VPWR _3026_ sky130_fd_sc_hd__a21oi_1
X_9314_ clknet_leaf_7_clk _0426_ VGND VGND VPWR VPWR pe_accum\[2\]\[24\] sky130_fd_sc_hd__dfxtp_1
X_6526_ _2043_ _2044_ VGND VGND VPWR VPWR _2045_ sky130_fd_sc_hd__nand2_1
X_4787_ _0532_ _0533_ _0517_ VGND VGND VPWR VPWR _0536_ sky130_fd_sc_hd__a21oi_1
XFILLER_109_57 VPWR VGND VPWR VGND sky130_ef_sc_hd__decap_12
XFILLER_106_326 VPWR VGND VPWR VGND sky130_ef_sc_hd__decap_12
X_6457_ _1891_ _1918_ _1974_ _1944_ VGND VGND VPWR VPWR _1978_ sky130_fd_sc_hd__or4bb_4
X_9245_ clknet_leaf_40_clk _0357_ VGND VGND VPWR VPWR pe_accum\[1\]\[31\] sky130_fd_sc_hd__dfxtp_1
X_9176_ clknet_leaf_21_clk _0288_ VGND VGND VPWR VPWR pe_accum\[0\]\[30\] sky130_fd_sc_hd__dfxtp_1
XFILLER_106_359 VGND VGND VPWR VPWR sky130_fd_sc_hd__decap_4
X_6388_ _1911_ _1910_ VGND VGND VPWR VPWR _1912_ sky130_fd_sc_hd__and2b_1
X_5408_ _1103_ _1105_ _1136_ VGND VGND VPWR VPWR _1138_ sky130_fd_sc_hd__nor3_1
XFILLER_114_381 VGND VGND VPWR VPWR sky130_fd_sc_hd__decap_4
X_8127_ _3515_ _3516_ _3507_ VGND VGND VPWR VPWR _3518_ sky130_fd_sc_hd__a21o_1
X_5339_ _1069_ _1070_ VGND VGND VPWR VPWR _1071_ sky130_fd_sc_hd__and2_1
XTAP_TAPCELL_ROW_89_1317 VGND VPWR sky130_fd_sc_hd__tapvpwrvgnd_1
XFILLER_75_405 VPWR VGND VPWR VGND sky130_ef_sc_hd__decap_12
X_8058_ _3438_ _3440_ VGND VGND VPWR VPWR _3450_ sky130_fd_sc_hd__or2_1
XFILLER_75_449 VGND VGND VPWR VPWR sky130_fd_sc_hd__decap_8
XFILLER_75_438 VGND VGND VPWR VPWR sky130_fd_sc_hd__decap_3
XFILLER_28_321 VGND VGND VPWR VPWR sky130_fd_sc_hd__decap_4
Xclkbuf_leaf_67_clk clknet_3_1__leaf_clk VGND VGND VPWR VPWR clknet_leaf_67_clk sky130_fd_sc_hd__clkbuf_8
X_7009_ _2475_ _2443_ _2476_ VGND VGND VPWR VPWR _2477_ sky130_fd_sc_hd__and3_1
XFILLER_28_365 VGND VGND VPWR VPWR sky130_fd_sc_hd__decap_4
XTAP_TAPCELL_ROW_46_809 VGND VPWR sky130_fd_sc_hd__tapvpwrvgnd_1
XFILLER_71_666 VGND VGND VPWR VPWR sky130_fd_sc_hd__decap_6
XFILLER_70_121 VGND VGND VPWR VPWR sky130_fd_sc_hd__decap_3
XTAP_TAPCELL_ROW_54_897 VGND VPWR sky130_fd_sc_hd__tapvpwrvgnd_1
XTAP_TAPCELL_ROW_26_566 VGND VPWR sky130_fd_sc_hd__tapvpwrvgnd_1
XFILLER_11_221 VGND VGND VPWR VPWR sky130_fd_sc_hd__decap_3
XFILLER_34_75 VGND VGND VPWR VPWR sky130_fd_sc_hd__decap_4
XFILLER_11_265 VGND VGND VPWR VPWR sky130_fd_sc_hd__decap_6
XFILLER_50_41 VPWR VGND VPWR VGND sky130_ef_sc_hd__decap_12
XFILLER_50_85 VPWR VGND VPWR VGND sky130_ef_sc_hd__decap_12
XFILLER_3_497 VGND VGND VPWR VPWR sky130_fd_sc_hd__decap_6
XFILLER_78_221 VGND VGND VPWR VPWR sky130_fd_sc_hd__decap_3
XFILLER_39_608 VGND VGND VPWR VPWR sky130_fd_sc_hd__fill_1
XFILLER_38_107 VGND VGND VPWR VPWR sky130_fd_sc_hd__decap_4
Xclkbuf_leaf_58_clk clknet_3_0__leaf_clk VGND VGND VPWR VPWR clknet_leaf_58_clk sky130_fd_sc_hd__clkbuf_8
XTAP_TAPCELL_ROW_109_1564 VGND VPWR sky130_fd_sc_hd__tapvpwrvgnd_1
XFILLER_46_151 VGND VGND VPWR VPWR sky130_fd_sc_hd__decap_6
XFILLER_34_302 VGND VGND VPWR VPWR sky130_fd_sc_hd__decap_6
XFILLER_61_165 VGND VGND VPWR VPWR sky130_fd_sc_hd__decap_3
XFILLER_34_379 VGND VGND VPWR VPWR sky130_fd_sc_hd__decap_8
X_5690_ pe_array\[0\].u_pe.tap_count\[2\] _1236_ VGND VGND VPWR VPWR _1237_ sky130_fd_sc_hd__and2_1
XFILLER_30_530 VGND VGND VPWR VPWR sky130_fd_sc_hd__fill_2
X_4710_ _0460_ _4433_ VGND VGND VPWR VPWR _0461_ sky130_fd_sc_hd__and2b_1
X_4641_ _4399_ _4402_ VGND VGND VPWR VPWR _4403_ sky130_fd_sc_hd__xnor2_1
XFILLER_30_596 VGND VGND VPWR VPWR sky130_fd_sc_hd__decap_8
XFILLER_116_613 VPWR VGND VPWR VGND sky130_ef_sc_hd__decap_12
X_7360_ _2753_ _2756_ _2789_ VGND VGND VPWR VPWR _2819_ sky130_fd_sc_hd__a21oi_1
X_4572_ _4332_ _4333_ net303 net484 VGND VGND VPWR VPWR _4336_ sky130_fd_sc_hd__a2bb2o_1
XFILLER_116_657 VPWR VGND VPWR VGND sky130_ef_sc_hd__decap_12
X_6311_ _1777_ _1807_ VGND VGND VPWR VPWR _1838_ sky130_fd_sc_hd__nor2_1
XFILLER_6_280 VGND VGND VPWR VPWR sky130_fd_sc_hd__fill_1
X_7291_ _2749_ _2750_ _2751_ VGND VGND VPWR VPWR _2752_ sky130_fd_sc_hd__and3_1
X_6242_ _1768_ _1769_ net157 VGND VGND VPWR VPWR _1771_ sky130_fd_sc_hd__o21ai_1
XTAP_TAPCELL_ROW_73_1129 VGND VPWR sky130_fd_sc_hd__tapvpwrvgnd_1
X_9030_ clknet_leaf_45_clk _0142_ VGND VGND VPWR VPWR net101 sky130_fd_sc_hd__dfxtp_1
XFILLER_97_541 VGND VGND VPWR VPWR sky130_fd_sc_hd__decap_6
X_6173_ _1678_ _1702_ _1703_ VGND VGND VPWR VPWR _1704_ sky130_fd_sc_hd__nand3_1
XFILLER_97_585 VPWR VGND VPWR VGND sky130_ef_sc_hd__decap_12
X_5124_ net178 _0832_ _0831_ VGND VGND VPWR VPWR _0864_ sky130_fd_sc_hd__a21oi_1
XFILLER_57_449 VGND VGND VPWR VPWR sky130_fd_sc_hd__fill_2
XFILLER_57_438 VGND VGND VPWR VPWR sky130_fd_sc_hd__decap_3
X_5055_ _0794_ _0795_ _0796_ VGND VGND VPWR VPWR _0797_ sky130_fd_sc_hd__and3_1
XFILLER_72_419 VGND VGND VPWR VPWR sky130_fd_sc_hd__fill_1
XFILLER_55_19 VPWR VGND VPWR VGND sky130_ef_sc_hd__decap_12
X_8814_ _4160_ _4161_ net192 VGND VGND VPWR VPWR _4184_ sky130_fd_sc_hd__mux2_1
XFILLER_53_633 VGND VGND VPWR VPWR sky130_fd_sc_hd__fill_2
XFILLER_37_162 VGND VGND VPWR VPWR sky130_fd_sc_hd__decap_6
XTAP_TAPCELL_ROW_84_1258 VGND VPWR sky130_fd_sc_hd__tapvpwrvgnd_1
XFILLER_111_69 VPWR VGND VPWR VGND sky130_ef_sc_hd__decap_12
X_8745_ _4115_ _4116_ VGND VGND VPWR VPWR _4118_ sky130_fd_sc_hd__xnor2_1
X_5957_ _1490_ _1489_ _1491_ VGND VGND VPWR VPWR _1493_ sky130_fd_sc_hd__a21o_1
XFILLER_52_154 VGND VGND VPWR VPWR sky130_fd_sc_hd__decap_4
X_8676_ _4021_ _4023_ _4049_ VGND VGND VPWR VPWR _4051_ sky130_fd_sc_hd__nor3_1
XTAP_TAPCELL_ROW_23_525 VGND VPWR sky130_fd_sc_hd__tapvpwrvgnd_1
X_4908_ pe_array\[3\].u_pe.accum_reg\[13\] net295 net435 VGND VGND VPWR VPWR _0654_
+ sky130_fd_sc_hd__and3_4
X_5888_ net494 net488 net346 net344 VGND VGND VPWR VPWR _1425_ sky130_fd_sc_hd__and4_1
XTAP_TAPCELL_ROW_51_867 VGND VPWR sky130_fd_sc_hd__tapvpwrvgnd_1
X_7627_ pe_array\[1\].u_pe.accum_reg\[28\] net451 net342 VGND VGND VPWR VPWR _3076_
+ sky130_fd_sc_hd__and3_1
X_4839_ _0514_ _0516_ _0585_ _0586_ VGND VGND VPWR VPWR _0587_ sky130_fd_sc_hd__a211oi_4
XFILLER_107_613 VGND VGND VPWR VPWR sky130_fd_sc_hd__decap_3
X_7558_ _3009_ _3008_ VGND VGND VPWR VPWR _3010_ sky130_fd_sc_hd__and2b_1
X_6509_ net172 _2001_ _1999_ VGND VGND VPWR VPWR _2029_ sky130_fd_sc_hd__a21oi_1
XFILLER_107_635 VGND VGND VPWR VPWR sky130_fd_sc_hd__fill_1
XFILLER_106_101 VPWR VGND VPWR VGND sky130_ef_sc_hd__decap_12
X_7489_ _2940_ _2941_ VGND VGND VPWR VPWR _2943_ sky130_fd_sc_hd__xnor2_1
XFILLER_107_668 VGND VGND VPWR VPWR sky130_fd_sc_hd__decap_4
X_9228_ clknet_leaf_50_clk _0340_ VGND VGND VPWR VPWR pe_accum\[1\]\[14\] sky130_fd_sc_hd__dfxtp_1
XFILLER_20_77 VGND VGND VPWR VPWR sky130_fd_sc_hd__fill_1
XFILLER_106_178 VGND VGND VPWR VPWR sky130_fd_sc_hd__fill_2
XTAP_TAPCELL_ROW_95_1398 VGND VPWR sky130_fd_sc_hd__tapvpwrvgnd_1
X_9159_ clknet_leaf_30_clk _0271_ VGND VGND VPWR VPWR pe_accum\[0\]\[13\] sky130_fd_sc_hd__dfxtp_1
XFILLER_0_445 VGND VGND VPWR VPWR sky130_fd_sc_hd__decap_3
XFILLER_88_585 VGND VGND VPWR VPWR sky130_fd_sc_hd__decap_3
XFILLER_88_563 VGND VGND VPWR VPWR sky130_fd_sc_hd__fill_2
XFILLER_0_489 VPWR VGND VPWR VGND sky130_ef_sc_hd__decap_12
XFILLER_48_405 VGND VGND VPWR VPWR sky130_fd_sc_hd__decap_4
XFILLER_88_596 VGND VGND VPWR VPWR sky130_fd_sc_hd__fill_2
XFILLER_75_213 VGND VGND VPWR VPWR sky130_fd_sc_hd__decap_8
XTAP_TAPCELL_ROW_59_956 VGND VPWR sky130_fd_sc_hd__tapvpwrvgnd_1
XFILLER_29_630 VGND VGND VPWR VPWR sky130_fd_sc_hd__fill_2
XFILLER_90_205 VGND VGND VPWR VPWR sky130_fd_sc_hd__fill_2
XTAP_TAPCELL_ROW_59_967 VGND VPWR sky130_fd_sc_hd__tapvpwrvgnd_1
XFILLER_56_460 VGND VGND VPWR VPWR sky130_fd_sc_hd__decap_6
XTAP_TAPCELL_ROW_3_294 VGND VPWR sky130_fd_sc_hd__tapvpwrvgnd_1
XFILLER_16_302 VGND VGND VPWR VPWR sky130_fd_sc_hd__decap_6
XFILLER_16_357 VGND VGND VPWR VPWR sky130_fd_sc_hd__decap_6
XFILLER_28_195 VGND VGND VPWR VPWR sky130_fd_sc_hd__fill_1
XFILLER_43_176 VGND VGND VPWR VPWR sky130_fd_sc_hd__fill_1
XFILLER_8_501 VPWR VGND VPWR VGND sky130_ef_sc_hd__decap_12
XFILLER_8_545 VPWR VGND VPWR VGND sky130_ef_sc_hd__decap_12
XANTENNA_6 net369 VGND VGND VPWR VPWR sky130_fd_sc_hd__diode_2
XFILLER_112_159 VGND VGND VPWR VPWR sky130_fd_sc_hd__decap_3
XFILLER_79_552 VGND VGND VPWR VPWR sky130_fd_sc_hd__decap_8
XFILLER_3_294 VGND VGND VPWR VPWR sky130_fd_sc_hd__decap_8
XFILLER_94_511 VGND VGND VPWR VPWR sky130_fd_sc_hd__decap_4
XFILLER_79_574 VGND VGND VPWR VPWR sky130_fd_sc_hd__decap_8
XFILLER_94_533 VGND VGND VPWR VPWR sky130_fd_sc_hd__fill_2
XFILLER_39_449 VGND VGND VPWR VPWR sky130_fd_sc_hd__decap_4
XFILLER_94_566 VGND VGND VPWR VPWR sky130_fd_sc_hd__fill_2
XFILLER_54_419 VGND VGND VPWR VPWR sky130_fd_sc_hd__fill_1
Xrebuffer18 net532 VGND VGND VPWR VPWR net533 sky130_fd_sc_hd__dlymetal6s2s_1
Xrebuffer29 _2512_ VGND VGND VPWR VPWR net544 sky130_fd_sc_hd__clkbuf_2
X_6860_ net464 net343 pe_array\[1\].u_pe.accum_reg\[6\] VGND VGND VPWR VPWR _2331_
+ sky130_fd_sc_hd__a21oi_1
XFILLER_34_132 VGND VGND VPWR VPWR sky130_fd_sc_hd__fill_2
X_5811_ _1344_ _1348_ VGND VGND VPWR VPWR _1350_ sky130_fd_sc_hd__xnor2_1
XFILLER_62_452 VGND VGND VPWR VPWR sky130_fd_sc_hd__decap_6
X_6791_ pe_array\[1\].u_pe.accum_reg\[4\] net481 net343 VGND VGND VPWR VPWR _2264_
+ sky130_fd_sc_hd__and3_1
XFILLER_50_625 VGND VGND VPWR VPWR sky130_fd_sc_hd__decap_3
XFILLER_22_305 VGND VGND VPWR VPWR sky130_fd_sc_hd__decap_3
XFILLER_35_677 VGND VGND VPWR VPWR sky130_fd_sc_hd__fill_1
X_8530_ _3908_ _3909_ VGND VGND VPWR VPWR _3910_ sky130_fd_sc_hd__nor2_1
X_5742_ _1283_ VGND VGND VPWR VPWR _1284_ sky130_fd_sc_hd__inv_2
XFILLER_50_669 VGND VGND VPWR VPWR sky130_fd_sc_hd__decap_3
X_8461_ _3840_ _3841_ _3842_ VGND VGND VPWR VPWR _3843_ sky130_fd_sc_hd__and3_1
X_5673_ _4236_ _4239_ VGND VGND VPWR VPWR _1230_ sky130_fd_sc_hd__nor2_2
X_8392_ _3732_ _3734_ _3773_ _3774_ VGND VGND VPWR VPWR _3776_ sky130_fd_sc_hd__o211ai_1
X_7412_ _2868_ _2867_ VGND VGND VPWR VPWR _2869_ sky130_fd_sc_hd__and2b_1
XPHY_EDGE_ROW_6_Right_6 VGND VGND VPWR VPWR sky130_fd_sc_hd__decap_3
X_4624_ _4350_ _4351_ VGND VGND VPWR VPWR _4387_ sky130_fd_sc_hd__nor2_1
Xhold501 pe_accum\[1\]\[6\] VGND VGND VPWR VPWR net1016 sky130_fd_sc_hd__dlygate4sd3_1
X_7343_ _2799_ _2800_ net196 VGND VGND VPWR VPWR _2802_ sky130_fd_sc_hd__a21o_1
X_4555_ _4273_ _4295_ net582 VGND VGND VPWR VPWR _4320_ sky130_fd_sc_hd__a21oi_2
Xhold512 pe_array\[2\].u_pe.tap_count\[1\] VGND VGND VPWR VPWR net1027 sky130_fd_sc_hd__dlygate4sd3_1
X_7274_ _2731_ _2732_ net266 VGND VGND VPWR VPWR _2735_ sky130_fd_sc_hd__o21ai_1
X_4486_ net427 _4254_ VGND VGND VPWR VPWR _0012_ sky130_fd_sc_hd__nor2_1
X_9013_ clknet_leaf_40_clk _0125_ VGND VGND VPWR VPWR net82 sky130_fd_sc_hd__dfxtp_1
X_6225_ net656 _1752_ _1753_ VGND VGND VPWR VPWR _1754_ sky130_fd_sc_hd__nor3_1
X_6156_ pe_array\[0\].u_pe.accum_reg\[14\] net458 net361 VGND VGND VPWR VPWR _1687_
+ sky130_fd_sc_hd__and3_1
XFILLER_112_693 VGND VGND VPWR VPWR sky130_fd_sc_hd__decap_6
XFILLER_66_29 VGND VGND VPWR VPWR sky130_fd_sc_hd__decap_6
X_5107_ net282 _0845_ _0846_ VGND VGND VPWR VPWR _0847_ sky130_fd_sc_hd__nor3_1
X_6087_ net201 _1576_ _1574_ VGND VGND VPWR VPWR _1620_ sky130_fd_sc_hd__a21o_1
XTAP_TAPCELL_ROW_56_926 VGND VPWR sky130_fd_sc_hd__tapvpwrvgnd_1
XFILLER_26_600 VGND VGND VPWR VPWR sky130_fd_sc_hd__fill_1
X_5038_ _0635_ _0676_ _0777_ _0779_ VGND VGND VPWR VPWR _0781_ sky130_fd_sc_hd__o31a_1
XTAP_TAPCELL_ROW_0_242 VGND VPWR sky130_fd_sc_hd__tapvpwrvgnd_1
XTAP_TAPCELL_ROW_0_253 VGND VPWR sky130_fd_sc_hd__tapvpwrvgnd_1
XFILLER_26_655 VGND VGND VPWR VPWR sky130_fd_sc_hd__decap_3
XFILLER_26_666 VGND VGND VPWR VPWR sky130_fd_sc_hd__decap_6
X_8728_ _4067_ _4069_ VGND VGND VPWR VPWR _4101_ sky130_fd_sc_hd__or2_1
XTAP_TAPCELL_ROW_36_683 VGND VPWR sky130_fd_sc_hd__tapvpwrvgnd_1
X_6989_ net465 _2455_ _2456_ VGND VGND VPWR VPWR _2457_ sky130_fd_sc_hd__a21bo_1
X_8659_ _4005_ _4008_ _4033_ VGND VGND VPWR VPWR _4035_ sky130_fd_sc_hd__nand3_2
XFILLER_21_382 VGND VGND VPWR VPWR sky130_fd_sc_hd__decap_8
XFILLER_40_179 VGND VGND VPWR VPWR sky130_fd_sc_hd__decap_3
XTAP_TAPCELL_ROW_97_1416 VGND VPWR sky130_fd_sc_hd__tapvpwrvgnd_1
XFILLER_21_393 VPWR VGND VPWR VGND sky130_ef_sc_hd__decap_12
XFILLER_110_3 VPWR VGND VPWR VGND sky130_ef_sc_hd__decap_12
XFILLER_5_526 VGND VGND VPWR VPWR sky130_fd_sc_hd__decap_4
XFILLER_107_498 VGND VGND VPWR VPWR sky130_fd_sc_hd__decap_6
Xoutput43 net43 VGND VGND VPWR VPWR result_data[119] sky130_fd_sc_hd__buf_2
Xoutput32 net32 VGND VGND VPWR VPWR result_data[109] sky130_fd_sc_hd__buf_2
Xoutput65 net65 VGND VGND VPWR VPWR result_data[23] sky130_fd_sc_hd__buf_2
Xoutput54 net54 VGND VGND VPWR VPWR result_data[13] sky130_fd_sc_hd__buf_2
Xoutput76 net76 VGND VGND VPWR VPWR result_data[33] sky130_fd_sc_hd__buf_2
XTAP_TAPCELL_ROW_8_353 VGND VPWR sky130_fd_sc_hd__tapvpwrvgnd_1
XFILLER_95_308 VGND VGND VPWR VPWR sky130_fd_sc_hd__decap_3
XFILLER_0_231 VGND VGND VPWR VPWR sky130_fd_sc_hd__decap_3
Xoutput98 net98 VGND VGND VPWR VPWR result_data[53] sky130_fd_sc_hd__buf_2
Xoutput87 net87 VGND VGND VPWR VPWR result_data[43] sky130_fd_sc_hd__buf_2
XFILLER_76_533 VPWR VGND VPWR VGND sky130_ef_sc_hd__decap_12
XTAP_TAPCELL_ROW_106_1523 VGND VPWR sky130_fd_sc_hd__tapvpwrvgnd_1
XFILLER_91_558 VGND VGND VPWR VPWR sky130_fd_sc_hd__fill_2
XFILLER_17_655 VGND VGND VPWR VPWR sky130_fd_sc_hd__fill_1
XFILLER_44_441 VGND VGND VPWR VPWR sky130_fd_sc_hd__fill_1
XFILLER_16_165 VGND VGND VPWR VPWR sky130_fd_sc_hd__decap_6
XFILLER_44_463 VGND VGND VPWR VPWR sky130_fd_sc_hd__decap_8
XFILLER_44_474 VGND VGND VPWR VPWR sky130_fd_sc_hd__fill_2
XFILLER_16_176 VGND VGND VPWR VPWR sky130_fd_sc_hd__decap_8
XFILLER_31_113 VPWR VGND VPWR VGND sky130_ef_sc_hd__decap_12
XFILLER_32_625 VGND VGND VPWR VPWR sky130_fd_sc_hd__decap_8
XFILLER_72_83 VGND VGND VPWR VPWR sky130_fd_sc_hd__fill_1
XPHY_EDGE_ROW_59_Right_59 VGND VGND VPWR VPWR sky130_fd_sc_hd__decap_3
XTAP_TAPCELL_ROW_117_1674 VGND VPWR sky130_fd_sc_hd__tapvpwrvgnd_1
XTAP_TAPCELL_ROW_117_1663 VGND VPWR sky130_fd_sc_hd__tapvpwrvgnd_1
XTAP_TAPCELL_ROW_117_1652 VGND VPWR sky130_fd_sc_hd__tapvpwrvgnd_1
XFILLER_113_446 VGND VGND VPWR VPWR sky130_fd_sc_hd__fill_2
XFILLER_113_424 VGND VGND VPWR VPWR sky130_fd_sc_hd__decap_6
XFILLER_4_581 VGND VGND VPWR VPWR sky130_fd_sc_hd__decap_6
X_6010_ _1543_ _1544_ VGND VGND VPWR VPWR _1545_ sky130_fd_sc_hd__or2_1
XFILLER_79_371 VGND VGND VPWR VPWR sky130_fd_sc_hd__decap_4
XPHY_EDGE_ROW_68_Right_68 VGND VGND VPWR VPWR sky130_fd_sc_hd__decap_3
XFILLER_94_363 VGND VGND VPWR VPWR sky130_fd_sc_hd__fill_1
X_7961_ _3355_ _3308_ VGND VGND VPWR VPWR _3356_ sky130_fd_sc_hd__xnor2_4
X_7892_ net422 _3288_ VGND VGND VPWR VPWR _0374_ sky130_fd_sc_hd__nor2_1
XFILLER_82_547 VGND VGND VPWR VPWR sky130_fd_sc_hd__decap_3
X_6912_ _2380_ _2381_ VGND VGND VPWR VPWR _2382_ sky130_fd_sc_hd__nand2_1
X_6843_ _2313_ _2314_ VGND VGND VPWR VPWR _2315_ sky130_fd_sc_hd__or2_1
XFILLER_23_614 VGND VGND VPWR VPWR sky130_fd_sc_hd__fill_2
XTAP_TAPCELL_ROW_81_1228 VGND VPWR sky130_fd_sc_hd__tapvpwrvgnd_1
XFILLER_50_433 VPWR VGND VPWR VGND sky130_ef_sc_hd__decap_12
XFILLER_23_625 VGND VGND VPWR VPWR sky130_fd_sc_hd__fill_1
XPHY_EDGE_ROW_77_Right_77 VGND VGND VPWR VPWR sky130_fd_sc_hd__decap_3
X_6774_ _2246_ _2247_ VGND VGND VPWR VPWR _2248_ sky130_fd_sc_hd__nor2_1
XTAP_TAPCELL_ROW_33_653 VGND VPWR sky130_fd_sc_hd__tapvpwrvgnd_1
X_8513_ _3889_ _3890_ net573 VGND VGND VPWR VPWR _3893_ sky130_fd_sc_hd__o21ai_1
X_5725_ net428 _1267_ VGND VGND VPWR VPWR _0228_ sky130_fd_sc_hd__nor2_1
XTAP_TAPCELL_ROW_61_984 VGND VPWR sky130_fd_sc_hd__tapvpwrvgnd_1
XFILLER_50_499 VGND VGND VPWR VPWR sky130_fd_sc_hd__fill_1
XFILLER_50_477 VGND VGND VPWR VPWR sky130_fd_sc_hd__fill_2
X_8444_ net419 _3826_ VGND VGND VPWR VPWR _0388_ sky130_fd_sc_hd__nor2_1
X_5656_ net954 net370 VGND VGND VPWR VPWR _0197_ sky130_fd_sc_hd__and2_1
X_4607_ _4368_ _4367_ net302 net477 VGND VGND VPWR VPWR _4370_ sky130_fd_sc_hd__or4bb_4
X_8375_ _3693_ _3694_ _3726_ _3727_ VGND VGND VPWR VPWR _3760_ sky130_fd_sc_hd__and4_1
X_5587_ net1003 net376 VGND VGND VPWR VPWR _0128_ sky130_fd_sc_hd__and2_1
XFILLER_104_413 VGND VGND VPWR VPWR sky130_fd_sc_hd__decap_6
X_7326_ net156 _2785_ VGND VGND VPWR VPWR _2786_ sky130_fd_sc_hd__xnor2_1
X_4538_ net500 net300 pe_array\[3\].u_pe.accum_reg\[4\] VGND VGND VPWR VPWR _4303_
+ sky130_fd_sc_hd__a21oi_1
XFILLER_117_57 VPWR VGND VPWR VGND sky130_ef_sc_hd__decap_12
Xhold386 pe_accum\[0\]\[5\] VGND VGND VPWR VPWR net901 sky130_fd_sc_hd__dlygate4sd3_1
XTAP_TAPCELL_ROW_92_1357 VGND VPWR sky130_fd_sc_hd__tapvpwrvgnd_1
XFILLER_77_28 VGND VGND VPWR VPWR sky130_fd_sc_hd__decap_4
X_7257_ _2716_ _2715_ _2717_ VGND VGND VPWR VPWR _2719_ sky130_fd_sc_hd__a21o_1
X_4469_ pe_array\[3\].u_pe.tap_count\[2\] pe_array\[3\].u_pe.tap_count\[1\] pe_array\[3\].u_pe.tap_count\[0\]
+ pe_array\[3\].u_pe.tap_count\[3\] VGND VGND VPWR VPWR _4242_ sky130_fd_sc_hd__or4b_1
Xhold397 pe_accum\[0\]\[27\] VGND VGND VPWR VPWR net912 sky130_fd_sc_hd__dlygate4sd3_1
XPHY_EDGE_ROW_86_Right_86 VGND VGND VPWR VPWR sky130_fd_sc_hd__decap_3
X_6208_ _1718_ _1737_ VGND VGND VPWR VPWR _1738_ sky130_fd_sc_hd__xor2_2
XFILLER_77_308 VGND VGND VPWR VPWR sky130_fd_sc_hd__fill_2
XTAP_TAPCELL_ROW_5_312 VGND VPWR sky130_fd_sc_hd__tapvpwrvgnd_1
XFILLER_58_533 VGND VGND VPWR VPWR sky130_fd_sc_hd__decap_8
X_7188_ _2650_ _2651_ _2607_ VGND VGND VPWR VPWR _2652_ sky130_fd_sc_hd__a21oi_1
XFILLER_100_641 VGND VGND VPWR VPWR sky130_fd_sc_hd__decap_3
X_6139_ _1668_ _1669_ _1631_ VGND VGND VPWR VPWR _1671_ sky130_fd_sc_hd__a21oi_1
XFILLER_100_674 VGND VGND VPWR VPWR sky130_fd_sc_hd__fill_2
XFILLER_73_503 VGND VGND VPWR VPWR sky130_fd_sc_hd__fill_1
XFILLER_18_419 VGND VGND VPWR VPWR sky130_fd_sc_hd__fill_1
XPHY_EDGE_ROW_95_Right_95 VGND VGND VPWR VPWR sky130_fd_sc_hd__decap_3
XFILLER_13_113 VGND VGND VPWR VPWR sky130_fd_sc_hd__fill_1
XFILLER_14_625 VGND VGND VPWR VPWR sky130_fd_sc_hd__decap_3
XTAP_TAPCELL_ROW_101_1464 VGND VPWR sky130_fd_sc_hd__tapvpwrvgnd_1
XFILLER_42_53 VPWR VGND VPWR VGND sky130_ef_sc_hd__decap_12
Xrebuffer9 net449 VGND VGND VPWR VPWR net524 sky130_fd_sc_hd__dlygate4sd1_1
XFILLER_5_345 VGND VGND VPWR VPWR sky130_fd_sc_hd__decap_6
XFILLER_107_251 VPWR VGND VPWR VGND sky130_ef_sc_hd__decap_12
XFILLER_5_389 VGND VGND VPWR VPWR sky130_fd_sc_hd__decap_3
XFILLER_68_319 VPWR VGND VPWR VGND sky130_ef_sc_hd__decap_12
XTAP_TAPCELL_ROW_112_1593 VGND VPWR sky130_fd_sc_hd__tapvpwrvgnd_1
XFILLER_95_127 VGND VGND VPWR VPWR sky130_fd_sc_hd__decap_4
XFILLER_89_691 VGND VGND VPWR VPWR sky130_fd_sc_hd__fill_1
XFILLER_1_573 VPWR VGND VPWR VGND sky130_ef_sc_hd__decap_12
XFILLER_3_69 VPWR VGND VPWR VGND sky130_ef_sc_hd__decap_12
XFILLER_67_72 VGND VGND VPWR VPWR sky130_fd_sc_hd__fill_2
XFILLER_64_525 VGND VGND VPWR VPWR sky130_fd_sc_hd__decap_6
XFILLER_49_599 VGND VGND VPWR VPWR sky130_fd_sc_hd__decap_3
XTAP_TAPCELL_ROW_67_1061 VGND VPWR sky130_fd_sc_hd__tapvpwrvgnd_1
XFILLER_51_208 VPWR VGND VPWR VGND sky130_ef_sc_hd__decap_12
XFILLER_17_441 VGND VGND VPWR VPWR sky130_fd_sc_hd__decap_6
XFILLER_32_433 VGND VGND VPWR VPWR sky130_fd_sc_hd__decap_3
XFILLER_44_282 VGND VGND VPWR VPWR sky130_fd_sc_hd__decap_8
XTAP_TAPCELL_ROW_30_612 VGND VPWR sky130_fd_sc_hd__tapvpwrvgnd_1
XFILLER_32_499 VGND VGND VPWR VPWR sky130_fd_sc_hd__fill_1
X_5510_ net980 net246 _1215_ net363 VGND VGND VPWR VPWR _0065_ sky130_fd_sc_hd__o211a_1
X_6490_ net411 pe_array\[0\].u_pe.accum_reg\[24\] net238 _2010_ VGND VGND VPWR VPWR
+ _2011_ sky130_fd_sc_hd__o2bb2a_1
XFILLER_9_673 VPWR VGND VPWR VGND sky130_ef_sc_hd__decap_12
X_5441_ net182 _1169_ VGND VGND VPWR VPWR _1170_ sky130_fd_sc_hd__xor2_1
XTAP_TAPCELL_ROW_78_1190 VGND VPWR sky130_fd_sc_hd__tapvpwrvgnd_1
X_8160_ net443 net312 VGND VGND VPWR VPWR _3550_ sky130_fd_sc_hd__and2_1
X_5372_ _1101_ _1102_ VGND VGND VPWR VPWR _1103_ sky130_fd_sc_hd__and2_1
XFILLER_113_221 VGND VGND VPWR VPWR sky130_fd_sc_hd__decap_3
X_8091_ _3480_ _3481_ _3412_ _3415_ VGND VGND VPWR VPWR _3483_ sky130_fd_sc_hd__o211a_1
X_7111_ net330 _2498_ _2455_ VGND VGND VPWR VPWR _2576_ sky130_fd_sc_hd__a21o_1
XFILLER_99_466 VGND VGND VPWR VPWR sky130_fd_sc_hd__fill_1
XFILLER_99_455 VGND VGND VPWR VPWR sky130_fd_sc_hd__fill_1
XFILLER_87_617 VPWR VGND VPWR VGND sky130_ef_sc_hd__decap_12
X_7042_ _2507_ _2506_ _2460_ _2462_ VGND VGND VPWR VPWR _2509_ sky130_fd_sc_hd__a211o_1
XFILLER_95_661 VGND VGND VPWR VPWR sky130_fd_sc_hd__decap_8
X_8993_ clknet_leaf_25_clk _0105_ VGND VGND VPWR VPWR net60 sky130_fd_sc_hd__dfxtp_1
XFILLER_103_15 VPWR VGND VPWR VGND sky130_ef_sc_hd__decap_12
XTAP_TAPCELL_ROW_38_712 VGND VPWR sky130_fd_sc_hd__tapvpwrvgnd_1
XFILLER_82_344 VGND VGND VPWR VPWR sky130_fd_sc_hd__decap_8
X_7944_ _3331_ _3332_ _3338_ VGND VGND VPWR VPWR _3339_ sky130_fd_sc_hd__nand3_1
X_7875_ _3270_ _3271_ VGND VGND VPWR VPWR _3272_ sky130_fd_sc_hd__nand2_1
X_6826_ _2296_ _2295_ _2264_ _2265_ VGND VGND VPWR VPWR _2298_ sky130_fd_sc_hd__a211o_1
XFILLER_23_444 VGND VGND VPWR VPWR sky130_fd_sc_hd__decap_4
XFILLER_35_293 VGND VGND VPWR VPWR sky130_fd_sc_hd__decap_6
X_6757_ net511 net335 _2230_ VGND VGND VPWR VPWR _2232_ sky130_fd_sc_hd__a21o_1
XFILLER_11_617 VPWR VGND VPWR VGND sky130_ef_sc_hd__decap_12
XFILLER_23_477 VPWR VGND VPWR VGND sky130_ef_sc_hd__decap_12
XFILLER_50_285 VGND VGND VPWR VPWR sky130_fd_sc_hd__fill_1
XFILLER_109_505 VGND VGND VPWR VPWR sky130_fd_sc_hd__fill_2
X_5708_ _1233_ _1250_ _1251_ net1026 net409 VGND VGND VPWR VPWR _1252_ sky130_fd_sc_hd__a32oi_1
X_6688_ net945 net233 _1243_ _0085_ VGND VGND VPWR VPWR _0258_ sky130_fd_sc_hd__a22o_1
X_5639_ net998 net387 VGND VGND VPWR VPWR _0180_ sky130_fd_sc_hd__and2_1
X_8427_ _3806_ _3807_ _3808_ VGND VGND VPWR VPWR _3810_ sky130_fd_sc_hd__a21oi_1
XFILLER_88_27 VGND VGND VPWR VPWR sky130_fd_sc_hd__fill_1
X_8358_ _3740_ _3741_ _3742_ VGND VGND VPWR VPWR _3743_ sky130_fd_sc_hd__and3_1
X_7309_ net267 _2767_ _2768_ VGND VGND VPWR VPWR _2769_ sky130_fd_sc_hd__nor3_1
X_8289_ _3635_ _3636_ _3674_ _3675_ VGND VGND VPWR VPWR _3676_ sky130_fd_sc_hd__o211a_1
XFILLER_77_105 VGND VGND VPWR VPWR sky130_fd_sc_hd__decap_3
XFILLER_100_471 VGND VGND VPWR VPWR sky130_fd_sc_hd__decap_4
XFILLER_46_525 VGND VGND VPWR VPWR sky130_fd_sc_hd__fill_1
XFILLER_73_399 VGND VGND VPWR VPWR sky130_fd_sc_hd__decap_6
XFILLER_14_433 VPWR VGND VPWR VGND sky130_ef_sc_hd__decap_12
XFILLER_41_230 VGND VGND VPWR VPWR sky130_fd_sc_hd__decap_6
XFILLER_41_274 VGND VGND VPWR VPWR sky130_fd_sc_hd__decap_6
XFILLER_10_661 VGND VGND VPWR VPWR sky130_fd_sc_hd__fill_1
XTAP_TAPCELL_ROW_114_1622 VGND VPWR sky130_fd_sc_hd__tapvpwrvgnd_1
XFILLER_5_164 VGND VGND VPWR VPWR sky130_fd_sc_hd__decap_4
XFILLER_69_617 VPWR VGND VPWR VGND sky130_ef_sc_hd__decap_12
XFILLER_78_93 VPWR VGND VPWR VGND sky130_ef_sc_hd__decap_12
XFILLER_96_458 VGND VGND VPWR VPWR sky130_fd_sc_hd__fill_2
XFILLER_68_138 VGND VGND VPWR VPWR sky130_fd_sc_hd__fill_2
XFILLER_94_70 VGND VGND VPWR VPWR sky130_fd_sc_hd__decap_3
XFILLER_64_333 VPWR VGND VPWR VGND sky130_ef_sc_hd__decap_12
XFILLER_37_536 VPWR VGND VPWR VGND sky130_ef_sc_hd__decap_12
XFILLER_91_163 VGND VGND VPWR VPWR sky130_fd_sc_hd__fill_1
X_5990_ _1522_ _1523_ VGND VGND VPWR VPWR _1525_ sky130_fd_sc_hd__xnor2_1
XFILLER_37_569 VGND VGND VPWR VPWR sky130_fd_sc_hd__decap_3
XFILLER_17_271 VGND VGND VPWR VPWR sky130_fd_sc_hd__fill_1
X_4941_ _0685_ _0602_ VGND VGND VPWR VPWR _0686_ sky130_fd_sc_hd__xnor2_4
X_4872_ _0616_ _0617_ net207 VGND VGND VPWR VPWR _0619_ sky130_fd_sc_hd__a21o_1
X_7660_ net272 _3106_ _3107_ VGND VGND VPWR VPWR _3108_ sky130_fd_sc_hd__nor3_1
X_6611_ net410 pe_array\[0\].u_pe.accum_reg\[28\] net239 _2127_ VGND VGND VPWR VPWR
+ _2128_ sky130_fd_sc_hd__o2bb2a_1
XFILLER_60_572 VPWR VGND VPWR VGND sky130_ef_sc_hd__decap_12
XTAP_TAPCELL_ROW_43_770 VGND VPWR sky130_fd_sc_hd__tapvpwrvgnd_1
XFILLER_20_436 VPWR VGND VPWR VGND sky130_ef_sc_hd__decap_12
X_7591_ net406 pe_array\[1\].u_pe.accum_reg\[26\] net232 _3041_ VGND VGND VPWR VPWR
+ _3042_ sky130_fd_sc_hd__o2bb2a_4
X_6542_ _2036_ _2037_ _2033_ VGND VGND VPWR VPWR _2061_ sky130_fd_sc_hd__o21bai_1
X_6473_ net198 _1993_ VGND VGND VPWR VPWR _1994_ sky130_fd_sc_hd__xnor2_1
X_9261_ clknet_leaf_15_clk _0373_ VGND VGND VPWR VPWR pe_array\[2\].u_pe.accum_reg\[3\]
+ sky130_fd_sc_hd__dfxtp_1
XFILLER_9_481 VGND VGND VPWR VPWR sky130_fd_sc_hd__decap_3
X_8212_ _3598_ _3599_ net189 VGND VGND VPWR VPWR _3601_ sky130_fd_sc_hd__a21o_1
X_5424_ _1123_ _1120_ VGND VGND VPWR VPWR _1154_ sky130_fd_sc_hd__nor2_4
X_9192_ clknet_leaf_38_clk _0304_ VGND VGND VPWR VPWR pe_array\[1\].u_pe.accum_reg\[10\]
+ sky130_fd_sc_hd__dfxtp_1
X_8143_ _3490_ _3533_ _3532_ VGND VGND VPWR VPWR _3534_ sky130_fd_sc_hd__o21a_1
XFILLER_114_552 VPWR VGND VPWR VGND sky130_ef_sc_hd__decap_12
X_5355_ _1057_ _1085_ VGND VGND VPWR VPWR _1087_ sky130_fd_sc_hd__xnor2_1
X_8074_ net462 net317 pe_array\[2\].u_pe.accum_reg\[9\] VGND VGND VPWR VPWR _3466_
+ sky130_fd_sc_hd__a21oi_1
X_5286_ net689 _1019_ VGND VGND VPWR VPWR _1020_ sky130_fd_sc_hd__xnor2_1
XFILLER_87_458 VGND VGND VPWR VPWR sky130_fd_sc_hd__decap_8
X_7025_ net487 _4234_ VGND VGND VPWR VPWR _2492_ sky130_fd_sc_hd__nor2_1
XFILLER_67_160 VGND VGND VPWR VPWR sky130_fd_sc_hd__decap_8
XFILLER_74_29 VGND VGND VPWR VPWR sky130_fd_sc_hd__decap_8
X_8976_ clknet_leaf_21_clk _0088_ VGND VGND VPWR VPWR net72 sky130_fd_sc_hd__dfxtp_1
XFILLER_82_141 VGND VGND VPWR VPWR sky130_fd_sc_hd__fill_2
XFILLER_55_344 VGND VGND VPWR VPWR sky130_fd_sc_hd__decap_4
X_7927_ net403 pe_array\[2\].u_pe.accum_reg\[5\] net219 _3322_ VGND VGND VPWR VPWR
+ _3323_ sky130_fd_sc_hd__o2bb2a_1
XFILLER_83_697 VGND VGND VPWR VPWR sky130_fd_sc_hd__decap_3
XFILLER_36_580 VGND VGND VPWR VPWR sky130_fd_sc_hd__fill_1
X_7858_ _3252_ _3255_ VGND VGND VPWR VPWR _3256_ sky130_fd_sc_hd__xnor2_1
X_6809_ _2280_ _2281_ VGND VGND VPWR VPWR _2282_ sky130_fd_sc_hd__or2_1
XTAP_TAPCELL_ROW_13_409 VGND VPWR sky130_fd_sc_hd__tapvpwrvgnd_1
XFILLER_23_274 VGND VGND VPWR VPWR sky130_fd_sc_hd__decap_6
X_7789_ net226 _3158_ VGND VGND VPWR VPWR _3204_ sky130_fd_sc_hd__nand2_1
XFILLER_11_447 VGND VGND VPWR VPWR sky130_fd_sc_hd__fill_1
XFILLER_23_55 VGND VGND VPWR VPWR sky130_fd_sc_hd__fill_1
XFILLER_7_429 VPWR VGND VPWR VGND sky130_ef_sc_hd__decap_12
XFILLER_109_335 VGND VGND VPWR VPWR sky130_fd_sc_hd__fill_1
XFILLER_99_15 VGND VGND VPWR VPWR sky130_fd_sc_hd__decap_4
XFILLER_2_101 VGND VGND VPWR VPWR sky130_fd_sc_hd__decap_6
XFILLER_105_541 VGND VGND VPWR VPWR sky130_fd_sc_hd__decap_6
XFILLER_3_3 VPWR VGND VPWR VGND sky130_ef_sc_hd__decap_12
XFILLER_48_41 VPWR VGND VPWR VGND sky130_ef_sc_hd__decap_12
Xfanout482 net5 VGND VGND VPWR VPWR net482 sky130_fd_sc_hd__buf_2
Xfanout493 net499 VGND VGND VPWR VPWR net493 sky130_fd_sc_hd__buf_2
Xfanout471 net6 VGND VGND VPWR VPWR net471 sky130_fd_sc_hd__buf_2
Xfanout460 net468 VGND VGND VPWR VPWR net460 sky130_fd_sc_hd__buf_2
XFILLER_19_503 VGND VGND VPWR VPWR sky130_fd_sc_hd__fill_1
Xclone228 _0567_ VGND VGND VPWR VPWR net743 sky130_fd_sc_hd__clkbuf_1
XFILLER_48_85 VGND VGND VPWR VPWR sky130_fd_sc_hd__decap_8
XFILLER_86_491 VPWR VGND VPWR VGND sky130_ef_sc_hd__decap_12
XFILLER_0_15 VPWR VGND VPWR VGND sky130_ef_sc_hd__decap_12
XFILLER_100_290 VGND VGND VPWR VPWR sky130_fd_sc_hd__decap_6
XFILLER_73_185 VGND VGND VPWR VPWR sky130_fd_sc_hd__decap_4
XTAP_TAPCELL_ROW_29_597 VGND VPWR sky130_fd_sc_hd__tapvpwrvgnd_1
XTAP_TAPCELL_ROW_64_1020 VGND VPWR sky130_fd_sc_hd__tapvpwrvgnd_1
XFILLER_42_550 VGND VGND VPWR VPWR sky130_fd_sc_hd__decap_4
XFILLER_9_57 VGND VGND VPWR VPWR sky130_fd_sc_hd__decap_4
XFILLER_6_473 VGND VGND VPWR VPWR sky130_fd_sc_hd__decap_3
XFILLER_69_414 VPWR VGND VPWR VGND sky130_ef_sc_hd__decap_12
X_5140_ _0877_ _0878_ VGND VGND VPWR VPWR _0879_ sky130_fd_sc_hd__and2b_1
X_5071_ _0811_ _0812_ VGND VGND VPWR VPWR _0813_ sky130_fd_sc_hd__xor2_2
X_8830_ net214 _3263_ VGND VGND VPWR VPWR _4196_ sky130_fd_sc_hd__nand2_1
XFILLER_65_653 VPWR VGND VPWR VGND sky130_ef_sc_hd__decap_12
XFILLER_92_494 VGND VGND VPWR VPWR sky130_fd_sc_hd__fill_2
X_8761_ _4130_ _4131_ VGND VGND VPWR VPWR _4133_ sky130_fd_sc_hd__xor2_1
X_5973_ net413 pe_array\[0\].u_pe.accum_reg\[9\] net238 _1508_ VGND VGND VPWR VPWR
+ _1509_ sky130_fd_sc_hd__o2bb2a_1
XFILLER_80_645 VPWR VGND VPWR VGND sky130_ef_sc_hd__decap_12
X_7712_ net408 pe_array\[1\].u_pe.accum_reg\[30\] net232 _3158_ VGND VGND VPWR VPWR
+ _3159_ sky130_fd_sc_hd__o2bb2a_4
X_4924_ _0606_ _0608_ _0669_ _0668_ VGND VGND VPWR VPWR _0670_ sky130_fd_sc_hd__a211oi_4
XFILLER_100_27 VGND VGND VPWR VPWR sky130_fd_sc_hd__fill_1
X_8692_ net442 pe_array\[2\].u_pe.weight_in\[2\] _4040_ _4038_ VGND VGND VPWR VPWR
+ _4066_ sky130_fd_sc_hd__a31o_1
XFILLER_33_561 VPWR VGND VPWR VGND sky130_ef_sc_hd__decap_12
X_4855_ net291 net289 net435 VGND VGND VPWR VPWR _0602_ sky130_fd_sc_hd__nand3_4
XFILLER_20_222 VGND VGND VPWR VPWR sky130_fd_sc_hd__decap_3
X_7643_ _3091_ _3090_ VGND VGND VPWR VPWR _3092_ sky130_fd_sc_hd__and2b_1
XFILLER_20_266 VPWR VGND VPWR VGND sky130_ef_sc_hd__decap_12
X_7574_ net197 _3024_ VGND VGND VPWR VPWR _3025_ sky130_fd_sc_hd__xnor2_1
X_4786_ _0517_ _0532_ net594 VGND VGND VPWR VPWR _0535_ sky130_fd_sc_hd__nand3_1
X_6525_ _2012_ _2014_ VGND VGND VPWR VPWR _2044_ sky130_fd_sc_hd__nand2b_1
X_9313_ clknet_leaf_5_clk _0425_ VGND VGND VPWR VPWR pe_accum\[2\]\[23\] sky130_fd_sc_hd__dfxtp_1
X_9244_ clknet_leaf_41_clk _0356_ VGND VGND VPWR VPWR pe_accum\[1\]\[30\] sky130_fd_sc_hd__dfxtp_1
XFILLER_109_69 VPWR VGND VPWR VGND sky130_ef_sc_hd__decap_12
X_6456_ net432 _1977_ VGND VGND VPWR VPWR _0249_ sky130_fd_sc_hd__nor2_1
XFILLER_106_338 VPWR VGND VPWR VGND sky130_ef_sc_hd__decap_12
X_9175_ clknet_leaf_22_clk _0287_ VGND VGND VPWR VPWR pe_accum\[0\]\[29\] sky130_fd_sc_hd__dfxtp_1
X_6387_ net177 _1882_ _1881_ VGND VGND VPWR VPWR _1911_ sky130_fd_sc_hd__a21oi_1
X_5407_ _1103_ _1105_ _1136_ VGND VGND VPWR VPWR _1137_ sky130_fd_sc_hd__o21a_1
XFILLER_102_522 VGND VGND VPWR VPWR sky130_fd_sc_hd__decap_4
XFILLER_87_211 VGND VGND VPWR VPWR sky130_fd_sc_hd__fill_1
X_8126_ _3507_ _3515_ _3516_ VGND VGND VPWR VPWR _3517_ sky130_fd_sc_hd__nand3_1
X_5338_ net302 net629 _1041_ _1039_ VGND VGND VPWR VPWR _1070_ sky130_fd_sc_hd__a31o_1
X_8057_ net422 _3449_ VGND VGND VPWR VPWR _0378_ sky130_fd_sc_hd__nor2_1
XTAP_TAPCELL_ROW_89_1318 VGND VPWR sky130_fd_sc_hd__tapvpwrvgnd_1
XFILLER_87_277 VGND VGND VPWR VPWR sky130_fd_sc_hd__decap_3
XFILLER_75_417 VPWR VGND VPWR VGND sky130_ef_sc_hd__decap_12
X_5269_ net179 _1003_ VGND VGND VPWR VPWR _1004_ sky130_fd_sc_hd__xor2_1
X_7008_ net518 _2474_ _2425_ _2427_ VGND VGND VPWR VPWR _2476_ sky130_fd_sc_hd__o211ai_2
XFILLER_47_108 VGND VGND VPWR VPWR sky130_fd_sc_hd__decap_4
XFILLER_28_333 VGND VGND VPWR VPWR sky130_fd_sc_hd__decap_4
XFILLER_83_461 VGND VGND VPWR VPWR sky130_fd_sc_hd__decap_4
XFILLER_18_66 VGND VGND VPWR VPWR sky130_fd_sc_hd__fill_1
XFILLER_70_100 VGND VGND VPWR VPWR sky130_fd_sc_hd__decap_6
XFILLER_28_377 VPWR VGND VPWR VGND sky130_ef_sc_hd__decap_12
XFILLER_43_303 VGND VGND VPWR VPWR sky130_fd_sc_hd__decap_4
XFILLER_55_196 VGND VGND VPWR VPWR sky130_fd_sc_hd__fill_2
X_8959_ clknet_leaf_60_clk _0071_ VGND VGND VPWR VPWR pe_accum\[3\]\[27\] sky130_fd_sc_hd__dfxtp_1
XFILLER_71_678 VGND VGND VPWR VPWR sky130_fd_sc_hd__fill_2
XTAP_TAPCELL_ROW_54_898 VGND VPWR sky130_fd_sc_hd__tapvpwrvgnd_1
XTAP_TAPCELL_ROW_26_567 VGND VPWR sky130_fd_sc_hd__tapvpwrvgnd_1
XFILLER_109_110 VGND VGND VPWR VPWR sky130_fd_sc_hd__fill_2
XFILLER_50_53 VPWR VGND VPWR VGND sky130_ef_sc_hd__decap_12
XFILLER_59_95 VPWR VGND VPWR VGND sky130_ef_sc_hd__decap_12
XFILLER_66_406 VGND VGND VPWR VPWR sky130_fd_sc_hd__decap_6
XFILLER_93_225 VGND VGND VPWR VPWR sky130_fd_sc_hd__decap_4
XFILLER_93_214 VGND VGND VPWR VPWR sky130_fd_sc_hd__fill_1
XTAP_TAPCELL_ROW_70_1090 VGND VPWR sky130_fd_sc_hd__tapvpwrvgnd_1
Xfanout290 pe_array\[3\].u_pe.weight_in\[6\] VGND VGND VPWR VPWR net290 sky130_fd_sc_hd__dlymetal6s2s_1
XFILLER_19_311 VPWR VGND VPWR VGND sky130_ef_sc_hd__decap_12
XFILLER_75_50 VGND VGND VPWR VPWR sky130_fd_sc_hd__decap_6
XFILLER_46_141 VGND VGND VPWR VPWR sky130_fd_sc_hd__decap_4
XTAP_TAPCELL_ROW_109_1565 VGND VPWR sky130_fd_sc_hd__tapvpwrvgnd_1
XFILLER_74_483 VGND VGND VPWR VPWR sky130_fd_sc_hd__decap_8
XFILLER_62_612 VPWR VGND VPWR VGND sky130_ef_sc_hd__decap_12
XFILLER_47_697 VGND VGND VPWR VPWR sky130_fd_sc_hd__decap_3
X_4640_ _4400_ _4401_ VGND VGND VPWR VPWR _4402_ sky130_fd_sc_hd__nor2_1
XFILLER_30_542 VGND VGND VPWR VPWR sky130_fd_sc_hd__decap_8
X_6310_ _1836_ VGND VGND VPWR VPWR _1837_ sky130_fd_sc_hd__inv_2
X_4571_ _4332_ _4333_ net303 net484 VGND VGND VPWR VPWR _4335_ sky130_fd_sc_hd__or4bb_4
XFILLER_116_625 VPWR VGND VPWR VGND sky130_ef_sc_hd__decap_12
XFILLER_115_113 VGND VGND VPWR VPWR sky130_fd_sc_hd__fill_1
X_7290_ _2719_ _2699_ _2718_ VGND VGND VPWR VPWR _2751_ sky130_fd_sc_hd__a21bo_1
XFILLER_116_669 VPWR VGND VPWR VGND sky130_ef_sc_hd__decap_12
X_6241_ net157 _1768_ _1769_ VGND VGND VPWR VPWR _1770_ sky130_fd_sc_hd__or3_4
XFILLER_103_308 VGND VGND VPWR VPWR sky130_fd_sc_hd__decap_3
X_6172_ _1699_ _1700_ _1701_ VGND VGND VPWR VPWR _1703_ sky130_fd_sc_hd__a21o_1
XFILLER_69_244 VPWR VGND VPWR VGND sky130_ef_sc_hd__decap_12
X_5123_ net178 _0862_ VGND VGND VPWR VPWR _0863_ sky130_fd_sc_hd__xnor2_1
XFILLER_97_597 VPWR VGND VPWR VGND sky130_ef_sc_hd__decap_12
X_5054_ net744 _0757_ _0755_ VGND VGND VPWR VPWR _0796_ sky130_fd_sc_hd__a21o_1
XFILLER_84_247 VGND VGND VPWR VPWR sky130_fd_sc_hd__decap_4
X_8813_ pe_array\[2\].u_pe.accum_reg\[31\] _4182_ VGND VGND VPWR VPWR _4183_ sky130_fd_sc_hd__xnor2_1
XFILLER_25_314 VPWR VGND VPWR VGND sky130_ef_sc_hd__decap_12
XFILLER_111_15 VPWR VGND VPWR VGND sky130_ef_sc_hd__decap_12
XTAP_TAPCELL_ROW_84_1259 VGND VPWR sky130_fd_sc_hd__tapvpwrvgnd_1
XFILLER_52_122 VGND VGND VPWR VPWR sky130_fd_sc_hd__fill_1
X_8744_ _4116_ _4115_ VGND VGND VPWR VPWR _4117_ sky130_fd_sc_hd__and2b_1
X_5956_ _1489_ _1490_ _1491_ VGND VGND VPWR VPWR _1492_ sky130_fd_sc_hd__nand3_2
XFILLER_53_689 VGND VGND VPWR VPWR sky130_fd_sc_hd__decap_8
XFILLER_52_177 VGND VGND VPWR VPWR sky130_fd_sc_hd__decap_8
XFILLER_13_509 VGND VGND VPWR VPWR sky130_fd_sc_hd__decap_6
X_8675_ _4021_ _4023_ _4049_ VGND VGND VPWR VPWR _4050_ sky130_fd_sc_hd__o21a_1
X_5887_ net488 net346 net344 net494 VGND VGND VPWR VPWR _1424_ sky130_fd_sc_hd__a22oi_1
XTAP_TAPCELL_ROW_23_526 VGND VPWR sky130_fd_sc_hd__tapvpwrvgnd_1
X_4907_ net295 net435 pe_array\[3\].u_pe.accum_reg\[13\] VGND VGND VPWR VPWR _0653_
+ sky130_fd_sc_hd__a21oi_1
XFILLER_33_380 VPWR VGND VPWR VGND sky130_ef_sc_hd__decap_12
XTAP_TAPCELL_ROW_51_868 VGND VPWR sky130_fd_sc_hd__tapvpwrvgnd_1
X_7626_ _3070_ _3073_ _3074_ _3065_ VGND VGND VPWR VPWR _3075_ sky130_fd_sc_hd__o211a_1
X_4838_ _0584_ _0582_ _0532_ _0535_ VGND VGND VPWR VPWR _0586_ sky130_fd_sc_hd__o211a_1
XFILLER_107_603 VGND VGND VPWR VPWR sky130_fd_sc_hd__decap_4
X_7557_ net169 _2981_ _2979_ VGND VGND VPWR VPWR _3009_ sky130_fd_sc_hd__a21oi_1
X_4769_ net293 net460 VGND VGND VPWR VPWR _0518_ sky130_fd_sc_hd__nand2_1
X_6508_ net157 _2027_ VGND VGND VPWR VPWR _2028_ sky130_fd_sc_hd__xnor2_1
XFILLER_106_113 VGND VGND VPWR VPWR sky130_fd_sc_hd__fill_2
X_7488_ _2941_ _2940_ VGND VGND VPWR VPWR _2942_ sky130_fd_sc_hd__and2b_1
X_6439_ net202 _1928_ _1927_ VGND VGND VPWR VPWR _1961_ sky130_fd_sc_hd__a21boi_1
XTAP_TAPCELL_ROW_95_1388 VGND VPWR sky130_fd_sc_hd__tapvpwrvgnd_1
X_9227_ clknet_leaf_50_clk _0339_ VGND VGND VPWR VPWR pe_accum\[1\]\[13\] sky130_fd_sc_hd__dfxtp_1
XFILLER_20_67 VGND VGND VPWR VPWR sky130_fd_sc_hd__decap_4
XTAP_TAPCELL_ROW_95_1399 VGND VPWR sky130_fd_sc_hd__tapvpwrvgnd_1
X_9158_ clknet_leaf_30_clk _0270_ VGND VGND VPWR VPWR pe_accum\[0\]\[12\] sky130_fd_sc_hd__dfxtp_1
XFILLER_88_531 VGND VGND VPWR VPWR sky130_fd_sc_hd__fill_1
X_8109_ _3499_ _3494_ VGND VGND VPWR VPWR _3500_ sky130_fd_sc_hd__nand2b_1
XFILLER_102_352 VGND VGND VPWR VPWR sky130_fd_sc_hd__decap_3
X_9089_ clknet_leaf_64_clk _0201_ VGND VGND VPWR VPWR net39 sky130_fd_sc_hd__dfxtp_1
XFILLER_75_225 VGND VGND VPWR VPWR sky130_fd_sc_hd__decap_8
XTAP_TAPCELL_ROW_59_957 VGND VPWR sky130_fd_sc_hd__tapvpwrvgnd_1
XTAP_TAPCELL_ROW_3_295 VGND VPWR sky130_fd_sc_hd__tapvpwrvgnd_1
XTAP_TAPCELL_ROW_3_284 VGND VPWR sky130_fd_sc_hd__tapvpwrvgnd_1
XFILLER_43_122 VGND VGND VPWR VPWR sky130_fd_sc_hd__decap_3
XFILLER_8_513 VGND VGND VPWR VPWR sky130_fd_sc_hd__decap_4
XFILLER_8_557 VPWR VGND VPWR VGND sky130_ef_sc_hd__decap_12
XANTENNA_7 net370 VGND VGND VPWR VPWR sky130_fd_sc_hd__diode_2
XFILLER_113_617 VPWR VGND VPWR VGND sky130_ef_sc_hd__decap_12
XFILLER_98_306 VGND VGND VPWR VPWR sky130_fd_sc_hd__fill_2
XFILLER_66_225 VGND VGND VPWR VPWR sky130_fd_sc_hd__decap_3
XFILLER_66_214 VGND VGND VPWR VPWR sky130_fd_sc_hd__fill_1
XFILLER_94_589 VPWR VGND VPWR VGND sky130_ef_sc_hd__decap_12
Xrebuffer19 net533 VGND VGND VPWR VPWR net534 sky130_fd_sc_hd__buf_1
XFILLER_47_461 VPWR VGND VPWR VGND sky130_ef_sc_hd__decap_12
XFILLER_35_634 VGND VGND VPWR VPWR sky130_fd_sc_hd__fill_2
X_5810_ _1344_ _1345_ _1347_ VGND VGND VPWR VPWR _1349_ sky130_fd_sc_hd__and3_1
XFILLER_62_475 VGND VGND VPWR VPWR sky130_fd_sc_hd__fill_1
X_6790_ net481 net343 pe_array\[1\].u_pe.accum_reg\[4\] VGND VGND VPWR VPWR _2263_
+ sky130_fd_sc_hd__a21oi_1
X_5741_ _1264_ _1282_ VGND VGND VPWR VPWR _1283_ sky130_fd_sc_hd__and2_1
X_8460_ net164 _3810_ _3809_ VGND VGND VPWR VPWR _3842_ sky130_fd_sc_hd__o21bai_1
XFILLER_15_391 VGND VGND VPWR VPWR sky130_fd_sc_hd__fill_1
X_5672_ net1000 net368 VGND VGND VPWR VPWR _0213_ sky130_fd_sc_hd__and2_1
X_7411_ _2838_ _2840_ VGND VGND VPWR VPWR _2868_ sky130_fd_sc_hd__and2_4
X_8391_ _3732_ _3734_ _3773_ _3774_ VGND VGND VPWR VPWR _3775_ sky130_fd_sc_hd__o211a_1
X_4623_ _4385_ _4349_ VGND VGND VPWR VPWR _4386_ sky130_fd_sc_hd__xnor2_4
Xhold502 pe_array\[1\].u_pe.tap_count\[2\] VGND VGND VPWR VPWR net1017 sky130_fd_sc_hd__dlygate4sd3_1
X_7342_ net193 _2798_ net527 VGND VGND VPWR VPWR _2801_ sky130_fd_sc_hd__or3b_1
X_4554_ _4316_ _4317_ VGND VGND VPWR VPWR _4319_ sky130_fd_sc_hd__xor2_1
X_7273_ net266 _2731_ _2732_ VGND VGND VPWR VPWR _2734_ sky130_fd_sc_hd__or3_4
Xhold513 pe_array\[3\].u_pe.tap_count\[2\] VGND VGND VPWR VPWR net1028 sky130_fd_sc_hd__dlygate4sd3_1
X_6224_ net457 net360 pe_array\[0\].u_pe.accum_reg\[16\] VGND VGND VPWR VPWR _1753_
+ sky130_fd_sc_hd__a21oi_1
X_9012_ clknet_leaf_40_clk _0124_ VGND VGND VPWR VPWR net81 sky130_fd_sc_hd__dfxtp_1
X_4485_ net408 pe_array\[3\].u_pe.accum_reg\[0\] net257 _4253_ VGND VGND VPWR VPWR
+ _4254_ sky130_fd_sc_hd__o2bb2a_1
XFILLER_106_15 VPWR VGND VPWR VGND sky130_ef_sc_hd__decap_12
X_6155_ net458 net361 pe_array\[0\].u_pe.accum_reg\[14\] VGND VGND VPWR VPWR _1686_
+ sky130_fd_sc_hd__a21oi_1
XFILLER_111_182 VGND VGND VPWR VPWR sky130_fd_sc_hd__decap_6
X_6086_ _1616_ _1617_ net200 VGND VGND VPWR VPWR _1619_ sky130_fd_sc_hd__a21o_1
XFILLER_57_225 VGND VGND VPWR VPWR sky130_fd_sc_hd__decap_4
X_5106_ pe_array\[3\].u_pe.accum_reg\[19\] net295 net433 VGND VGND VPWR VPWR _0846_
+ sky130_fd_sc_hd__and3_1
X_5037_ _0548_ _0593_ _0550_ _0638_ net586 VGND VGND VPWR VPWR _0780_ sky130_fd_sc_hd__o311a_4
XTAP_TAPCELL_ROW_56_927 VGND VPWR sky130_fd_sc_hd__tapvpwrvgnd_1
XFILLER_26_612 VGND VGND VPWR VPWR sky130_fd_sc_hd__fill_1
XFILLER_82_29 VGND VGND VPWR VPWR sky130_fd_sc_hd__fill_1
XTAP_TAPCELL_ROW_0_243 VGND VPWR sky130_fd_sc_hd__tapvpwrvgnd_1
XTAP_TAPCELL_ROW_0_254 VGND VPWR sky130_fd_sc_hd__tapvpwrvgnd_1
XFILLER_25_111 VGND VGND VPWR VPWR sky130_fd_sc_hd__fill_1
XFILLER_25_122 VGND VGND VPWR VPWR sky130_fd_sc_hd__decap_6
XFILLER_41_615 VGND VGND VPWR VPWR sky130_fd_sc_hd__fill_1
X_8727_ _4098_ _4099_ VGND VGND VPWR VPWR _4100_ sky130_fd_sc_hd__nor2_1
XFILLER_80_294 VGND VGND VPWR VPWR sky130_fd_sc_hd__decap_6
XFILLER_80_283 VGND VGND VPWR VPWR sky130_fd_sc_hd__decap_4
XTAP_TAPCELL_ROW_36_684 VGND VPWR sky130_fd_sc_hd__tapvpwrvgnd_1
X_6988_ net452 net334 net332 net465 VGND VGND VPWR VPWR _2456_ sky130_fd_sc_hd__a22o_1
XFILLER_41_648 VPWR VGND VPWR VGND sky130_ef_sc_hd__decap_12
X_5939_ _1466_ _1474_ VGND VGND VPWR VPWR _1475_ sky130_fd_sc_hd__nand2b_1
X_8658_ _4008_ _4005_ _4033_ VGND VGND VPWR VPWR _4034_ sky130_fd_sc_hd__a21o_1
XTAP_TAPCELL_ROW_97_1417 VGND VPWR sky130_fd_sc_hd__tapvpwrvgnd_1
X_8589_ net155 _3935_ _3934_ VGND VGND VPWR VPWR _3967_ sky130_fd_sc_hd__o21bai_1
XFILLER_31_33 VGND VGND VPWR VPWR sky130_fd_sc_hd__fill_1
X_7609_ _3058_ _3057_ VGND VGND VPWR VPWR _3059_ sky130_fd_sc_hd__and2b_1
XFILLER_107_400 VGND VGND VPWR VPWR sky130_fd_sc_hd__fill_1
Xoutput22 net22 VGND VGND VPWR VPWR result_data[0] sky130_fd_sc_hd__buf_2
XFILLER_103_3 VPWR VGND VPWR VGND sky130_ef_sc_hd__decap_12
Xoutput33 net33 VGND VGND VPWR VPWR result_data[10] sky130_fd_sc_hd__buf_2
Xoutput66 net66 VGND VGND VPWR VPWR result_data[24] sky130_fd_sc_hd__buf_2
Xoutput44 net44 VGND VGND VPWR VPWR result_data[11] sky130_fd_sc_hd__buf_2
Xoutput55 net55 VGND VGND VPWR VPWR result_data[14] sky130_fd_sc_hd__buf_2
XTAP_TAPCELL_ROW_8_354 VGND VPWR sky130_fd_sc_hd__tapvpwrvgnd_1
Xoutput77 net77 VGND VGND VPWR VPWR result_data[34] sky130_fd_sc_hd__buf_2
Xoutput99 net99 VGND VGND VPWR VPWR result_data[54] sky130_fd_sc_hd__buf_2
Xoutput88 net88 VGND VGND VPWR VPWR result_data[44] sky130_fd_sc_hd__buf_2
XFILLER_103_694 VGND VGND VPWR VPWR sky130_fd_sc_hd__fill_2
XFILLER_76_545 VGND VGND VPWR VPWR sky130_fd_sc_hd__decap_6
XFILLER_56_41 VPWR VGND VPWR VGND sky130_ef_sc_hd__decap_12
XFILLER_17_612 VGND VGND VPWR VPWR sky130_fd_sc_hd__decap_4
XTAP_TAPCELL_ROW_106_1524 VGND VPWR sky130_fd_sc_hd__tapvpwrvgnd_1
XFILLER_63_239 VGND VGND VPWR VPWR sky130_fd_sc_hd__decap_4
XFILLER_56_85 VPWR VGND VPWR VGND sky130_ef_sc_hd__decap_12
XFILLER_16_122 VGND VGND VPWR VPWR sky130_fd_sc_hd__fill_1
XFILLER_71_261 VPWR VGND VPWR VGND sky130_ef_sc_hd__decap_12
XFILLER_31_125 VGND VGND VPWR VPWR sky130_fd_sc_hd__fill_1
XFILLER_31_136 VGND VGND VPWR VPWR sky130_fd_sc_hd__fill_2
XFILLER_40_681 VGND VGND VPWR VPWR sky130_fd_sc_hd__decap_3
XFILLER_68_6 VGND VGND VPWR VPWR sky130_fd_sc_hd__fill_1
XFILLER_8_365 VGND VGND VPWR VPWR sky130_fd_sc_hd__fill_1
XTAP_TAPCELL_ROW_117_1664 VGND VPWR sky130_fd_sc_hd__tapvpwrvgnd_1
XTAP_TAPCELL_ROW_117_1653 VGND VPWR sky130_fd_sc_hd__tapvpwrvgnd_1
XTAP_TAPCELL_ROW_117_1675 VGND VPWR sky130_fd_sc_hd__tapvpwrvgnd_1
XFILLER_98_147 VGND VGND VPWR VPWR sky130_fd_sc_hd__fill_1
XFILLER_98_158 VGND VGND VPWR VPWR sky130_fd_sc_hd__fill_1
XFILLER_94_320 VGND VGND VPWR VPWR sky130_fd_sc_hd__fill_2
XFILLER_94_386 VPWR VGND VPWR VGND sky130_ef_sc_hd__decap_12
XFILLER_82_526 VGND VGND VPWR VPWR sky130_fd_sc_hd__decap_6
X_7960_ _3353_ _3354_ VGND VGND VPWR VPWR _3355_ sky130_fd_sc_hd__and2b_1
X_7891_ net404 pe_array\[2\].u_pe.accum_reg\[4\] net220 _3287_ VGND VGND VPWR VPWR
+ _3288_ sky130_fd_sc_hd__o2bb2a_1
X_6911_ _2323_ _2341_ _2340_ VGND VGND VPWR VPWR _2381_ sky130_fd_sc_hd__a21bo_1
X_6842_ _2280_ _2312_ VGND VGND VPWR VPWR _2314_ sky130_fd_sc_hd__nor2_1
XFILLER_23_604 VGND VGND VPWR VPWR sky130_fd_sc_hd__decap_6
XTAP_TAPCELL_ROW_81_1229 VGND VPWR sky130_fd_sc_hd__tapvpwrvgnd_1
X_6773_ net511 net591 net335 net333 VGND VGND VPWR VPWR _2247_ sky130_fd_sc_hd__and4_1
XFILLER_50_445 VPWR VGND VPWR VGND sky130_ef_sc_hd__decap_12
XTAP_TAPCELL_ROW_33_654 VGND VPWR sky130_fd_sc_hd__tapvpwrvgnd_1
X_8512_ _3890_ _3889_ net262 VGND VGND VPWR VPWR _3892_ sky130_fd_sc_hd__or3_4
X_5724_ net409 pe_array\[0\].u_pe.accum_reg\[2\] net239 _1266_ VGND VGND VPWR VPWR
+ _1267_ sky130_fd_sc_hd__o2bb2a_1
XTAP_TAPCELL_ROW_61_985 VGND VPWR sky130_fd_sc_hd__tapvpwrvgnd_1
XFILLER_31_670 VGND VGND VPWR VPWR sky130_fd_sc_hd__fill_2
X_8443_ net402 pe_array\[2\].u_pe.accum_reg\[18\] net217 _3825_ VGND VGND VPWR VPWR
+ _3826_ sky130_fd_sc_hd__o2bb2a_4
X_5655_ net929 net370 VGND VGND VPWR VPWR _0196_ sky130_fd_sc_hd__and2_1
X_8374_ _3758_ VGND VGND VPWR VPWR _3759_ sky130_fd_sc_hd__inv_2
X_4606_ pe_array\[3\].u_pe.accum_reg\[6\] net299 net484 VGND VGND VPWR VPWR _4369_
+ sky130_fd_sc_hd__nand3_1
X_7325_ _2783_ _2784_ VGND VGND VPWR VPWR _2785_ sky130_fd_sc_hd__nand2_1
X_5586_ net978 net376 VGND VGND VPWR VPWR _0127_ sky130_fd_sc_hd__and2_1
X_4537_ _4300_ _4301_ VGND VGND VPWR VPWR _4302_ sky130_fd_sc_hd__xor2_1
XFILLER_117_69 VPWR VGND VPWR VGND sky130_ef_sc_hd__decap_12
Xhold376 pe_array\[0\].u_pe.valid_out VGND VGND VPWR VPWR net891 sky130_fd_sc_hd__dlygate4sd3_1
XFILLER_104_425 VGND VGND VPWR VPWR sky130_fd_sc_hd__fill_1
XTAP_TAPCELL_ROW_92_1358 VGND VPWR sky130_fd_sc_hd__tapvpwrvgnd_1
Xhold387 pe_accum\[0\]\[16\] VGND VGND VPWR VPWR net902 sky130_fd_sc_hd__dlygate4sd3_1
X_4468_ net20 _4240_ _4241_ pe_array\[0\].u_pe.weight_in\[7\] VGND VGND VPWR VPWR
+ _0007_ sky130_fd_sc_hd__a22o_1
X_7256_ _2715_ _2716_ _2717_ VGND VGND VPWR VPWR _2718_ sky130_fd_sc_hd__nand3_1
Xhold398 pe_accum\[0\]\[3\] VGND VGND VPWR VPWR net913 sky130_fd_sc_hd__dlygate4sd3_1
X_6207_ _1735_ _1736_ VGND VGND VPWR VPWR _1737_ sky130_fd_sc_hd__nand2_2
XTAP_TAPCELL_ROW_5_313 VGND VPWR sky130_fd_sc_hd__tapvpwrvgnd_1
X_7187_ _2648_ _2649_ _2603_ _2605_ VGND VGND VPWR VPWR _2651_ sky130_fd_sc_hd__o211ai_1
XFILLER_98_681 VPWR VGND VPWR VGND sky130_ef_sc_hd__decap_12
X_6138_ _1631_ _1668_ _1669_ VGND VGND VPWR VPWR _1670_ sky130_fd_sc_hd__nand3_1
XFILLER_58_501 VGND VGND VPWR VPWR sky130_fd_sc_hd__fill_1
XFILLER_85_331 VGND VGND VPWR VPWR sky130_fd_sc_hd__decap_4
X_6069_ net466 net455 net347 net345 VGND VGND VPWR VPWR _1602_ sky130_fd_sc_hd__and4_1
XFILLER_60_209 VGND VGND VPWR VPWR sky130_fd_sc_hd__decap_6
XFILLER_26_55 VGND VGND VPWR VPWR sky130_fd_sc_hd__fill_1
XFILLER_53_272 VGND VGND VPWR VPWR sky130_fd_sc_hd__decap_8
XFILLER_13_103 VGND VGND VPWR VPWR sky130_fd_sc_hd__decap_8
XFILLER_13_158 VGND VGND VPWR VPWR sky130_fd_sc_hd__decap_8
XFILLER_9_107 VGND VGND VPWR VPWR sky130_fd_sc_hd__decap_4
XTAP_TAPCELL_ROW_101_1465 VGND VPWR sky130_fd_sc_hd__tapvpwrvgnd_1
XFILLER_13_169 VPWR VGND VPWR VGND sky130_ef_sc_hd__decap_12
XFILLER_21_180 VPWR VGND VPWR VGND sky130_ef_sc_hd__decap_12
XFILLER_42_65 VPWR VGND VPWR VGND sky130_ef_sc_hd__decap_12
XFILLER_5_335 VGND VGND VPWR VPWR sky130_fd_sc_hd__fill_1
XPHY_EDGE_ROW_2_Left_120 VGND VGND VPWR VPWR sky130_fd_sc_hd__decap_3
XFILLER_107_263 VGND VGND VPWR VPWR sky130_fd_sc_hd__decap_3
XPHY_EDGE_ROW_39_Left_157 VGND VGND VPWR VPWR sky130_fd_sc_hd__decap_3
XFILLER_68_309 VGND VGND VPWR VPWR sky130_fd_sc_hd__decap_6
XFILLER_3_15 VPWR VGND VPWR VGND sky130_ef_sc_hd__decap_12
XTAP_TAPCELL_ROW_112_1594 VGND VPWR sky130_fd_sc_hd__tapvpwrvgnd_1
XFILLER_95_106 VGND VGND VPWR VPWR sky130_fd_sc_hd__decap_6
XFILLER_89_681 VGND VGND VPWR VPWR sky130_fd_sc_hd__fill_1
XFILLER_1_585 VPWR VGND VPWR VGND sky130_ef_sc_hd__decap_12
XFILLER_76_342 VGND VGND VPWR VPWR sky130_fd_sc_hd__decap_3
XFILLER_49_545 VPWR VGND VPWR VGND sky130_ef_sc_hd__decap_12
XFILLER_76_353 VGND VGND VPWR VPWR sky130_fd_sc_hd__decap_8
XFILLER_91_345 VGND VGND VPWR VPWR sky130_fd_sc_hd__decap_8
XPHY_EDGE_ROW_48_Left_166 VGND VGND VPWR VPWR sky130_fd_sc_hd__decap_3
XFILLER_83_83 VGND VGND VPWR VPWR sky130_fd_sc_hd__decap_4
XTAP_TAPCELL_ROW_67_1062 VGND VPWR sky130_fd_sc_hd__tapvpwrvgnd_1
XFILLER_32_401 VPWR VGND VPWR VGND sky130_ef_sc_hd__decap_12
XFILLER_20_607 VGND VGND VPWR VPWR sky130_fd_sc_hd__decap_4
XTAP_TAPCELL_ROW_30_613 VGND VPWR sky130_fd_sc_hd__tapvpwrvgnd_1
XFILLER_9_685 VPWR VGND VPWR VGND sky130_ef_sc_hd__decap_12
X_5440_ _1157_ _1167_ VGND VGND VPWR VPWR _1169_ sky130_fd_sc_hd__xnor2_1
XFILLER_66_3 VPWR VGND VPWR VGND sky130_ef_sc_hd__decap_12
XPHY_EDGE_ROW_57_Left_175 VGND VGND VPWR VPWR sky130_fd_sc_hd__decap_3
XTAP_TAPCELL_ROW_10_370 VGND VPWR sky130_fd_sc_hd__tapvpwrvgnd_1
X_5371_ _1065_ _1067_ VGND VGND VPWR VPWR _1102_ sky130_fd_sc_hd__or2_1
XFILLER_99_445 VGND VGND VPWR VPWR sky130_fd_sc_hd__decap_3
XTAP_TAPCELL_ROW_78_1191 VGND VPWR sky130_fd_sc_hd__tapvpwrvgnd_1
X_8090_ _3412_ _3415_ _3480_ _3481_ VGND VGND VPWR VPWR _3482_ sky130_fd_sc_hd__a211oi_2
X_7110_ net330 _2498_ net529 VGND VGND VPWR VPWR _2575_ sky130_fd_sc_hd__a21oi_2
XFILLER_87_607 VGND VGND VPWR VPWR sky130_fd_sc_hd__decap_4
X_7041_ _2460_ _2462_ net546 _2507_ VGND VGND VPWR VPWR _2508_ sky130_fd_sc_hd__o211ai_2
XFILLER_101_428 VGND VGND VPWR VPWR sky130_fd_sc_hd__fill_1
XFILLER_87_629 VGND VGND VPWR VPWR sky130_fd_sc_hd__decap_4
XFILLER_86_139 VGND VGND VPWR VPWR sky130_fd_sc_hd__fill_1
X_8992_ clknet_leaf_27_clk _0104_ VGND VGND VPWR VPWR net59 sky130_fd_sc_hd__dfxtp_1
XPHY_EDGE_ROW_66_Left_184 VGND VGND VPWR VPWR sky130_fd_sc_hd__decap_3
XFILLER_27_217 VGND VGND VPWR VPWR sky130_fd_sc_hd__fill_1
XTAP_TAPCELL_ROW_38_713 VGND VPWR sky130_fd_sc_hd__tapvpwrvgnd_1
XFILLER_103_27 VPWR VGND VPWR VGND sky130_ef_sc_hd__decap_12
X_7943_ _3333_ _3337_ VGND VGND VPWR VPWR _3338_ sky130_fd_sc_hd__xnor2_1
X_7874_ _3268_ _3269_ _3246_ _3247_ VGND VGND VPWR VPWR _3271_ sky130_fd_sc_hd__a211o_1
XTAP_TAPCELL_ROW_18_470 VGND VPWR sky130_fd_sc_hd__tapvpwrvgnd_1
XFILLER_35_261 VPWR VGND VPWR VGND sky130_ef_sc_hd__decap_12
X_6825_ _2264_ _2265_ _2295_ _2296_ VGND VGND VPWR VPWR _2297_ sky130_fd_sc_hd__o211ai_2
X_6756_ net511 net335 _2230_ VGND VGND VPWR VPWR _2231_ sky130_fd_sc_hd__nand3_1
XFILLER_11_629 VPWR VGND VPWR VGND sky130_ef_sc_hd__decap_12
XFILLER_11_607 VGND VGND VPWR VPWR sky130_fd_sc_hd__decap_8
XFILLER_23_489 VPWR VGND VPWR VGND sky130_ef_sc_hd__decap_12
XFILLER_50_253 VGND VGND VPWR VPWR sky130_fd_sc_hd__decap_4
X_5707_ _1241_ _1249_ VGND VGND VPWR VPWR _1251_ sky130_fd_sc_hd__or2_1
XFILLER_10_139 VGND VGND VPWR VPWR sky130_fd_sc_hd__fill_1
XFILLER_50_297 VGND VGND VPWR VPWR sky130_fd_sc_hd__decap_3
X_6687_ net429 _2200_ VGND VGND VPWR VPWR _0257_ sky130_fd_sc_hd__nor2_1
XPHY_EDGE_ROW_75_Left_193 VGND VGND VPWR VPWR sky130_fd_sc_hd__decap_3
X_5638_ net936 net385 VGND VGND VPWR VPWR _0179_ sky130_fd_sc_hd__and2_1
X_8426_ _3806_ _3807_ _3808_ VGND VGND VPWR VPWR _3809_ sky130_fd_sc_hd__and3_1
XFILLER_117_561 VPWR VGND VPWR VGND sky130_ef_sc_hd__decap_12
X_5569_ net908 net393 VGND VGND VPWR VPWR _0110_ sky130_fd_sc_hd__and2_1
X_8357_ net190 _3710_ _3708_ VGND VGND VPWR VPWR _3742_ sky130_fd_sc_hd__a21o_1
X_7308_ net446 net338 pe_array\[1\].u_pe.accum_reg\[17\] VGND VGND VPWR VPWR _2768_
+ sky130_fd_sc_hd__a21oi_1
X_8288_ _3671_ _3672_ net683 VGND VGND VPWR VPWR _3675_ sky130_fd_sc_hd__o21ai_1
X_7239_ _2663_ _2664_ VGND VGND VPWR VPWR _2701_ sky130_fd_sc_hd__or2_4
XFILLER_100_494 VGND VGND VPWR VPWR sky130_fd_sc_hd__decap_3
XFILLER_85_172 VPWR VGND VPWR VGND sky130_ef_sc_hd__decap_12
XFILLER_46_559 VGND VGND VPWR VPWR sky130_fd_sc_hd__fill_1
XFILLER_14_401 VPWR VGND VPWR VGND sky130_ef_sc_hd__decap_12
XFILLER_14_445 VPWR VGND VPWR VGND sky130_ef_sc_hd__decap_12
XFILLER_26_294 VGND VGND VPWR VPWR sky130_fd_sc_hd__decap_3
XFILLER_10_684 VPWR VGND VPWR VGND sky130_ef_sc_hd__decap_12
XTAP_TAPCELL_ROW_114_1623 VGND VPWR sky130_fd_sc_hd__tapvpwrvgnd_1
XFILLER_6_699 VGND VGND VPWR VPWR sky130_fd_sc_hd__fill_1
XFILLER_5_187 VGND VGND VPWR VPWR sky130_fd_sc_hd__fill_1
XFILLER_96_437 VGND VGND VPWR VPWR sky130_fd_sc_hd__decap_6
XFILLER_69_629 VPWR VGND VPWR VGND sky130_ef_sc_hd__decap_12
XFILLER_77_673 VPWR VGND VPWR VGND sky130_ef_sc_hd__decap_12
XFILLER_92_632 VPWR VGND VPWR VGND sky130_ef_sc_hd__decap_12
XFILLER_37_548 VPWR VGND VPWR VGND sky130_ef_sc_hd__decap_12
XFILLER_94_82 VGND VGND VPWR VPWR sky130_fd_sc_hd__fill_2
XFILLER_64_345 VGND VGND VPWR VPWR sky130_fd_sc_hd__decap_3
X_4940_ _0683_ _0598_ VGND VGND VPWR VPWR _0685_ sky130_fd_sc_hd__xor2_4
X_4871_ net204 _0615_ _0617_ VGND VGND VPWR VPWR _0618_ sky130_fd_sc_hd__or3b_4
X_6610_ _2125_ _2126_ VGND VGND VPWR VPWR _2127_ sky130_fd_sc_hd__nand2_1
XFILLER_60_584 VGND VGND VPWR VPWR sky130_fd_sc_hd__decap_4
XFILLER_32_253 VGND VGND VPWR VPWR sky130_fd_sc_hd__decap_3
X_7590_ net626 _3040_ VGND VGND VPWR VPWR _3041_ sky130_fd_sc_hd__or2_4
XTAP_TAPCELL_ROW_43_771 VGND VPWR sky130_fd_sc_hd__tapvpwrvgnd_1
X_6541_ _2030_ _2058_ VGND VGND VPWR VPWR _2060_ sky130_fd_sc_hd__xnor2_1
XFILLER_20_448 VGND VGND VPWR VPWR sky130_fd_sc_hd__decap_3
X_6472_ _1991_ _1992_ VGND VGND VPWR VPWR _1993_ sky130_fd_sc_hd__and2b_1
X_9260_ clknet_leaf_15_clk _0372_ VGND VGND VPWR VPWR pe_array\[2\].u_pe.accum_reg\[2\]
+ sky130_fd_sc_hd__dfxtp_1
XFILLER_106_509 VGND VGND VPWR VPWR sky130_fd_sc_hd__decap_8
X_8211_ _3597_ net187 _3599_ VGND VGND VPWR VPWR _3600_ sky130_fd_sc_hd__or3b_4
X_5423_ _1150_ _1151_ VGND VGND VPWR VPWR _1153_ sky130_fd_sc_hd__nand2_1
X_9191_ clknet_leaf_38_clk _0303_ VGND VGND VPWR VPWR pe_array\[1\].u_pe.accum_reg\[9\]
+ sky130_fd_sc_hd__dfxtp_1
X_8142_ _3442_ _3486_ _3487_ VGND VGND VPWR VPWR _3533_ sky130_fd_sc_hd__a21o_1
X_5354_ _1057_ _1085_ VGND VGND VPWR VPWR _1086_ sky130_fd_sc_hd__nand2_1
XFILLER_114_564 VPWR VGND VPWR VGND sky130_ef_sc_hd__decap_12
XFILLER_114_531 VGND VGND VPWR VPWR sky130_fd_sc_hd__fill_1
X_8073_ net444 pe_array\[2\].u_pe.weight_in\[2\] VGND VGND VPWR VPWR _3465_ sky130_fd_sc_hd__nand2_8
X_5285_ _1017_ _1018_ VGND VGND VPWR VPWR _1019_ sky130_fd_sc_hd__nor2_1
XFILLER_114_15 VPWR VGND VPWR VGND sky130_ef_sc_hd__decap_12
XFILLER_101_236 VGND VGND VPWR VPWR sky130_fd_sc_hd__fill_1
X_7024_ _2489_ _2490_ VGND VGND VPWR VPWR _2491_ sky130_fd_sc_hd__nand2b_1
XFILLER_101_269 VGND VGND VPWR VPWR sky130_fd_sc_hd__decap_8
XFILLER_83_621 VPWR VGND VPWR VGND sky130_ef_sc_hd__decap_12
XFILLER_82_120 VGND VGND VPWR VPWR sky130_fd_sc_hd__decap_8
XFILLER_55_334 VGND VGND VPWR VPWR sky130_fd_sc_hd__fill_2
X_8975_ clknet_leaf_12_clk _0087_ VGND VGND VPWR VPWR net61 sky130_fd_sc_hd__dfxtp_1
X_7926_ _3289_ _3321_ VGND VGND VPWR VPWR _3322_ sky130_fd_sc_hd__xnor2_1
XFILLER_15_209 VGND VGND VPWR VPWR sky130_fd_sc_hd__decap_3
X_7857_ _3253_ _3254_ VGND VGND VPWR VPWR _3255_ sky130_fd_sc_hd__nor2_1
XFILLER_82_197 VGND VGND VPWR VPWR sky130_fd_sc_hd__fill_2
X_6808_ _2254_ _2279_ VGND VGND VPWR VPWR _2281_ sky130_fd_sc_hd__and2_1
XPHY_EDGE_ROW_83_Left_201 VGND VGND VPWR VPWR sky130_fd_sc_hd__decap_3
X_7788_ net932 net227 _3203_ net378 VGND VGND VPWR VPWR _0355_ sky130_fd_sc_hd__o211a_1
X_6739_ net591 net342 pe_array\[1\].u_pe.accum_reg\[1\] VGND VGND VPWR VPWR _2215_
+ sky130_fd_sc_hd__a21oi_1
X_8409_ _3754_ _3791_ VGND VGND VPWR VPWR _3793_ sky130_fd_sc_hd__and2_1
XPHY_EDGE_ROW_92_Left_210 VGND VGND VPWR VPWR sky130_fd_sc_hd__decap_3
XFILLER_78_426 VPWR VGND VPWR VGND sky130_ef_sc_hd__decap_12
Xfanout450 net451 VGND VGND VPWR VPWR net450 sky130_fd_sc_hd__buf_8
XFILLER_59_673 VGND VGND VPWR VPWR sky130_fd_sc_hd__decap_6
Xfanout461 net468 VGND VGND VPWR VPWR net461 sky130_fd_sc_hd__clkbuf_2
Xfanout483 net486 VGND VGND VPWR VPWR net483 sky130_fd_sc_hd__buf_2
Xfanout472 net873 VGND VGND VPWR VPWR net472 sky130_fd_sc_hd__buf_2
Xclone229 net745 VGND VGND VPWR VPWR net744 sky130_fd_sc_hd__clkbuf_1
XFILLER_48_53 VPWR VGND VPWR VGND sky130_ef_sc_hd__decap_12
XFILLER_74_643 VGND VGND VPWR VPWR sky130_fd_sc_hd__fill_1
Xfanout494 net495 VGND VGND VPWR VPWR net494 sky130_fd_sc_hd__buf_2
XFILLER_59_684 VPWR VGND VPWR VGND sky130_ef_sc_hd__decap_12
XFILLER_58_194 VGND VGND VPWR VPWR sky130_fd_sc_hd__fill_2
XFILLER_0_27 VGND VGND VPWR VPWR sky130_fd_sc_hd__fill_1
XFILLER_19_559 VGND VGND VPWR VPWR sky130_fd_sc_hd__fill_1
XFILLER_64_41 VPWR VGND VPWR VGND sky130_ef_sc_hd__decap_12
XFILLER_27_581 VGND VGND VPWR VPWR sky130_fd_sc_hd__fill_1
XTAP_TAPCELL_ROW_64_1021 VGND VPWR sky130_fd_sc_hd__tapvpwrvgnd_1
XTAP_TAPCELL_ROW_29_598 VGND VPWR sky130_fd_sc_hd__tapvpwrvgnd_1
XFILLER_14_253 VPWR VGND VPWR VGND sky130_ef_sc_hd__decap_12
XFILLER_42_584 VGND VGND VPWR VPWR sky130_fd_sc_hd__decap_4
XFILLER_80_62 VGND VGND VPWR VPWR sky130_fd_sc_hd__decap_3
XTAP_TAPCELL_ROW_40_730 VGND VPWR sky130_fd_sc_hd__tapvpwrvgnd_1
XTAP_TAPCELL_ROW_75_1150 VGND VPWR sky130_fd_sc_hd__tapvpwrvgnd_1
XFILLER_111_501 VGND VGND VPWR VPWR sky130_fd_sc_hd__decap_3
XFILLER_69_426 VGND VGND VPWR VPWR sky130_fd_sc_hd__decap_6
X_5070_ _0774_ _0783_ VGND VGND VPWR VPWR _0812_ sky130_fd_sc_hd__nor2_4
XFILLER_56_109 VGND VGND VPWR VPWR sky130_fd_sc_hd__decap_8
XTAP_TAPCELL_ROW_48_830 VGND VPWR sky130_fd_sc_hd__tapvpwrvgnd_1
XFILLER_65_665 VGND VGND VPWR VPWR sky130_fd_sc_hd__decap_6
XFILLER_64_131 VGND VGND VPWR VPWR sky130_fd_sc_hd__decap_8
XFILLER_92_473 VGND VGND VPWR VPWR sky130_fd_sc_hd__decap_3
X_8760_ _4130_ _4131_ VGND VGND VPWR VPWR _4132_ sky130_fd_sc_hd__nand2_1
X_5972_ _1506_ _1507_ VGND VGND VPWR VPWR _1508_ sky130_fd_sc_hd__xnor2_1
XTAP_TAPCELL_ROW_86_1290 VGND VPWR sky130_fd_sc_hd__tapvpwrvgnd_1
XFILLER_80_657 VPWR VGND VPWR VGND sky130_ef_sc_hd__decap_12
XFILLER_64_197 VGND VGND VPWR VPWR sky130_fd_sc_hd__decap_4
X_4923_ _0666_ _0667_ _0621_ _0624_ VGND VGND VPWR VPWR _0669_ sky130_fd_sc_hd__o211a_1
X_7711_ _3156_ _3157_ VGND VGND VPWR VPWR _3158_ sky130_fd_sc_hd__or2_4
X_8691_ _4041_ _4042_ _4044_ VGND VGND VPWR VPWR _4065_ sky130_fd_sc_hd__a21oi_1
XFILLER_33_573 VPWR VGND VPWR VGND sky130_ef_sc_hd__decap_12
X_7642_ _3052_ _3053_ _3055_ VGND VGND VPWR VPWR _3091_ sky130_fd_sc_hd__a21oi_1
X_4854_ net291 net289 net435 VGND VGND VPWR VPWR _0601_ sky130_fd_sc_hd__and3_1
X_7573_ _3021_ _3022_ VGND VGND VPWR VPWR _3024_ sky130_fd_sc_hd__xnor2_1
X_4785_ _0517_ _0533_ _0532_ VGND VGND VPWR VPWR _0534_ sky130_fd_sc_hd__and3_1
X_6524_ net276 _2042_ VGND VGND VPWR VPWR _2043_ sky130_fd_sc_hd__xnor2_1
X_9312_ clknet_leaf_5_clk _0424_ VGND VGND VPWR VPWR pe_accum\[2\]\[22\] sky130_fd_sc_hd__dfxtp_1
XFILLER_20_278 VGND VGND VPWR VPWR sky130_fd_sc_hd__decap_4
XFILLER_109_15 VPWR VGND VPWR VGND sky130_ef_sc_hd__decap_12
X_9243_ clknet_leaf_41_clk _0355_ VGND VGND VPWR VPWR pe_accum\[1\]\[29\] sky130_fd_sc_hd__dfxtp_1
X_6455_ net411 pe_array\[0\].u_pe.accum_reg\[23\] net241 _1976_ VGND VGND VPWR VPWR
+ _1977_ sky130_fd_sc_hd__o2bb2a_1
X_9174_ clknet_leaf_22_clk _0286_ VGND VGND VPWR VPWR pe_accum\[0\]\[28\] sky130_fd_sc_hd__dfxtp_1
X_6386_ net175 _1909_ VGND VGND VPWR VPWR _1910_ sky130_fd_sc_hd__xnor2_1
X_5406_ net690 _1134_ VGND VGND VPWR VPWR _1136_ sky130_fd_sc_hd__xnor2_1
X_8125_ _3514_ _3513_ _3467_ _3468_ VGND VGND VPWR VPWR _3516_ sky130_fd_sc_hd__a211o_1
XFILLER_0_617 VPWR VGND VPWR VGND sky130_ef_sc_hd__decap_12
X_5337_ _1067_ _1068_ VGND VGND VPWR VPWR _1069_ sky130_fd_sc_hd__nor2_1
XFILLER_87_223 VGND VGND VPWR VPWR sky130_fd_sc_hd__fill_1
X_8056_ net404 pe_array\[2\].u_pe.accum_reg\[8\] net219 _3448_ VGND VGND VPWR VPWR
+ _3449_ sky130_fd_sc_hd__o2bb2a_1
X_5268_ _1001_ _1002_ VGND VGND VPWR VPWR _1003_ sky130_fd_sc_hd__nor2_1
XFILLER_102_589 VGND VGND VPWR VPWR sky130_fd_sc_hd__decap_6
XFILLER_102_578 VGND VGND VPWR VPWR sky130_fd_sc_hd__decap_8
XFILLER_102_556 VGND VGND VPWR VPWR sky130_fd_sc_hd__fill_2
XTAP_TAPCELL_ROW_89_1319 VGND VPWR sky130_fd_sc_hd__tapvpwrvgnd_1
X_7007_ _2425_ _2427_ _2474_ _2472_ VGND VGND VPWR VPWR _2475_ sky130_fd_sc_hd__a211o_4
XFILLER_75_429 VGND VGND VPWR VPWR sky130_fd_sc_hd__decap_4
XFILLER_68_492 VPWR VGND VPWR VGND sky130_ef_sc_hd__decap_12
X_5199_ _0934_ _0935_ VGND VGND VPWR VPWR _0936_ sky130_fd_sc_hd__nor2_1
XFILLER_55_153 VGND VGND VPWR VPWR sky130_fd_sc_hd__fill_2
X_8958_ clknet_leaf_60_clk _0070_ VGND VGND VPWR VPWR pe_accum\[3\]\[26\] sky130_fd_sc_hd__dfxtp_1
XFILLER_16_518 VPWR VGND VPWR VGND sky130_ef_sc_hd__decap_12
XFILLER_28_389 VGND VGND VPWR VPWR sky130_fd_sc_hd__decap_6
X_7909_ _3290_ _3303_ _3304_ VGND VGND VPWR VPWR _3305_ sky130_fd_sc_hd__nand3_1
XFILLER_43_337 VGND VGND VPWR VPWR sky130_fd_sc_hd__decap_3
X_8889_ clknet_leaf_36_clk _0001_ VGND VGND VPWR VPWR pe_array\[0\].u_pe.weight_in\[1\]
+ sky130_fd_sc_hd__dfxtp_1
XTAP_TAPCELL_ROW_26_568 VGND VPWR sky130_fd_sc_hd__tapvpwrvgnd_1
XTAP_TAPCELL_ROW_54_899 VGND VPWR sky130_fd_sc_hd__tapvpwrvgnd_1
XFILLER_11_256 VGND VGND VPWR VPWR sky130_fd_sc_hd__fill_2
XFILLER_50_65 VPWR VGND VPWR VGND sky130_ef_sc_hd__decap_12
XFILLER_112_309 VPWR VGND VPWR VGND sky130_ef_sc_hd__decap_12
XFILLER_105_361 VGND VGND VPWR VPWR sky130_fd_sc_hd__decap_6
XFILLER_105_383 VGND VGND VPWR VPWR sky130_fd_sc_hd__decap_8
XFILLER_78_234 VPWR VGND VPWR VGND sky130_ef_sc_hd__decap_12
Xfanout280 net281 VGND VGND VPWR VPWR net280 sky130_fd_sc_hd__buf_8
XTAP_TAPCELL_ROW_70_1091 VGND VPWR sky130_fd_sc_hd__tapvpwrvgnd_1
Xfanout291 pe_array\[3\].u_pe.weight_in\[5\] VGND VGND VPWR VPWR net291 sky130_fd_sc_hd__buf_2
XFILLER_19_323 VPWR VGND VPWR VGND sky130_ef_sc_hd__decap_12
XFILLER_75_73 VGND VGND VPWR VPWR sky130_fd_sc_hd__decap_3
XTAP_TAPCELL_ROW_109_1566 VGND VPWR sky130_fd_sc_hd__tapvpwrvgnd_1
XFILLER_62_624 VPWR VGND VPWR VGND sky130_ef_sc_hd__decap_12
XFILLER_46_197 VGND VGND VPWR VPWR sky130_fd_sc_hd__decap_6
XFILLER_15_573 VGND VGND VPWR VPWR sky130_fd_sc_hd__decap_3
XFILLER_15_595 VGND VGND VPWR VPWR sky130_fd_sc_hd__decap_8
XFILLER_42_381 VGND VGND VPWR VPWR sky130_fd_sc_hd__fill_1
X_4570_ _4332_ _4333_ net302 net484 VGND VGND VPWR VPWR _4334_ sky130_fd_sc_hd__and4bb_1
XFILLER_116_637 VGND VGND VPWR VPWR sky130_fd_sc_hd__decap_6
X_6240_ _1765_ _1766_ _1767_ VGND VGND VPWR VPWR _1769_ sky130_fd_sc_hd__a21oi_1
XFILLER_115_169 VGND VGND VPWR VPWR sky130_fd_sc_hd__decap_4
X_6171_ _1699_ _1700_ _1701_ VGND VGND VPWR VPWR _1702_ sky130_fd_sc_hd__nand3_1
XFILLER_111_320 VPWR VGND VPWR VGND sky130_ef_sc_hd__decap_12
XFILLER_69_223 VGND VGND VPWR VPWR sky130_fd_sc_hd__fill_1
X_5122_ _0860_ _0861_ VGND VGND VPWR VPWR _0862_ sky130_fd_sc_hd__and2b_1
XFILLER_97_554 VGND VGND VPWR VPWR sky130_fd_sc_hd__decap_6
XFILLER_69_256 VPWR VGND VPWR VGND sky130_ef_sc_hd__decap_12
X_5053_ _0792_ _0793_ net744 VGND VGND VPWR VPWR _0795_ sky130_fd_sc_hd__a21o_1
XFILLER_38_643 VGND VGND VPWR VPWR sky130_fd_sc_hd__fill_1
X_8812_ pe_array\[2\].u_pe.accum_reg\[30\] _3509_ _4181_ VGND VGND VPWR VPWR _4182_
+ sky130_fd_sc_hd__a21oi_1
XFILLER_1_81 VPWR VGND VPWR VGND sky130_ef_sc_hd__decap_12
XFILLER_111_27 VPWR VGND VPWR VGND sky130_ef_sc_hd__decap_12
XFILLER_80_421 VGND VGND VPWR VPWR sky130_fd_sc_hd__decap_4
XFILLER_25_326 VGND VGND VPWR VPWR sky130_fd_sc_hd__decap_3
X_8743_ net159 _4081_ _4080_ VGND VGND VPWR VPWR _4116_ sky130_fd_sc_hd__a21oi_1
X_5955_ _1437_ _1446_ _1445_ VGND VGND VPWR VPWR _1491_ sky130_fd_sc_hd__a21bo_1
X_8674_ net176 _4047_ VGND VGND VPWR VPWR _4049_ sky130_fd_sc_hd__xnor2_1
X_5886_ _1352_ _1389_ _1390_ VGND VGND VPWR VPWR _1423_ sky130_fd_sc_hd__o21ba_1
XTAP_TAPCELL_ROW_23_527 VGND VPWR sky130_fd_sc_hd__tapvpwrvgnd_1
X_4906_ _0644_ _0651_ VGND VGND VPWR VPWR _0652_ sky130_fd_sc_hd__xor2_1
XTAP_TAPCELL_ROW_51_869 VGND VPWR sky130_fd_sc_hd__tapvpwrvgnd_1
X_7625_ _3035_ _3064_ _3037_ VGND VGND VPWR VPWR _3074_ sky130_fd_sc_hd__o21ai_1
X_4837_ _0532_ _0535_ _0582_ _0584_ VGND VGND VPWR VPWR _0585_ sky130_fd_sc_hd__a211oi_4
XFILLER_21_587 VPWR VGND VPWR VGND sky130_ef_sc_hd__decap_12
X_7556_ net156 _3007_ VGND VGND VPWR VPWR _3008_ sky130_fd_sc_hd__xnor2_1
X_4768_ _0507_ _0515_ VGND VGND VPWR VPWR _0517_ sky130_fd_sc_hd__xnor2_1
X_6507_ _2024_ _2025_ VGND VGND VPWR VPWR _2027_ sky130_fd_sc_hd__xnor2_1
XFILLER_4_219 VGND VGND VPWR VPWR sky130_fd_sc_hd__fill_1
X_7487_ net196 _2910_ _2909_ VGND VGND VPWR VPWR _2941_ sky130_fd_sc_hd__a21boi_1
X_4699_ _4403_ _4410_ _4409_ VGND VGND VPWR VPWR _0450_ sky130_fd_sc_hd__a21bo_1
X_6438_ net198 _1959_ VGND VGND VPWR VPWR _1960_ sky130_fd_sc_hd__xnor2_1
X_9226_ clknet_leaf_44_clk _0338_ VGND VGND VPWR VPWR pe_accum\[1\]\[12\] sky130_fd_sc_hd__dfxtp_1
XTAP_TAPCELL_ROW_95_1389 VGND VPWR sky130_fd_sc_hd__tapvpwrvgnd_1
X_9157_ clknet_leaf_28_clk _0269_ VGND VGND VPWR VPWR pe_accum\[0\]\[11\] sky130_fd_sc_hd__dfxtp_1
X_6369_ _1836_ _1839_ _1867_ VGND VGND VPWR VPWR _1894_ sky130_fd_sc_hd__nand3_2
X_8108_ _3495_ _3498_ VGND VGND VPWR VPWR _3499_ sky130_fd_sc_hd__xnor2_1
X_9088_ clknet_leaf_64_clk _0200_ VGND VGND VPWR VPWR net38 sky130_fd_sc_hd__dfxtp_1
X_8039_ _3429_ _3430_ _3423_ VGND VGND VPWR VPWR _3432_ sky130_fd_sc_hd__a21o_1
XFILLER_29_55 VGND VGND VPWR VPWR sky130_fd_sc_hd__fill_1
XTAP_TAPCELL_ROW_59_958 VGND VPWR sky130_fd_sc_hd__tapvpwrvgnd_1
XFILLER_28_131 VGND VGND VPWR VPWR sky130_fd_sc_hd__fill_2
XPHY_EDGE_ROW_11_Left_129 VGND VGND VPWR VPWR sky130_fd_sc_hd__decap_3
XTAP_TAPCELL_ROW_3_285 VGND VPWR sky130_fd_sc_hd__tapvpwrvgnd_1
XFILLER_44_624 VGND VGND VPWR VPWR sky130_fd_sc_hd__decap_3
XFILLER_83_281 VGND VGND VPWR VPWR sky130_fd_sc_hd__fill_2
XFILLER_28_197 VGND VGND VPWR VPWR sky130_fd_sc_hd__decap_8
XFILLER_71_476 VGND VGND VPWR VPWR sky130_fd_sc_hd__fill_1
XFILLER_43_167 VGND VGND VPWR VPWR sky130_fd_sc_hd__fill_1
XFILLER_31_318 VPWR VGND VPWR VGND sky130_ef_sc_hd__decap_12
XTAP_TAPCELL_ROW_104_1496 VGND VPWR sky130_fd_sc_hd__tapvpwrvgnd_1
XFILLER_61_31 VPWR VGND VPWR VGND sky130_ef_sc_hd__decap_12
XFILLER_8_569 VPWR VGND VPWR VGND sky130_ef_sc_hd__decap_12
XFILLER_6_15 VPWR VGND VPWR VGND sky130_ef_sc_hd__decap_12
XANTENNA_8 net389 VGND VGND VPWR VPWR sky130_fd_sc_hd__diode_2
XPHY_EDGE_ROW_20_Left_138 VGND VGND VPWR VPWR sky130_fd_sc_hd__decap_3
XFILLER_113_629 VPWR VGND VPWR VGND sky130_ef_sc_hd__decap_12
XFILLER_112_139 VGND VGND VPWR VPWR sky130_fd_sc_hd__fill_1
XFILLER_106_681 VGND VGND VPWR VPWR sky130_fd_sc_hd__decap_3
XTAP_TAPCELL_ROW_72_1120 VGND VPWR sky130_fd_sc_hd__tapvpwrvgnd_1
XFILLER_86_61 VGND VGND VPWR VPWR sky130_fd_sc_hd__decap_4
XFILLER_39_418 VPWR VGND VPWR VGND sky130_ef_sc_hd__decap_12
XFILLER_81_207 VGND VGND VPWR VPWR sky130_fd_sc_hd__fill_1
XFILLER_47_473 VGND VGND VPWR VPWR sky130_fd_sc_hd__decap_8
XFILLER_74_281 VGND VGND VPWR VPWR sky130_fd_sc_hd__decap_8
XFILLER_62_432 VGND VGND VPWR VPWR sky130_fd_sc_hd__decap_3
XFILLER_34_101 VGND VGND VPWR VPWR sky130_fd_sc_hd__decap_3
XFILLER_34_112 VGND VGND VPWR VPWR sky130_fd_sc_hd__fill_2
XFILLER_34_145 VGND VGND VPWR VPWR sky130_fd_sc_hd__fill_1
XFILLER_96_3 VGND VGND VPWR VPWR sky130_fd_sc_hd__decap_4
X_5740_ _1280_ _1281_ VGND VGND VPWR VPWR _1282_ sky130_fd_sc_hd__and2_1
XFILLER_34_178 VGND VGND VPWR VPWR sky130_fd_sc_hd__fill_1
X_5671_ net952 net368 VGND VGND VPWR VPWR _0212_ sky130_fd_sc_hd__and2_1
X_7410_ _2866_ net156 VGND VGND VPWR VPWR _2867_ sky130_fd_sc_hd__xnor2_2
XFILLER_30_373 VPWR VGND VPWR VGND sky130_ef_sc_hd__decap_12
X_8390_ _3770_ _3771_ net684 VGND VGND VPWR VPWR _3774_ sky130_fd_sc_hd__o21ai_1
X_4622_ _4384_ _4383_ VGND VGND VPWR VPWR _4385_ sky130_fd_sc_hd__nand2_4
X_7341_ _2797_ _2796_ _2767_ _2769_ VGND VGND VPWR VPWR _2800_ sky130_fd_sc_hd__a211o_1
X_4553_ _4316_ _4317_ VGND VGND VPWR VPWR _4318_ sky130_fd_sc_hd__and2b_1
Xhold514 pe_array\[0\].u_pe.tap_count\[2\] VGND VGND VPWR VPWR net1029 sky130_fd_sc_hd__dlygate4sd3_1
X_7272_ net266 _2731_ _2732_ VGND VGND VPWR VPWR _2733_ sky130_fd_sc_hd__nor3_1
Xhold503 pe_array\[3\].u_pe.tap_count\[3\] VGND VGND VPWR VPWR net1018 sky130_fd_sc_hd__dlygate4sd3_1
X_4484_ _4251_ _4252_ VGND VGND VPWR VPWR _4253_ sky130_fd_sc_hd__or2_1
X_6223_ pe_array\[0\].u_pe.accum_reg\[16\] net457 net360 VGND VGND VPWR VPWR _1752_
+ sky130_fd_sc_hd__and3_1
X_9011_ clknet_leaf_40_clk _0123_ VGND VGND VPWR VPWR net80 sky130_fd_sc_hd__dfxtp_1
XFILLER_106_27 VGND VGND VPWR VPWR sky130_fd_sc_hd__fill_1
XFILLER_103_117 VGND VGND VPWR VPWR sky130_fd_sc_hd__fill_1
X_6154_ _1600_ net177 _1644_ VGND VGND VPWR VPWR _1685_ sky130_fd_sc_hd__mux2_1
X_6085_ net199 _1615_ _1617_ VGND VGND VPWR VPWR _1618_ sky130_fd_sc_hd__or3b_4
XFILLER_57_204 VPWR VGND VPWR VGND sky130_ef_sc_hd__decap_12
X_5105_ net295 net433 pe_array\[3\].u_pe.accum_reg\[19\] VGND VGND VPWR VPWR _0845_
+ sky130_fd_sc_hd__a21oi_1
X_5036_ _0714_ _0713_ _0746_ _0778_ net692 VGND VGND VPWR VPWR _0779_ sky130_fd_sc_hd__a311oi_4
XTAP_TAPCELL_ROW_56_928 VGND VPWR sky130_fd_sc_hd__tapvpwrvgnd_1
XFILLER_82_19 VGND VGND VPWR VPWR sky130_fd_sc_hd__decap_8
XFILLER_65_281 VGND VGND VPWR VPWR sky130_fd_sc_hd__fill_1
XFILLER_65_270 VGND VGND VPWR VPWR sky130_fd_sc_hd__decap_8
XTAP_TAPCELL_ROW_0_244 VGND VPWR sky130_fd_sc_hd__tapvpwrvgnd_1
XFILLER_26_624 VGND VGND VPWR VPWR sky130_fd_sc_hd__decap_4
XFILLER_80_251 VGND VGND VPWR VPWR sky130_fd_sc_hd__fill_1
XFILLER_53_443 VGND VGND VPWR VPWR sky130_fd_sc_hd__fill_1
XTAP_TAPCELL_ROW_0_255 VGND VPWR sky130_fd_sc_hd__tapvpwrvgnd_1
XFILLER_25_167 VGND VGND VPWR VPWR sky130_fd_sc_hd__fill_1
X_6987_ net452 net334 net333 VGND VGND VPWR VPWR _2455_ sky130_fd_sc_hd__and3_4
X_8726_ _4096_ _4097_ net264 VGND VGND VPWR VPWR _4099_ sky130_fd_sc_hd__o21a_1
X_5938_ _1467_ _1472_ VGND VGND VPWR VPWR _1474_ sky130_fd_sc_hd__xnor2_1
XTAP_TAPCELL_ROW_36_685 VGND VPWR sky130_fd_sc_hd__tapvpwrvgnd_1
XFILLER_40_115 VGND VGND VPWR VPWR sky130_fd_sc_hd__decap_3
X_8657_ _4003_ _4031_ VGND VGND VPWR VPWR _4033_ sky130_fd_sc_hd__xnor2_1
X_5869_ _1350_ _1368_ _1367_ VGND VGND VPWR VPWR _1407_ sky130_fd_sc_hd__a21boi_1
X_8588_ _3963_ _3964_ net159 VGND VGND VPWR VPWR _3966_ sky130_fd_sc_hd__a21o_1
XTAP_TAPCELL_ROW_97_1418 VGND VPWR sky130_fd_sc_hd__tapvpwrvgnd_1
X_7608_ _2700_ _3028_ _3027_ VGND VGND VPWR VPWR _3058_ sky130_fd_sc_hd__a21oi_1
X_7539_ net425 _2991_ VGND VGND VPWR VPWR _0318_ sky130_fd_sc_hd__nor2_1
XFILLER_31_67 VGND VGND VPWR VPWR sky130_fd_sc_hd__decap_4
Xoutput23 net23 VGND VGND VPWR VPWR result_data[100] sky130_fd_sc_hd__buf_2
Xoutput34 net34 VGND VGND VPWR VPWR result_data[110] sky130_fd_sc_hd__buf_2
X_9209_ clknet_3_3__leaf_clk _0321_ VGND VGND VPWR VPWR pe_array\[1\].u_pe.accum_reg\[27\]
+ sky130_fd_sc_hd__dfxtp_1
Xoutput67 net67 VGND VGND VPWR VPWR result_data[25] sky130_fd_sc_hd__buf_2
Xoutput56 net56 VGND VGND VPWR VPWR result_data[15] sky130_fd_sc_hd__buf_2
XTAP_TAPCELL_ROW_8_344 VGND VPWR sky130_fd_sc_hd__tapvpwrvgnd_1
Xoutput45 net45 VGND VGND VPWR VPWR result_data[120] sky130_fd_sc_hd__buf_2
Xoutput78 net78 VGND VGND VPWR VPWR result_data[35] sky130_fd_sc_hd__buf_2
XTAP_TAPCELL_ROW_8_355 VGND VPWR sky130_fd_sc_hd__tapvpwrvgnd_1
Xoutput89 net89 VGND VGND VPWR VPWR result_data[45] sky130_fd_sc_hd__buf_2
XFILLER_88_384 VGND VGND VPWR VPWR sky130_fd_sc_hd__fill_1
XFILLER_102_183 VGND VGND VPWR VPWR sky130_fd_sc_hd__decap_8
XFILLER_48_248 VGND VGND VPWR VPWR sky130_fd_sc_hd__decap_4
XFILLER_91_505 VGND VGND VPWR VPWR sky130_fd_sc_hd__fill_1
XFILLER_63_207 VGND VGND VPWR VPWR sky130_fd_sc_hd__decap_3
XFILLER_56_53 VPWR VGND VPWR VGND sky130_ef_sc_hd__decap_12
XTAP_TAPCELL_ROW_106_1525 VGND VPWR sky130_fd_sc_hd__tapvpwrvgnd_1
XFILLER_56_292 VGND VGND VPWR VPWR sky130_fd_sc_hd__decap_4
XFILLER_56_281 VGND VGND VPWR VPWR sky130_fd_sc_hd__decap_6
XFILLER_56_97 VPWR VGND VPWR VGND sky130_ef_sc_hd__decap_12
XFILLER_17_624 VGND VGND VPWR VPWR sky130_fd_sc_hd__decap_8
XPHY_EDGE_ROW_113_Right_113 VGND VGND VPWR VPWR sky130_fd_sc_hd__decap_3
XFILLER_17_668 VGND VGND VPWR VPWR sky130_fd_sc_hd__decap_4
XFILLER_71_273 VGND VGND VPWR VPWR sky130_fd_sc_hd__decap_4
XFILLER_31_104 VGND VGND VPWR VPWR sky130_fd_sc_hd__decap_8
XTAP_TAPCELL_ROW_117_1665 VGND VPWR sky130_fd_sc_hd__tapvpwrvgnd_1
XTAP_TAPCELL_ROW_117_1654 VGND VPWR sky130_fd_sc_hd__tapvpwrvgnd_1
XFILLER_79_384 VGND VGND VPWR VPWR sky130_fd_sc_hd__decap_4
XFILLER_67_513 VGND VGND VPWR VPWR sky130_fd_sc_hd__fill_2
XFILLER_39_204 VGND VGND VPWR VPWR sky130_fd_sc_hd__decap_4
XFILLER_39_215 VGND VGND VPWR VPWR sky130_fd_sc_hd__fill_2
XFILLER_11_3 VPWR VGND VPWR VGND sky130_ef_sc_hd__decap_12
XFILLER_94_365 VGND VGND VPWR VPWR sky130_fd_sc_hd__decap_8
X_7890_ _3261_ _3286_ VGND VGND VPWR VPWR _3287_ sky130_fd_sc_hd__xnor2_1
XFILLER_94_398 VGND VGND VPWR VPWR sky130_fd_sc_hd__fill_1
XFILLER_35_410 VGND VGND VPWR VPWR sky130_fd_sc_hd__fill_1
XFILLER_47_281 VGND VGND VPWR VPWR sky130_fd_sc_hd__decap_6
XFILLER_47_292 VPWR VGND VPWR VGND sky130_ef_sc_hd__decap_12
X_6910_ _2378_ _2362_ VGND VGND VPWR VPWR _2380_ sky130_fd_sc_hd__xor2_2
X_6841_ _2253_ _2277_ _2278_ _2310_ VGND VGND VPWR VPWR _2313_ sky130_fd_sc_hd__and4_1
XFILLER_90_593 VGND VGND VPWR VPWR sky130_fd_sc_hd__decap_3
XFILLER_35_487 VGND VGND VPWR VPWR sky130_fd_sc_hd__decap_4
X_8511_ net262 _3889_ net600 VGND VGND VPWR VPWR _3891_ sky130_fd_sc_hd__nor3_2
X_6772_ net591 net335 net333 net511 VGND VGND VPWR VPWR _2246_ sky130_fd_sc_hd__a22oi_1
XFILLER_50_457 VPWR VGND VPWR VGND sky130_ef_sc_hd__decap_12
XTAP_TAPCELL_ROW_33_644 VGND VPWR sky130_fd_sc_hd__tapvpwrvgnd_1
XTAP_TAPCELL_ROW_33_655 VGND VPWR sky130_fd_sc_hd__tapvpwrvgnd_1
X_5723_ _1264_ _1265_ VGND VGND VPWR VPWR _1266_ sky130_fd_sc_hd__or2_1
XTAP_TAPCELL_ROW_61_986 VGND VPWR sky130_fd_sc_hd__tapvpwrvgnd_1
X_8442_ _3823_ _3824_ VGND VGND VPWR VPWR _3825_ sky130_fd_sc_hd__xnor2_4
X_5654_ net992 net364 VGND VGND VPWR VPWR _0195_ sky130_fd_sc_hd__and2_1
XFILLER_108_209 VGND VGND VPWR VPWR sky130_fd_sc_hd__decap_4
X_8373_ _3724_ _3756_ VGND VGND VPWR VPWR _3758_ sky130_fd_sc_hd__xnor2_1
X_4605_ net484 net299 pe_array\[3\].u_pe.accum_reg\[6\] VGND VGND VPWR VPWR _4368_
+ sky130_fd_sc_hd__and3_1
X_7324_ _2780_ _2781_ _2782_ VGND VGND VPWR VPWR _2784_ sky130_fd_sc_hd__a21o_1
X_5585_ net972 net377 VGND VGND VPWR VPWR _0126_ sky130_fd_sc_hd__and2_1
XFILLER_117_15 VPWR VGND VPWR VGND sky130_ef_sc_hd__decap_12
XFILLER_116_253 VPWR VGND VPWR VGND sky130_ef_sc_hd__decap_12
XFILLER_89_104 VGND VGND VPWR VPWR sky130_fd_sc_hd__fill_1
X_4536_ net510 net294 VGND VGND VPWR VPWR _4301_ sky130_fd_sc_hd__nand2_1
XTAP_TAPCELL_ROW_92_1359 VGND VPWR sky130_fd_sc_hd__tapvpwrvgnd_1
Xhold377 pe_accum\[0\]\[10\] VGND VGND VPWR VPWR net892 sky130_fd_sc_hd__dlygate4sd3_1
X_4467_ net19 _4240_ _4241_ net344 VGND VGND VPWR VPWR _0006_ sky130_fd_sc_hd__a22o_1
X_7255_ _2666_ _2679_ _2678_ VGND VGND VPWR VPWR _2717_ sky130_fd_sc_hd__a21bo_1
Xhold399 pe_accum\[0\]\[20\] VGND VGND VPWR VPWR net914 sky130_fd_sc_hd__dlygate4sd3_1
X_6206_ _1732_ _1733_ _1734_ VGND VGND VPWR VPWR _1736_ sky130_fd_sc_hd__a21o_1
XFILLER_77_19 VGND VGND VPWR VPWR sky130_fd_sc_hd__fill_1
Xhold388 pe_accum\[1\]\[1\] VGND VGND VPWR VPWR net903 sky130_fd_sc_hd__dlygate4sd3_1
X_7186_ _2605_ _2603_ _2648_ _2649_ VGND VGND VPWR VPWR _2650_ sky130_fd_sc_hd__a211o_1
XFILLER_112_470 VGND VGND VPWR VPWR sky130_fd_sc_hd__decap_6
XFILLER_98_693 VGND VGND VPWR VPWR sky130_fd_sc_hd__decap_6
X_6137_ _1666_ _1667_ _1627_ _1629_ VGND VGND VPWR VPWR _1669_ sky130_fd_sc_hd__o211ai_1
XFILLER_58_513 VGND VGND VPWR VPWR sky130_fd_sc_hd__fill_1
XTAP_TAPCELL_ROW_5_314 VGND VPWR sky130_fd_sc_hd__tapvpwrvgnd_1
XFILLER_97_181 VGND VGND VPWR VPWR sky130_fd_sc_hd__decap_8
XFILLER_100_665 VGND VGND VPWR VPWR sky130_fd_sc_hd__fill_1
X_6068_ net455 net347 net345 net466 VGND VGND VPWR VPWR _1601_ sky130_fd_sc_hd__a22oi_1
XFILLER_73_505 VPWR VGND VPWR VGND sky130_ef_sc_hd__decap_12
XFILLER_73_538 VPWR VGND VPWR VGND sky130_ef_sc_hd__decap_12
XFILLER_26_421 VPWR VGND VPWR VGND sky130_ef_sc_hd__decap_12
X_5019_ _0758_ _0759_ _0760_ VGND VGND VPWR VPWR _0762_ sky130_fd_sc_hd__a21oi_1
XFILLER_41_457 VGND VGND VPWR VPWR sky130_fd_sc_hd__decap_8
X_8709_ _4063_ _4082_ VGND VGND VPWR VPWR _4083_ sky130_fd_sc_hd__and2b_1
XTAP_TAPCELL_ROW_101_1466 VGND VPWR sky130_fd_sc_hd__tapvpwrvgnd_1
XFILLER_22_682 VGND VGND VPWR VPWR sky130_fd_sc_hd__fill_2
XFILLER_42_77 VGND VGND VPWR VPWR sky130_fd_sc_hd__decap_6
XFILLER_21_192 VGND VGND VPWR VPWR sky130_fd_sc_hd__decap_4
XFILLER_1_553 VGND VGND VPWR VPWR sky130_fd_sc_hd__decap_6
XFILLER_3_27 VPWR VGND VPWR VGND sky130_ef_sc_hd__decap_12
XTAP_TAPCELL_ROW_112_1595 VGND VPWR sky130_fd_sc_hd__tapvpwrvgnd_1
XFILLER_110_429 VGND VGND VPWR VPWR sky130_fd_sc_hd__fill_1
XFILLER_110_407 VGND VGND VPWR VPWR sky130_fd_sc_hd__fill_1
XFILLER_107_81 VGND VGND VPWR VPWR sky130_fd_sc_hd__decap_8
XFILLER_67_41 VGND VGND VPWR VPWR sky130_fd_sc_hd__fill_2
XFILLER_1_597 VPWR VGND VPWR VGND sky130_ef_sc_hd__decap_12
XFILLER_76_365 VGND VGND VPWR VPWR sky130_fd_sc_hd__decap_8
XFILLER_29_281 VGND VGND VPWR VPWR sky130_fd_sc_hd__decap_8
XPHY_EDGE_ROW_103_Left_221 VGND VGND VPWR VPWR sky130_fd_sc_hd__decap_3
XTAP_TAPCELL_ROW_67_1052 VGND VPWR sky130_fd_sc_hd__tapvpwrvgnd_1
XTAP_TAPCELL_ROW_67_1063 VGND VPWR sky130_fd_sc_hd__tapvpwrvgnd_1
XFILLER_32_413 VGND VGND VPWR VPWR sky130_fd_sc_hd__decap_6
XFILLER_44_262 VGND VGND VPWR VPWR sky130_fd_sc_hd__fill_2
XTAP_TAPCELL_ROW_30_614 VGND VPWR sky130_fd_sc_hd__tapvpwrvgnd_1
XFILLER_8_141 VGND VGND VPWR VPWR sky130_fd_sc_hd__fill_1
XPHY_EDGE_ROW_112_Left_230 VGND VGND VPWR VPWR sky130_fd_sc_hd__decap_3
XFILLER_9_697 VGND VGND VPWR VPWR sky130_fd_sc_hd__decap_3
XTAP_TAPCELL_ROW_10_371 VGND VPWR sky130_fd_sc_hd__tapvpwrvgnd_1
X_5370_ _1099_ _1100_ VGND VGND VPWR VPWR _1101_ sky130_fd_sc_hd__nor2_1
XTAP_TAPCELL_ROW_78_1192 VGND VPWR sky130_fd_sc_hd__tapvpwrvgnd_1
X_7040_ _2503_ _2504_ net551 VGND VGND VPWR VPWR _2507_ sky130_fd_sc_hd__o21ai_1
XFILLER_113_278 VGND VGND VPWR VPWR sky130_fd_sc_hd__fill_2
X_8991_ clknet_leaf_27_clk _0103_ VGND VGND VPWR VPWR net58 sky130_fd_sc_hd__dfxtp_1
XFILLER_55_505 VPWR VGND VPWR VGND sky130_ef_sc_hd__decap_12
XFILLER_103_39 VPWR VGND VPWR VGND sky130_ef_sc_hd__decap_12
X_7942_ _3335_ _3336_ VGND VGND VPWR VPWR _3337_ sky130_fd_sc_hd__and2b_1
XTAP_TAPCELL_ROW_38_714 VGND VPWR sky130_fd_sc_hd__tapvpwrvgnd_1
X_7873_ _3246_ _3247_ _3268_ _3269_ VGND VGND VPWR VPWR _3270_ sky130_fd_sc_hd__o211ai_1
XFILLER_35_273 VGND VGND VPWR VPWR sky130_fd_sc_hd__decap_6
X_6824_ _2292_ _2293_ net481 net336 VGND VGND VPWR VPWR _2296_ sky130_fd_sc_hd__a2bb2o_1
XTAP_TAPCELL_ROW_18_471 VGND VPWR sky130_fd_sc_hd__tapvpwrvgnd_1
X_6755_ _2227_ _2228_ VGND VGND VPWR VPWR _2230_ sky130_fd_sc_hd__xnor2_1
XFILLER_50_243 VGND VGND VPWR VPWR sky130_fd_sc_hd__fill_1
X_5706_ _1241_ _1249_ VGND VGND VPWR VPWR _1250_ sky130_fd_sc_hd__nand2_1
X_6686_ net238 _2199_ _2198_ _4226_ net508 VGND VGND VPWR VPWR _2200_ sky130_fd_sc_hd__o32a_1
X_8425_ net189 _3777_ _3775_ VGND VGND VPWR VPWR _3808_ sky130_fd_sc_hd__a21o_1
Xclkbuf_leaf_30_clk clknet_3_6__leaf_clk VGND VGND VPWR VPWR clknet_leaf_30_clk sky130_fd_sc_hd__clkbuf_8
X_5637_ net928 net385 VGND VGND VPWR VPWR _0178_ sky130_fd_sc_hd__and2_1
X_5568_ net926 net395 VGND VGND VPWR VPWR _0109_ sky130_fd_sc_hd__and2_1
X_8356_ _3738_ _3739_ net189 VGND VGND VPWR VPWR _3741_ sky130_fd_sc_hd__a21o_1
XFILLER_117_573 VPWR VGND VPWR VGND sky130_ef_sc_hd__decap_12
X_8287_ net259 _3671_ _3672_ VGND VGND VPWR VPWR _3674_ sky130_fd_sc_hd__or3_4
X_7307_ pe_array\[1\].u_pe.accum_reg\[17\] net446 net338 VGND VGND VPWR VPWR _2767_
+ sky130_fd_sc_hd__and3_1
X_4519_ net306 net305 net492 net484 VGND VGND VPWR VPWR _4285_ sky130_fd_sc_hd__and4_1
XFILLER_104_234 VGND VGND VPWR VPWR sky130_fd_sc_hd__fill_2
X_7238_ _2663_ _2664_ VGND VGND VPWR VPWR _2700_ sky130_fd_sc_hd__nor2_4
X_5499_ _0784_ net249 VGND VGND VPWR VPWR _1210_ sky130_fd_sc_hd__nand2_1
X_7169_ net268 _2631_ _2632_ VGND VGND VPWR VPWR _2633_ sky130_fd_sc_hd__nor3_1
XFILLER_58_365 VGND VGND VPWR VPWR sky130_fd_sc_hd__decap_3
XFILLER_85_184 VGND VGND VPWR VPWR sky130_fd_sc_hd__fill_2
XFILLER_73_335 VGND VGND VPWR VPWR sky130_fd_sc_hd__fill_1
XFILLER_54_582 VGND VGND VPWR VPWR sky130_fd_sc_hd__decap_6
XFILLER_14_413 VGND VGND VPWR VPWR sky130_fd_sc_hd__decap_6
XFILLER_14_457 VPWR VGND VPWR VGND sky130_ef_sc_hd__decap_12
Xclkbuf_leaf_21_clk clknet_3_5__leaf_clk VGND VGND VPWR VPWR clknet_leaf_21_clk sky130_fd_sc_hd__clkbuf_8
XFILLER_10_641 VGND VGND VPWR VPWR sky130_fd_sc_hd__decap_3
XFILLER_22_490 VGND VGND VPWR VPWR sky130_fd_sc_hd__decap_4
XFILLER_10_696 VGND VGND VPWR VPWR sky130_fd_sc_hd__decap_4
XFILLER_6_645 VPWR VGND VPWR VGND sky130_ef_sc_hd__decap_12
XFILLER_108_540 VGND VGND VPWR VPWR sky130_fd_sc_hd__decap_4
XTAP_TAPCELL_ROW_114_1624 VGND VPWR sky130_fd_sc_hd__tapvpwrvgnd_1
XFILLER_108_584 VGND VGND VPWR VPWR sky130_fd_sc_hd__decap_4
XFILLER_108_573 VGND VGND VPWR VPWR sky130_fd_sc_hd__decap_4
XFILLER_110_248 VGND VGND VPWR VPWR sky130_fd_sc_hd__decap_4
XFILLER_110_226 VGND VGND VPWR VPWR sky130_fd_sc_hd__fill_2
XFILLER_77_641 VPWR VGND VPWR VGND sky130_ef_sc_hd__decap_12
XFILLER_77_685 VPWR VGND VPWR VGND sky130_ef_sc_hd__decap_12
XFILLER_76_195 VGND VGND VPWR VPWR sky130_fd_sc_hd__fill_1
XFILLER_91_187 VGND VGND VPWR VPWR sky130_fd_sc_hd__fill_2
X_4870_ _0613_ _0614_ _0570_ _0571_ VGND VGND VPWR VPWR _0617_ sky130_fd_sc_hd__a211o_1
XFILLER_32_210 VGND VGND VPWR VPWR sky130_fd_sc_hd__decap_8
XTAP_TAPCELL_ROW_15_430 VGND VPWR sky130_fd_sc_hd__tapvpwrvgnd_1
XFILLER_32_243 VGND VGND VPWR VPWR sky130_fd_sc_hd__fill_2
X_6540_ _2031_ _2058_ VGND VGND VPWR VPWR _2059_ sky130_fd_sc_hd__nor2_1
XTAP_TAPCELL_ROW_43_772 VGND VPWR sky130_fd_sc_hd__tapvpwrvgnd_1
Xclkbuf_leaf_12_clk clknet_3_5__leaf_clk VGND VGND VPWR VPWR clknet_leaf_12_clk sky130_fd_sc_hd__clkbuf_8
XFILLER_9_461 VPWR VGND VPWR VGND sky130_ef_sc_hd__decap_12
X_6471_ _1989_ _1990_ _1953_ _1954_ VGND VGND VPWR VPWR _1992_ sky130_fd_sc_hd__a211o_1
X_8210_ _3596_ _3595_ _3553_ _3555_ VGND VGND VPWR VPWR _3599_ sky130_fd_sc_hd__a211o_1
X_5422_ _1151_ VGND VGND VPWR VPWR _1152_ sky130_fd_sc_hd__inv_2
X_9190_ clknet_leaf_37_clk _0302_ VGND VGND VPWR VPWR pe_array\[1\].u_pe.accum_reg\[8\]
+ sky130_fd_sc_hd__dfxtp_1
X_8141_ _3485_ _3530_ VGND VGND VPWR VPWR _3532_ sky130_fd_sc_hd__xnor2_1
X_5353_ _1082_ _1083_ VGND VGND VPWR VPWR _1085_ sky130_fd_sc_hd__xnor2_1
XFILLER_114_576 VPWR VGND VPWR VGND sky130_ef_sc_hd__decap_12
XFILLER_87_405 VPWR VGND VPWR VGND sky130_ef_sc_hd__decap_12
X_8072_ net471 net559 _3463_ VGND VGND VPWR VPWR _3464_ sky130_fd_sc_hd__a21boi_1
XFILLER_59_107 VGND VGND VPWR VPWR sky130_fd_sc_hd__decap_4
X_5284_ _1015_ _1016_ _0987_ _0989_ VGND VGND VPWR VPWR _1018_ sky130_fd_sc_hd__a211oi_1
XFILLER_101_215 VGND VGND VPWR VPWR sky130_fd_sc_hd__fill_2
XFILLER_87_449 VGND VGND VPWR VPWR sky130_fd_sc_hd__decap_4
X_7023_ net472 net328 net326 net479 VGND VGND VPWR VPWR _2490_ sky130_fd_sc_hd__a22o_1
XFILLER_114_27 VGND VGND VPWR VPWR sky130_fd_sc_hd__fill_1
XFILLER_83_600 VPWR VGND VPWR VGND sky130_ef_sc_hd__decap_12
XFILLER_83_633 VPWR VGND VPWR VGND sky130_ef_sc_hd__decap_12
X_8974_ clknet_leaf_21_clk _0086_ VGND VGND VPWR VPWR net22 sky130_fd_sc_hd__dfxtp_1
X_7925_ _3317_ _3318_ _3320_ VGND VGND VPWR VPWR _3321_ sky130_fd_sc_hd__nand3b_1
XFILLER_70_305 VGND VGND VPWR VPWR sky130_fd_sc_hd__decap_3
X_7856_ net498 net485 net323 net325 VGND VGND VPWR VPWR _3254_ sky130_fd_sc_hd__and4_1
X_6807_ _2254_ _2279_ VGND VGND VPWR VPWR _2280_ sky130_fd_sc_hd__nor2_1
XFILLER_11_405 VPWR VGND VPWR VGND sky130_ef_sc_hd__decap_12
XFILLER_23_35 VGND VGND VPWR VPWR sky130_fd_sc_hd__decap_6
X_4999_ _0739_ _0738_ _0740_ VGND VGND VPWR VPWR _0743_ sky130_fd_sc_hd__a21o_1
X_7787_ net225 _3135_ VGND VGND VPWR VPWR _3203_ sky130_fd_sc_hd__nand2_1
X_6738_ net430 _2214_ VGND VGND VPWR VPWR _0294_ sky130_fd_sc_hd__nor2_1
XFILLER_11_449 VGND VGND VPWR VPWR sky130_fd_sc_hd__decap_6
XFILLER_23_68 VGND VGND VPWR VPWR sky130_fd_sc_hd__fill_1
XFILLER_109_337 VPWR VGND VPWR VGND sky130_ef_sc_hd__decap_12
X_6669_ _2125_ _2122_ _2156_ _2183_ _2155_ VGND VGND VPWR VPWR _2184_ sky130_fd_sc_hd__a311o_1
X_8408_ _3754_ _3791_ VGND VGND VPWR VPWR _3792_ sky130_fd_sc_hd__nor2_1
XFILLER_105_521 VGND VGND VPWR VPWR sky130_fd_sc_hd__fill_2
X_8339_ _3721_ _3722_ _3723_ VGND VGND VPWR VPWR _3725_ sky130_fd_sc_hd__o21ai_1
XFILLER_3_615 VGND VGND VPWR VPWR sky130_fd_sc_hd__fill_1
XFILLER_78_416 VGND VGND VPWR VPWR sky130_fd_sc_hd__decap_4
XFILLER_78_438 VGND VGND VPWR VPWR sky130_fd_sc_hd__decap_8
Xfanout440 net575 VGND VGND VPWR VPWR net440 sky130_fd_sc_hd__buf_6
XFILLER_59_641 VGND VGND VPWR VPWR sky130_fd_sc_hd__decap_8
Xfanout473 net474 VGND VGND VPWR VPWR net473 sky130_fd_sc_hd__buf_8
Xfanout462 net463 VGND VGND VPWR VPWR net462 sky130_fd_sc_hd__clkbuf_4
Xfanout451 net459 VGND VGND VPWR VPWR net451 sky130_fd_sc_hd__buf_8
XFILLER_19_505 VPWR VGND VPWR VGND sky130_ef_sc_hd__decap_12
Xfanout484 net486 VGND VGND VPWR VPWR net484 sky130_fd_sc_hd__buf_6
XFILLER_48_65 VPWR VGND VPWR VGND sky130_ef_sc_hd__decap_12
Xfanout495 net499 VGND VGND VPWR VPWR net495 sky130_fd_sc_hd__buf_2
XFILLER_59_696 VGND VGND VPWR VPWR sky130_fd_sc_hd__decap_4
XFILLER_58_173 VGND VGND VPWR VPWR sky130_fd_sc_hd__fill_2
XFILLER_46_335 VPWR VGND VPWR VGND sky130_ef_sc_hd__decap_12
XFILLER_64_53 VGND VGND VPWR VPWR sky130_fd_sc_hd__fill_2
XFILLER_46_368 VPWR VGND VPWR VGND sky130_ef_sc_hd__decap_12
XTAP_TAPCELL_ROW_64_1022 VGND VPWR sky130_fd_sc_hd__tapvpwrvgnd_1
XFILLER_54_390 VPWR VGND VPWR VGND sky130_ef_sc_hd__decap_12
XTAP_TAPCELL_ROW_29_599 VGND VPWR sky130_fd_sc_hd__tapvpwrvgnd_1
XFILLER_14_265 VPWR VGND VPWR VGND sky130_ef_sc_hd__decap_12
XFILLER_14_243 VGND VGND VPWR VPWR sky130_fd_sc_hd__decap_8
XFILLER_9_15 VPWR VGND VPWR VGND sky130_ef_sc_hd__decap_12
XTAP_TAPCELL_ROW_12_400 VGND VPWR sky130_fd_sc_hd__tapvpwrvgnd_1
XTAP_TAPCELL_ROW_40_731 VGND VPWR sky130_fd_sc_hd__tapvpwrvgnd_1
XFILLER_13_90 VGND VGND VPWR VPWR sky130_fd_sc_hd__fill_1
XFILLER_89_72 VGND VGND VPWR VPWR sky130_fd_sc_hd__decap_8
XTAP_TAPCELL_ROW_75_1151 VGND VPWR sky130_fd_sc_hd__tapvpwrvgnd_1
XFILLER_69_449 VGND VGND VPWR VPWR sky130_fd_sc_hd__decap_8
XFILLER_2_681 VPWR VGND VPWR VGND sky130_ef_sc_hd__decap_12
Xclkbuf_leaf_1_clk clknet_3_4__leaf_clk VGND VGND VPWR VPWR clknet_leaf_1_clk sky130_fd_sc_hd__clkbuf_8
XFILLER_37_324 VGND VGND VPWR VPWR sky130_fd_sc_hd__fill_2
XTAP_TAPCELL_ROW_48_831 VGND VPWR sky130_fd_sc_hd__tapvpwrvgnd_1
X_5971_ _1414_ _1415_ _1462_ _1461_ VGND VGND VPWR VPWR _1507_ sky130_fd_sc_hd__o31a_1
X_8690_ _4045_ _4046_ _4048_ VGND VGND VPWR VPWR _4064_ sky130_fd_sc_hd__o21a_1
XTAP_TAPCELL_ROW_86_1291 VGND VPWR sky130_fd_sc_hd__tapvpwrvgnd_1
XTAP_TAPCELL_ROW_86_1280 VGND VPWR sky130_fd_sc_hd__tapvpwrvgnd_1
XFILLER_80_669 VGND VGND VPWR VPWR sky130_fd_sc_hd__decap_6
X_4922_ _0621_ _0624_ _0666_ _0667_ VGND VGND VPWR VPWR _0668_ sky130_fd_sc_hd__a211oi_4
X_7710_ _3133_ _3134_ _3154_ _3131_ VGND VGND VPWR VPWR _3157_ sky130_fd_sc_hd__o211a_1
X_7641_ _2700_ _3088_ VGND VGND VPWR VPWR _3090_ sky130_fd_sc_hd__xnor2_1
XFILLER_100_29 VGND VGND VPWR VPWR sky130_fd_sc_hd__decap_6
X_4853_ net460 net289 net435 net291 VGND VGND VPWR VPWR _0600_ sky130_fd_sc_hd__a22o_1
XFILLER_33_585 VGND VGND VPWR VPWR sky130_fd_sc_hd__decap_3
X_4784_ _0530_ _0529_ _0531_ VGND VGND VPWR VPWR _0533_ sky130_fd_sc_hd__a21o_1
X_7572_ _3021_ _3022_ VGND VGND VPWR VPWR _3023_ sky130_fd_sc_hd__nand2_1
X_9311_ clknet_leaf_7_clk _0423_ VGND VGND VPWR VPWR pe_accum\[2\]\[21\] sky130_fd_sc_hd__dfxtp_1
X_6523_ _2040_ _2041_ VGND VGND VPWR VPWR _2042_ sky130_fd_sc_hd__nor2_1
XFILLER_109_27 VPWR VGND VPWR VGND sky130_ef_sc_hd__decap_12
X_6454_ net610 _1975_ VGND VGND VPWR VPWR _1976_ sky130_fd_sc_hd__xor2_1
X_9242_ clknet_leaf_41_clk _0354_ VGND VGND VPWR VPWR pe_accum\[1\]\[28\] sky130_fd_sc_hd__dfxtp_1
Xclkload50 clknet_leaf_32_clk VGND VGND VPWR VPWR clkload50/Y sky130_fd_sc_hd__clkinv_4
X_5405_ net743 _1134_ VGND VGND VPWR VPWR _1135_ sky130_fd_sc_hd__and2_1
X_9173_ clknet_leaf_22_clk _0285_ VGND VGND VPWR VPWR pe_accum\[0\]\[27\] sky130_fd_sc_hd__dfxtp_1
X_6385_ _1906_ _1907_ VGND VGND VPWR VPWR _1909_ sky130_fd_sc_hd__xnor2_1
XFILLER_102_502 VGND VGND VPWR VPWR sky130_fd_sc_hd__fill_2
X_8124_ _3467_ _3468_ _3513_ _3514_ VGND VGND VPWR VPWR _3515_ sky130_fd_sc_hd__o211ai_2
XFILLER_0_629 VPWR VGND VPWR VGND sky130_ef_sc_hd__decap_12
X_5336_ _1065_ _1066_ net288 VGND VGND VPWR VPWR _1068_ sky130_fd_sc_hd__o21a_1
X_8055_ _3404_ _3447_ VGND VGND VPWR VPWR _3448_ sky130_fd_sc_hd__xnor2_1
X_5267_ _0964_ _0966_ _1000_ VGND VGND VPWR VPWR _1002_ sky130_fd_sc_hd__nor3_1
XFILLER_87_246 VGND VGND VPWR VPWR sky130_fd_sc_hd__decap_4
X_7006_ _2470_ _2471_ _2454_ VGND VGND VPWR VPWR _2474_ sky130_fd_sc_hd__a21oi_1
XFILLER_68_460 VGND VGND VPWR VPWR sky130_fd_sc_hd__fill_2
X_5198_ net205 _0907_ _0906_ VGND VGND VPWR VPWR _0935_ sky130_fd_sc_hd__a21oi_1
XFILLER_18_35 VGND VGND VPWR VPWR sky130_fd_sc_hd__fill_1
XFILLER_95_290 VGND VGND VPWR VPWR sky130_fd_sc_hd__decap_3
XFILLER_18_46 VGND VGND VPWR VPWR sky130_fd_sc_hd__decap_4
XFILLER_56_699 VGND VGND VPWR VPWR sky130_fd_sc_hd__fill_1
X_8957_ clknet_leaf_61_clk _0069_ VGND VGND VPWR VPWR pe_accum\[3\]\[25\] sky130_fd_sc_hd__dfxtp_1
X_7908_ _3296_ _3297_ _3302_ VGND VGND VPWR VPWR _3304_ sky130_fd_sc_hd__a21o_1
XFILLER_70_157 VGND VGND VPWR VPWR sky130_fd_sc_hd__fill_1
X_8888_ clknet_leaf_36_clk _0000_ VGND VGND VPWR VPWR pe_array\[0\].u_pe.weight_in\[0\]
+ sky130_fd_sc_hd__dfxtp_1
XTAP_TAPCELL_ROW_26_569 VGND VPWR sky130_fd_sc_hd__tapvpwrvgnd_1
X_7839_ _3222_ _3224_ _3235_ _3237_ VGND VGND VPWR VPWR _3238_ sky130_fd_sc_hd__o211a_1
XFILLER_11_235 VGND VGND VPWR VPWR sky130_fd_sc_hd__decap_3
XFILLER_109_123 VPWR VGND VPWR VGND sky130_ef_sc_hd__decap_12
Xclkload0 clknet_3_0__leaf_clk VGND VGND VPWR VPWR clkload0/Y sky130_fd_sc_hd__clkinv_2
XFILLER_109_167 VGND VGND VPWR VPWR sky130_fd_sc_hd__fill_1
XFILLER_50_77 VGND VGND VPWR VPWR sky130_fd_sc_hd__decap_6
XFILLER_59_31 VPWR VGND VPWR VGND sky130_ef_sc_hd__decap_12
XFILLER_78_213 VGND VGND VPWR VPWR sky130_fd_sc_hd__decap_8
XFILLER_78_246 VGND VGND VPWR VPWR sky130_fd_sc_hd__decap_6
XFILLER_115_81 VPWR VGND VPWR VGND sky130_ef_sc_hd__decap_12
Xfanout281 _1438_ VGND VGND VPWR VPWR net281 sky130_fd_sc_hd__buf_8
XTAP_TAPCELL_ROW_70_1092 VGND VPWR sky130_fd_sc_hd__tapvpwrvgnd_1
Xfanout292 pe_array\[3\].u_pe.weight_in\[5\] VGND VGND VPWR VPWR net292 sky130_fd_sc_hd__clkbuf_2
Xfanout270 net273 VGND VGND VPWR VPWR net270 sky130_fd_sc_hd__buf_8
XFILLER_47_611 VGND VGND VPWR VPWR sky130_fd_sc_hd__decap_4
XFILLER_74_430 VGND VGND VPWR VPWR sky130_fd_sc_hd__fill_1
XFILLER_59_493 VGND VGND VPWR VPWR sky130_fd_sc_hd__decap_8
XFILLER_19_335 VGND VGND VPWR VPWR sky130_fd_sc_hd__fill_1
XTAP_TAPCELL_ROW_109_1567 VGND VPWR sky130_fd_sc_hd__tapvpwrvgnd_1
XTAP_TAPCELL_ROW_109_1556 VGND VPWR sky130_fd_sc_hd__tapvpwrvgnd_1
XFILLER_74_474 VGND VGND VPWR VPWR sky130_fd_sc_hd__fill_2
XFILLER_62_636 VGND VGND VPWR VPWR sky130_fd_sc_hd__decap_8
XFILLER_15_530 VGND VGND VPWR VPWR sky130_fd_sc_hd__fill_1
XFILLER_61_157 VGND VGND VPWR VPWR sky130_fd_sc_hd__decap_8
XFILLER_91_84 VGND VGND VPWR VPWR sky130_fd_sc_hd__decap_4
XFILLER_30_500 VGND VGND VPWR VPWR sky130_fd_sc_hd__decap_4
XFILLER_42_371 VGND VGND VPWR VPWR sky130_fd_sc_hd__fill_1
XFILLER_30_555 VGND VGND VPWR VPWR sky130_fd_sc_hd__decap_6
XFILLER_6_250 VGND VGND VPWR VPWR sky130_fd_sc_hd__fill_2
X_6170_ _1648_ _1661_ _1660_ VGND VGND VPWR VPWR _1701_ sky130_fd_sc_hd__a21bo_1
XFILLER_41_3 VPWR VGND VPWR VGND sky130_ef_sc_hd__decap_12
X_5121_ _0857_ _0858_ _0859_ VGND VGND VPWR VPWR _0861_ sky130_fd_sc_hd__a21o_1
XFILLER_111_332 VGND VGND VPWR VPWR sky130_fd_sc_hd__decap_4
XFILLER_69_268 VGND VGND VPWR VPWR sky130_fd_sc_hd__fill_1
X_5052_ net688 _0791_ _0793_ VGND VGND VPWR VPWR _0794_ sky130_fd_sc_hd__or3b_1
X_8811_ pe_array\[2\].u_pe.accum_reg\[30\] _3509_ net264 VGND VGND VPWR VPWR _4181_
+ sky130_fd_sc_hd__o21a_1
XFILLER_65_452 VPWR VGND VPWR VGND sky130_ef_sc_hd__decap_12
XFILLER_53_614 VGND VGND VPWR VPWR sky130_fd_sc_hd__fill_2
X_8742_ net155 _4114_ VGND VGND VPWR VPWR _4115_ sky130_fd_sc_hd__xnor2_1
XFILLER_111_39 VPWR VGND VPWR VGND sky130_ef_sc_hd__decap_12
XFILLER_80_444 VPWR VGND VPWR VGND sky130_ef_sc_hd__decap_12
X_5954_ _1488_ _1487_ _1481_ VGND VGND VPWR VPWR _1490_ sky130_fd_sc_hd__a21o_1
X_8673_ net163 _4047_ VGND VGND VPWR VPWR _4048_ sky130_fd_sc_hd__or2_1
X_5885_ _1346_ _1382_ _1383_ VGND VGND VPWR VPWR _1422_ sky130_fd_sc_hd__o21ba_1
XTAP_TAPCELL_ROW_23_528 VGND VPWR sky130_fd_sc_hd__tapvpwrvgnd_1
X_4905_ _0599_ _0649_ VGND VGND VPWR VPWR _0651_ sky130_fd_sc_hd__xnor2_1
XFILLER_33_393 VGND VGND VPWR VPWR sky130_fd_sc_hd__fill_1
X_7624_ _2986_ _3013_ _3012_ VGND VGND VPWR VPWR _3073_ sky130_fd_sc_hd__o21a_1
X_4836_ _0580_ _0581_ _0565_ VGND VGND VPWR VPWR _0584_ sky130_fd_sc_hd__a21oi_1
X_7555_ _3005_ _3006_ VGND VGND VPWR VPWR _3007_ sky130_fd_sc_hd__nor2_1
X_6506_ _2025_ _2024_ VGND VGND VPWR VPWR _2026_ sky130_fd_sc_hd__and2b_1
XFILLER_21_599 VGND VGND VPWR VPWR sky130_fd_sc_hd__decap_4
X_4767_ _0507_ _0515_ VGND VGND VPWR VPWR _0516_ sky130_fd_sc_hd__nand2b_1
XFILLER_20_25 VGND VGND VPWR VPWR sky130_fd_sc_hd__decap_3
X_7486_ net193 _2939_ VGND VGND VPWR VPWR _2940_ sky130_fd_sc_hd__xnor2_1
X_4698_ _0446_ _0447_ _0441_ VGND VGND VPWR VPWR _0449_ sky130_fd_sc_hd__a21o_1
X_6437_ _1957_ _1958_ VGND VGND VPWR VPWR _1959_ sky130_fd_sc_hd__nor2_1
X_9225_ clknet_leaf_42_clk _0337_ VGND VGND VPWR VPWR pe_accum\[1\]\[11\] sky130_fd_sc_hd__dfxtp_1
XFILLER_115_671 VGND VGND VPWR VPWR sky130_fd_sc_hd__fill_1
X_6368_ _1836_ _1867_ VGND VGND VPWR VPWR _1893_ sky130_fd_sc_hd__nand2_1
X_9156_ clknet_leaf_28_clk _0268_ VGND VGND VPWR VPWR pe_accum\[0\]\[10\] sky130_fd_sc_hd__dfxtp_1
XFILLER_96_29 VGND VGND VPWR VPWR sky130_fd_sc_hd__fill_2
XFILLER_88_511 VPWR VGND VPWR VGND sky130_ef_sc_hd__decap_12
X_8107_ _3496_ _3497_ VGND VGND VPWR VPWR _3498_ sky130_fd_sc_hd__or2_1
X_5319_ _1022_ _1024_ _1051_ VGND VGND VPWR VPWR _1052_ sky130_fd_sc_hd__o21a_1
XFILLER_102_332 VPWR VGND VPWR VGND sky130_ef_sc_hd__decap_12
X_6299_ net174 _1793_ _1792_ VGND VGND VPWR VPWR _1826_ sky130_fd_sc_hd__o21bai_1
X_9087_ clknet_leaf_64_clk _0199_ VGND VGND VPWR VPWR net37 sky130_fd_sc_hd__dfxtp_1
X_8038_ _3423_ _3429_ _3430_ VGND VGND VPWR VPWR _3431_ sky130_fd_sc_hd__nand3_1
XFILLER_48_419 VGND VGND VPWR VPWR sky130_fd_sc_hd__fill_1
XTAP_TAPCELL_ROW_59_959 VGND VPWR sky130_fd_sc_hd__tapvpwrvgnd_1
XFILLER_29_644 VGND VGND VPWR VPWR sky130_fd_sc_hd__decap_4
XTAP_TAPCELL_ROW_3_286 VGND VPWR sky130_fd_sc_hd__tapvpwrvgnd_1
XFILLER_29_699 VGND VGND VPWR VPWR sky130_fd_sc_hd__fill_1
XFILLER_44_636 VGND VGND VPWR VPWR sky130_fd_sc_hd__fill_1
XFILLER_45_55 VGND VGND VPWR VPWR sky130_fd_sc_hd__fill_1
XTAP_TAPCELL_ROW_104_1497 VGND VPWR sky130_fd_sc_hd__tapvpwrvgnd_1
XFILLER_61_43 VPWR VGND VPWR VGND sky130_ef_sc_hd__decap_12
XANTENNA_9 net395 VGND VGND VPWR VPWR sky130_fd_sc_hd__diode_2
XFILLER_6_27 VGND VGND VPWR VPWR sky130_fd_sc_hd__fill_1
XFILLER_3_220 VGND VGND VPWR VPWR sky130_fd_sc_hd__decap_4
XFILLER_79_533 VGND VGND VPWR VPWR sky130_fd_sc_hd__decap_6
XFILLER_79_511 VGND VGND VPWR VPWR sky130_fd_sc_hd__decap_4
XTAP_TAPCELL_ROW_72_1121 VGND VPWR sky130_fd_sc_hd__tapvpwrvgnd_1
XFILLER_105_181 VGND VGND VPWR VPWR sky130_fd_sc_hd__decap_4
XFILLER_19_110 VGND VGND VPWR VPWR sky130_fd_sc_hd__fill_2
XFILLER_19_176 VGND VGND VPWR VPWR sky130_fd_sc_hd__decap_8
XFILLER_35_669 VGND VGND VPWR VPWR sky130_fd_sc_hd__decap_3
XTAP_TAPCELL_ROW_83_1250 VGND VPWR sky130_fd_sc_hd__tapvpwrvgnd_1
XFILLER_62_477 VPWR VGND VPWR VGND sky130_ef_sc_hd__decap_12
X_5670_ net986 net367 VGND VGND VPWR VPWR _0211_ sky130_fd_sc_hd__and2_1
XFILLER_15_393 VPWR VGND VPWR VGND sky130_ef_sc_hd__decap_12
X_4621_ _4382_ _4381_ _4325_ VGND VGND VPWR VPWR _4384_ sky130_fd_sc_hd__a21o_1
XFILLER_30_385 VGND VGND VPWR VPWR sky130_fd_sc_hd__decap_6
X_7340_ _2767_ _2769_ _2796_ _2797_ VGND VGND VPWR VPWR _2799_ sky130_fd_sc_hd__o211ai_1
X_4552_ _4289_ _4291_ VGND VGND VPWR VPWR _4317_ sky130_fd_sc_hd__nand2_1
Xhold515 pe_array\[0\].u_pe.tap_count\[1\] VGND VGND VPWR VPWR net1030 sky130_fd_sc_hd__dlygate4sd3_1
Xhold504 pe_accum\[2\]\[12\] VGND VGND VPWR VPWR net1019 sky130_fd_sc_hd__dlygate4sd3_1
X_7271_ net446 net338 pe_array\[1\].u_pe.accum_reg\[16\] VGND VGND VPWR VPWR _2732_
+ sky130_fd_sc_hd__a21oi_1
X_4483_ net306 net509 pe_array\[3\].u_pe.accum_reg\[0\] VGND VGND VPWR VPWR _4252_
+ sky130_fd_sc_hd__a21oi_1
X_6222_ _1597_ _1746_ _1747_ _1750_ VGND VGND VPWR VPWR _1751_ sky130_fd_sc_hd__a31o_4
X_9010_ clknet_leaf_40_clk _0122_ VGND VGND VPWR VPWR net79 sky130_fd_sc_hd__dfxtp_1
XFILLER_103_107 VGND VGND VPWR VPWR sky130_fd_sc_hd__decap_4
X_6153_ _1681_ _1682_ VGND VGND VPWR VPWR _1684_ sky130_fd_sc_hd__nand2_4
X_6084_ _1613_ _1614_ _1570_ _1571_ VGND VGND VPWR VPWR _1617_ sky130_fd_sc_hd__a211o_1
XFILLER_57_216 VGND VGND VPWR VPWR sky130_fd_sc_hd__decap_8
X_5104_ net414 _0844_ VGND VGND VPWR VPWR _0030_ sky130_fd_sc_hd__nor2_1
XFILLER_57_238 VGND VGND VPWR VPWR sky130_fd_sc_hd__fill_1
X_5035_ _0712_ _0744_ VGND VGND VPWR VPWR _0778_ sky130_fd_sc_hd__nor2_1
XTAP_TAPCELL_ROW_56_929 VGND VPWR sky130_fd_sc_hd__tapvpwrvgnd_1
XTAP_TAPCELL_ROW_0_245 VGND VPWR sky130_fd_sc_hd__tapvpwrvgnd_1
XTAP_TAPCELL_ROW_0_256 VGND VPWR sky130_fd_sc_hd__tapvpwrvgnd_1
XFILLER_25_135 VGND VGND VPWR VPWR sky130_fd_sc_hd__decap_4
X_6986_ _2444_ _2452_ VGND VGND VPWR VPWR _2454_ sky130_fd_sc_hd__xnor2_1
X_8725_ net264 _4096_ _4097_ VGND VGND VPWR VPWR _4098_ sky130_fd_sc_hd__nor3_1
X_5937_ _1467_ _1472_ VGND VGND VPWR VPWR _1473_ sky130_fd_sc_hd__nand2b_1
XTAP_TAPCELL_ROW_36_686 VGND VPWR sky130_fd_sc_hd__tapvpwrvgnd_1
XFILLER_41_617 VPWR VGND VPWR VGND sky130_ef_sc_hd__decap_12
X_8656_ _4003_ _4031_ VGND VGND VPWR VPWR _4032_ sky130_fd_sc_hd__nand2_1
X_5868_ _1388_ _1404_ VGND VGND VPWR VPWR _1406_ sky130_fd_sc_hd__xor2_1
XFILLER_21_352 VPWR VGND VPWR VGND sky130_ef_sc_hd__decap_12
X_7607_ _3055_ _3056_ VGND VGND VPWR VPWR _3057_ sky130_fd_sc_hd__and2b_1
X_8587_ net159 _3963_ _3964_ VGND VGND VPWR VPWR _3965_ sky130_fd_sc_hd__nand3_1
XTAP_TAPCELL_ROW_97_1419 VGND VPWR sky130_fd_sc_hd__tapvpwrvgnd_1
X_5799_ _1336_ _1337_ VGND VGND VPWR VPWR _1339_ sky130_fd_sc_hd__xnor2_1
X_4819_ _0438_ _0566_ _0440_ VGND VGND VPWR VPWR _0567_ sky130_fd_sc_hd__o21ba_4
X_7538_ net407 pe_array\[1\].u_pe.accum_reg\[24\] net229 _2990_ VGND VGND VPWR VPWR
+ _2991_ sky130_fd_sc_hd__o2bb2a_1
XFILLER_31_46 VGND VGND VPWR VPWR sky130_fd_sc_hd__fill_1
XFILLER_31_57 VGND VGND VPWR VPWR sky130_fd_sc_hd__decap_3
X_7469_ _2921_ _2922_ VGND VGND VPWR VPWR _2924_ sky130_fd_sc_hd__xor2_2
Xoutput24 net24 VGND VGND VPWR VPWR result_data[101] sky130_fd_sc_hd__buf_2
X_9208_ clknet_leaf_41_clk _0320_ VGND VGND VPWR VPWR pe_array\[1\].u_pe.accum_reg\[26\]
+ sky130_fd_sc_hd__dfxtp_1
Xoutput57 net57 VGND VGND VPWR VPWR result_data[16] sky130_fd_sc_hd__buf_2
XTAP_TAPCELL_ROW_8_345 VGND VPWR sky130_fd_sc_hd__tapvpwrvgnd_1
Xoutput46 net46 VGND VGND VPWR VPWR result_data[121] sky130_fd_sc_hd__buf_2
Xoutput35 net35 VGND VGND VPWR VPWR result_data[111] sky130_fd_sc_hd__buf_2
Xoutput68 net68 VGND VGND VPWR VPWR result_data[26] sky130_fd_sc_hd__buf_2
X_9139_ clknet_leaf_22_clk _0251_ VGND VGND VPWR VPWR pe_array\[0\].u_pe.accum_reg\[25\]
+ sky130_fd_sc_hd__dfxtp_1
XFILLER_103_641 VPWR VGND VPWR VGND sky130_ef_sc_hd__decap_12
XFILLER_88_341 VPWR VGND VPWR VGND sky130_ef_sc_hd__decap_12
Xoutput79 net79 VGND VGND VPWR VPWR result_data[36] sky130_fd_sc_hd__buf_2
XFILLER_0_245 VGND VGND VPWR VPWR sky130_fd_sc_hd__decap_3
XFILLER_0_223 VGND VGND VPWR VPWR sky130_fd_sc_hd__fill_1
XFILLER_88_363 VGND VGND VPWR VPWR sky130_fd_sc_hd__fill_1
XFILLER_48_205 VGND VGND VPWR VPWR sky130_fd_sc_hd__fill_2
XFILLER_0_289 VGND VGND VPWR VPWR sky130_fd_sc_hd__fill_1
XFILLER_29_430 VGND VGND VPWR VPWR sky130_fd_sc_hd__decap_3
XFILLER_56_65 VPWR VGND VPWR VGND sky130_ef_sc_hd__decap_12
XFILLER_29_452 VGND VGND VPWR VPWR sky130_fd_sc_hd__decap_8
XTAP_TAPCELL_ROW_106_1526 VGND VPWR sky130_fd_sc_hd__tapvpwrvgnd_1
XFILLER_16_102 VPWR VGND VPWR VGND sky130_ef_sc_hd__decap_12
XPHY_EDGE_ROW_19_Right_19 VGND VGND VPWR VPWR sky130_fd_sc_hd__decap_3
XFILLER_32_617 VGND VGND VPWR VPWR sky130_fd_sc_hd__fill_1
XFILLER_44_477 VPWR VGND VPWR VGND sky130_ef_sc_hd__decap_12
XFILLER_24_190 VGND VGND VPWR VPWR sky130_fd_sc_hd__fill_1
XFILLER_12_363 VGND VGND VPWR VPWR sky130_fd_sc_hd__fill_1
XFILLER_40_661 VGND VGND VPWR VPWR sky130_fd_sc_hd__decap_4
Xclkbuf_3_1__f_clk clknet_0_clk VGND VGND VPWR VPWR clknet_3_1__leaf_clk sky130_fd_sc_hd__clkbuf_16
XTAP_TAPCELL_ROW_117_1655 VGND VPWR sky130_fd_sc_hd__tapvpwrvgnd_1
XTAP_TAPCELL_ROW_117_1666 VGND VPWR sky130_fd_sc_hd__tapvpwrvgnd_1
XPHY_EDGE_ROW_28_Right_28 VGND VGND VPWR VPWR sky130_fd_sc_hd__decap_3
XFILLER_67_558 VGND VGND VPWR VPWR sky130_fd_sc_hd__fill_2
XPHY_EDGE_ROW_37_Right_37 VGND VGND VPWR VPWR sky130_fd_sc_hd__decap_3
X_6840_ _2277_ _2310_ VGND VGND VPWR VPWR _2312_ sky130_fd_sc_hd__xnor2_1
XFILLER_90_572 VGND VGND VPWR VPWR sky130_fd_sc_hd__decap_8
XFILLER_90_561 VGND VGND VPWR VPWR sky130_fd_sc_hd__fill_2
XFILLER_62_263 VGND VGND VPWR VPWR sky130_fd_sc_hd__decap_6
X_6771_ _2243_ _2244_ VGND VGND VPWR VPWR _2245_ sky130_fd_sc_hd__and2b_1
XFILLER_50_403 VPWR VGND VPWR VGND sky130_ef_sc_hd__decap_12
XFILLER_23_617 VGND VGND VPWR VPWR sky130_fd_sc_hd__decap_8
X_8510_ pe_array\[2\].u_pe.accum_reg\[21\] net441 net315 VGND VGND VPWR VPWR _3890_
+ sky130_fd_sc_hd__and3_4
X_5722_ _1250_ _1263_ VGND VGND VPWR VPWR _1265_ sky130_fd_sc_hd__and2_1
XTAP_TAPCELL_ROW_33_645 VGND VPWR sky130_fd_sc_hd__tapvpwrvgnd_1
XTAP_TAPCELL_ROW_61_987 VGND VPWR sky130_fd_sc_hd__tapvpwrvgnd_1
XFILLER_50_469 VGND VGND VPWR VPWR sky130_fd_sc_hd__decap_6
XFILLER_31_661 VGND VGND VPWR VPWR sky130_fd_sc_hd__fill_1
X_8441_ _3795_ _3794_ _3792_ VGND VGND VPWR VPWR _3824_ sky130_fd_sc_hd__o21bai_4
X_5653_ net939 net370 VGND VGND VPWR VPWR _0194_ sky130_fd_sc_hd__and2_1
X_8372_ _3724_ _3753_ _3755_ VGND VGND VPWR VPWR _3757_ sky130_fd_sc_hd__or3b_4
X_4604_ net299 net484 pe_array\[3\].u_pe.accum_reg\[6\] VGND VGND VPWR VPWR _4367_
+ sky130_fd_sc_hd__a21oi_1
XPHY_EDGE_ROW_46_Right_46 VGND VGND VPWR VPWR sky130_fd_sc_hd__decap_3
X_5584_ net964 net379 VGND VGND VPWR VPWR _0125_ sky130_fd_sc_hd__and2_1
XFILLER_116_210 VGND VGND VPWR VPWR sky130_fd_sc_hd__fill_2
X_7323_ _2780_ _2781_ _2782_ VGND VGND VPWR VPWR _2783_ sky130_fd_sc_hd__nand3_1
X_4535_ _4298_ _4299_ VGND VGND VPWR VPWR _4300_ sky130_fd_sc_hd__or2_1
XFILLER_117_27 VGND VGND VPWR VPWR sky130_fd_sc_hd__fill_1
XFILLER_116_232 VGND VGND VPWR VPWR sky130_fd_sc_hd__fill_1
XFILLER_116_265 VGND VGND VPWR VPWR sky130_fd_sc_hd__decap_3
Xhold378 pe_accum\[0\]\[15\] VGND VGND VPWR VPWR net893 sky130_fd_sc_hd__dlygate4sd3_1
X_4466_ net18 _4240_ _4241_ net346 VGND VGND VPWR VPWR _0005_ sky130_fd_sc_hd__a22o_1
X_7254_ _2713_ _2714_ net165 VGND VGND VPWR VPWR _2716_ sky130_fd_sc_hd__o21ai_1
Xhold389 pe_accum\[0\]\[18\] VGND VGND VPWR VPWR net904 sky130_fd_sc_hd__dlygate4sd3_1
X_6205_ _1732_ _1733_ _1734_ VGND VGND VPWR VPWR _1735_ sky130_fd_sc_hd__nand3_1
X_7185_ _2646_ _2647_ _2582_ _2584_ VGND VGND VPWR VPWR _2649_ sky130_fd_sc_hd__o211a_1
X_6136_ _1629_ _1627_ _1666_ _1667_ VGND VGND VPWR VPWR _1668_ sky130_fd_sc_hd__a211o_4
XTAP_TAPCELL_ROW_5_315 VGND VPWR sky130_fd_sc_hd__tapvpwrvgnd_1
XFILLER_97_193 VGND VGND VPWR VPWR sky130_fd_sc_hd__fill_1
XFILLER_85_355 VGND VGND VPWR VPWR sky130_fd_sc_hd__decap_3
X_6067_ net349 _1521_ _1477_ VGND VGND VPWR VPWR _1600_ sky130_fd_sc_hd__a21o_2
XFILLER_73_517 VPWR VGND VPWR VGND sky130_ef_sc_hd__decap_12
XPHY_EDGE_ROW_55_Right_55 VGND VGND VPWR VPWR sky130_fd_sc_hd__decap_3
XFILLER_26_400 VPWR VGND VPWR VGND sky130_ef_sc_hd__decap_12
X_5018_ _0758_ _0759_ _0760_ VGND VGND VPWR VPWR _0761_ sky130_fd_sc_hd__and3_1
XFILLER_26_433 VGND VGND VPWR VPWR sky130_fd_sc_hd__fill_1
XFILLER_26_444 VPWR VGND VPWR VGND sky130_ef_sc_hd__decap_12
XFILLER_81_561 VGND VGND VPWR VPWR sky130_fd_sc_hd__decap_4
XFILLER_26_477 VGND VGND VPWR VPWR sky130_fd_sc_hd__fill_2
X_6969_ _2391_ _2389_ _2437_ VGND VGND VPWR VPWR _2438_ sky130_fd_sc_hd__a21o_1
X_8708_ net155 _4081_ VGND VGND VPWR VPWR _4082_ sky130_fd_sc_hd__xnor2_1
XTAP_TAPCELL_ROW_101_1467 VGND VPWR sky130_fd_sc_hd__tapvpwrvgnd_1
X_8639_ _4012_ _4013_ net265 VGND VGND VPWR VPWR _4015_ sky130_fd_sc_hd__o21ai_1
XPHY_EDGE_ROW_64_Right_64 VGND VGND VPWR VPWR sky130_fd_sc_hd__decap_3
XFILLER_21_160 VGND VGND VPWR VPWR sky130_fd_sc_hd__decap_8
XFILLER_5_337 VGND VGND VPWR VPWR sky130_fd_sc_hd__decap_3
XFILLER_107_243 VGND VGND VPWR VPWR sky130_fd_sc_hd__decap_4
XFILLER_110_419 VGND VGND VPWR VPWR sky130_fd_sc_hd__fill_1
XFILLER_3_39 VPWR VGND VPWR VGND sky130_ef_sc_hd__decap_12
XFILLER_49_503 VGND VGND VPWR VPWR sky130_fd_sc_hd__fill_1
XTAP_TAPCELL_ROW_112_1596 VGND VPWR sky130_fd_sc_hd__tapvpwrvgnd_1
XPHY_EDGE_ROW_73_Right_73 VGND VGND VPWR VPWR sky130_fd_sc_hd__decap_3
XFILLER_91_358 VGND VGND VPWR VPWR sky130_fd_sc_hd__decap_8
XTAP_TAPCELL_ROW_67_1053 VGND VPWR sky130_fd_sc_hd__tapvpwrvgnd_1
XFILLER_17_466 VGND VGND VPWR VPWR sky130_fd_sc_hd__decap_6
XPHY_EDGE_ROW_82_Right_82 VGND VGND VPWR VPWR sky130_fd_sc_hd__decap_3
XFILLER_12_171 VGND VGND VPWR VPWR sky130_fd_sc_hd__fill_1
XFILLER_9_632 VPWR VGND VPWR VGND sky130_ef_sc_hd__decap_12
XFILLER_13_694 VGND VGND VPWR VPWR sky130_fd_sc_hd__decap_6
XTAP_TAPCELL_ROW_30_615 VGND VPWR sky130_fd_sc_hd__tapvpwrvgnd_1
XFILLER_8_197 VGND VGND VPWR VPWR sky130_fd_sc_hd__fill_2
XTAP_TAPCELL_ROW_10_372 VGND VPWR sky130_fd_sc_hd__tapvpwrvgnd_1
XTAP_TAPCELL_ROW_78_1193 VGND VPWR sky130_fd_sc_hd__tapvpwrvgnd_1
XFILLER_4_381 VPWR VGND VPWR VGND sky130_ef_sc_hd__decap_12
XPHY_EDGE_ROW_91_Right_91 VGND VGND VPWR VPWR sky130_fd_sc_hd__decap_3
XFILLER_79_160 VGND VGND VPWR VPWR sky130_fd_sc_hd__decap_8
X_8990_ clknet_leaf_27_clk _0102_ VGND VGND VPWR VPWR net57 sky130_fd_sc_hd__dfxtp_1
XFILLER_55_517 VPWR VGND VPWR VGND sky130_ef_sc_hd__decap_12
XTAP_TAPCELL_ROW_38_704 VGND VPWR sky130_fd_sc_hd__tapvpwrvgnd_1
XFILLER_95_686 VGND VGND VPWR VPWR sky130_fd_sc_hd__decap_6
X_7941_ net474 net322 net324 net467 VGND VGND VPWR VPWR _3336_ sky130_fd_sc_hd__a22o_1
XTAP_TAPCELL_ROW_38_715 VGND VPWR sky130_fd_sc_hd__tapvpwrvgnd_1
X_7872_ _3265_ _3266_ net496 net320 VGND VGND VPWR VPWR _3269_ sky130_fd_sc_hd__a2bb2o_1
XFILLER_63_561 VGND VGND VPWR VPWR sky130_fd_sc_hd__fill_1
X_6823_ _2293_ _2292_ net481 net336 VGND VGND VPWR VPWR _2295_ sky130_fd_sc_hd__or4bb_4
XTAP_TAPCELL_ROW_18_472 VGND VPWR sky130_fd_sc_hd__tapvpwrvgnd_1
XFILLER_23_425 VGND VGND VPWR VPWR sky130_fd_sc_hd__decap_3
X_6754_ _2225_ _2226_ _2228_ VGND VGND VPWR VPWR _2229_ sky130_fd_sc_hd__or3_1
X_6685_ net607 _2181_ _2197_ VGND VGND VPWR VPWR _2199_ sky130_fd_sc_hd__a21oi_2
X_5705_ _1247_ _1248_ VGND VGND VPWR VPWR _1249_ sky130_fd_sc_hd__nor2_1
X_5636_ net967 net385 VGND VGND VPWR VPWR _0177_ sky130_fd_sc_hd__and2_1
X_8424_ _3804_ _3805_ net191 VGND VGND VPWR VPWR _3807_ sky130_fd_sc_hd__a21o_1
XFILLER_12_15 VPWR VGND VPWR VGND sky130_ef_sc_hd__decap_12
XFILLER_12_59 VGND VGND VPWR VPWR sky130_fd_sc_hd__fill_1
X_5567_ net906 net395 VGND VGND VPWR VPWR _0108_ sky130_fd_sc_hd__and2_1
X_8355_ net187 _3737_ _3739_ VGND VGND VPWR VPWR _3740_ sky130_fd_sc_hd__or3b_1
XFILLER_117_585 VGND VGND VPWR VPWR sky130_fd_sc_hd__decap_3
X_8286_ net259 _3671_ _3672_ VGND VGND VPWR VPWR _3673_ sky130_fd_sc_hd__nor3_1
X_7306_ _2757_ _2763_ _2756_ VGND VGND VPWR VPWR _2766_ sky130_fd_sc_hd__o21a_1
X_4518_ net305 net492 net487 net306 VGND VGND VPWR VPWR _4284_ sky130_fd_sc_hd__a22oi_1
X_5498_ net954 net249 _1209_ net370 VGND VGND VPWR VPWR _0059_ sky130_fd_sc_hd__o211a_1
X_4449_ pe_array\[3\].u_pe.weight_in\[7\] VGND VGND VPWR VPWR _4230_ sky130_fd_sc_hd__inv_2
X_7237_ _2665_ net169 VGND VGND VPWR VPWR _2699_ sky130_fd_sc_hd__or2_1
X_7168_ pe_array\[1\].u_pe.accum_reg\[13\] net448 net339 VGND VGND VPWR VPWR _2632_
+ sky130_fd_sc_hd__and3_1
X_6119_ net277 _1649_ _1650_ VGND VGND VPWR VPWR _1651_ sky130_fd_sc_hd__nor3_1
X_7099_ _2563_ _2562_ _2518_ _2520_ VGND VGND VPWR VPWR _2565_ sky130_fd_sc_hd__a211o_1
XFILLER_86_697 VGND VGND VPWR VPWR sky130_fd_sc_hd__decap_3
XFILLER_26_274 VGND VGND VPWR VPWR sky130_fd_sc_hd__fill_1
XFILLER_41_222 VGND VGND VPWR VPWR sky130_fd_sc_hd__fill_2
XFILLER_53_55 VGND VGND VPWR VPWR sky130_fd_sc_hd__fill_1
XFILLER_14_469 VGND VGND VPWR VPWR sky130_fd_sc_hd__fill_1
XFILLER_5_101 VGND VGND VPWR VPWR sky130_fd_sc_hd__decap_8
XFILLER_108_552 VPWR VGND VPWR VGND sky130_ef_sc_hd__decap_12
XFILLER_6_657 VPWR VGND VPWR VGND sky130_ef_sc_hd__decap_12
XFILLER_5_123 VGND VGND VPWR VPWR sky130_fd_sc_hd__fill_2
XTAP_TAPCELL_ROW_114_1625 VGND VPWR sky130_fd_sc_hd__tapvpwrvgnd_1
XFILLER_68_119 VGND VGND VPWR VPWR sky130_fd_sc_hd__fill_1
XFILLER_89_491 VGND VGND VPWR VPWR sky130_fd_sc_hd__fill_1
XFILLER_77_653 VPWR VGND VPWR VGND sky130_ef_sc_hd__decap_12
XFILLER_76_141 VGND VGND VPWR VPWR sky130_fd_sc_hd__fill_1
XFILLER_91_100 VPWR VGND VPWR VGND sky130_ef_sc_hd__decap_12
XFILLER_77_697 VGND VGND VPWR VPWR sky130_fd_sc_hd__decap_3
XFILLER_64_303 VGND VGND VPWR VPWR sky130_fd_sc_hd__decap_4
XFILLER_64_369 VGND VGND VPWR VPWR sky130_fd_sc_hd__fill_1
XFILLER_45_561 VPWR VGND VPWR VGND sky130_ef_sc_hd__decap_12
XFILLER_91_199 VPWR VGND VPWR VGND sky130_ef_sc_hd__decap_12
XFILLER_60_531 VGND VGND VPWR VPWR sky130_fd_sc_hd__fill_1
XTAP_TAPCELL_ROW_15_431 VGND VPWR sky130_fd_sc_hd__tapvpwrvgnd_1
XFILLER_20_406 VPWR VGND VPWR VGND sky130_ef_sc_hd__decap_12
XFILLER_32_288 VGND VGND VPWR VPWR sky130_fd_sc_hd__fill_1
XFILLER_32_299 VGND VGND VPWR VPWR sky130_fd_sc_hd__decap_8
XTAP_TAPCELL_ROW_43_773 VGND VPWR sky130_fd_sc_hd__tapvpwrvgnd_1
X_6470_ _1953_ _1954_ _1989_ _1990_ VGND VGND VPWR VPWR _1991_ sky130_fd_sc_hd__o211a_1
XFILLER_9_473 VGND VGND VPWR VPWR sky130_fd_sc_hd__decap_8
X_5421_ _1118_ _1149_ VGND VGND VPWR VPWR _1151_ sky130_fd_sc_hd__nand2_1
X_8140_ _3528_ _3529_ _3485_ VGND VGND VPWR VPWR _3531_ sky130_fd_sc_hd__and3b_1
X_5352_ _1083_ _1082_ VGND VGND VPWR VPWR _1084_ sky130_fd_sc_hd__and2b_1
XFILLER_99_222 VGND VGND VPWR VPWR sky130_fd_sc_hd__fill_2
X_8071_ net443 _3418_ _3419_ net312 net471 VGND VGND VPWR VPWR _3463_ sky130_fd_sc_hd__a32o_1
XFILLER_87_417 VGND VGND VPWR VPWR sky130_fd_sc_hd__decap_3
X_5283_ _0987_ _0989_ _1015_ _1016_ VGND VGND VPWR VPWR _1017_ sky130_fd_sc_hd__o211a_1
X_7022_ net479 net472 net328 net326 VGND VGND VPWR VPWR _2489_ sky130_fd_sc_hd__and4_1
XFILLER_83_612 VGND VGND VPWR VPWR sky130_fd_sc_hd__decap_4
X_8973_ clknet_leaf_21_clk _0085_ VGND VGND VPWR VPWR pe_array\[0\].u_pe.valid_out
+ sky130_fd_sc_hd__dfxtp_1
XFILLER_83_656 VPWR VGND VPWR VGND sky130_ef_sc_hd__decap_12
X_7924_ _3285_ _3316_ VGND VGND VPWR VPWR _3320_ sky130_fd_sc_hd__or2_1
X_7855_ net498 net323 net325 net485 VGND VGND VPWR VPWR _3253_ sky130_fd_sc_hd__a22oi_1
XFILLER_51_520 VGND VGND VPWR VPWR sky130_fd_sc_hd__fill_2
XFILLER_23_200 VGND VGND VPWR VPWR sky130_fd_sc_hd__decap_8
X_6806_ _2277_ _2278_ VGND VGND VPWR VPWR _2279_ sky130_fd_sc_hd__nand2_1
XFILLER_51_597 VGND VGND VPWR VPWR sky130_fd_sc_hd__fill_1
XFILLER_11_417 VPWR VGND VPWR VGND sky130_ef_sc_hd__decap_12
XFILLER_23_288 VGND VGND VPWR VPWR sky130_fd_sc_hd__fill_1
X_4998_ _0738_ _0739_ _0740_ VGND VGND VPWR VPWR _0742_ sky130_fd_sc_hd__nand3_2
X_7786_ net966 net225 _3202_ net377 VGND VGND VPWR VPWR _0354_ sky130_fd_sc_hd__o211a_1
XFILLER_109_305 VPWR VGND VPWR VGND sky130_ef_sc_hd__decap_12
X_6737_ net412 pe_array\[1\].u_pe.accum_reg\[0\] net232 _2213_ VGND VGND VPWR VPWR
+ _2214_ sky130_fd_sc_hd__o2bb2a_1
X_6668_ _2181_ _2182_ VGND VGND VPWR VPWR _2183_ sky130_fd_sc_hd__nand2_1
XFILLER_109_349 VGND VGND VPWR VPWR sky130_fd_sc_hd__decap_4
X_6599_ _2113_ _2114_ VGND VGND VPWR VPWR _2116_ sky130_fd_sc_hd__xnor2_1
X_8407_ _3789_ _3790_ VGND VGND VPWR VPWR _3791_ sky130_fd_sc_hd__xnor2_1
X_5619_ net1001 net380 VGND VGND VPWR VPWR _0160_ sky130_fd_sc_hd__and2_1
X_8338_ _3721_ _3722_ _3723_ VGND VGND VPWR VPWR _3724_ sky130_fd_sc_hd__or3_4
XFILLER_117_393 VGND VGND VPWR VPWR sky130_fd_sc_hd__fill_2
XFILLER_105_533 VGND VGND VPWR VPWR sky130_fd_sc_hd__fill_1
XFILLER_105_577 VGND VGND VPWR VPWR sky130_fd_sc_hd__decap_8
X_8269_ _3653_ _3654_ _3613_ VGND VGND VPWR VPWR _3657_ sky130_fd_sc_hd__a21o_1
Xfanout441 net442 VGND VGND VPWR VPWR net441 sky130_fd_sc_hd__buf_8
Xfanout430 net432 VGND VGND VPWR VPWR net430 sky130_fd_sc_hd__clkbuf_4
Xfanout474 net475 VGND VGND VPWR VPWR net474 sky130_fd_sc_hd__buf_6
Xfanout463 net468 VGND VGND VPWR VPWR net463 sky130_fd_sc_hd__buf_4
Xfanout452 net516 VGND VGND VPWR VPWR net452 sky130_fd_sc_hd__buf_6
XFILLER_100_260 VGND VGND VPWR VPWR sky130_fd_sc_hd__decap_6
Xfanout496 net497 VGND VGND VPWR VPWR net496 sky130_fd_sc_hd__clkbuf_4
Xfanout485 net486 VGND VGND VPWR VPWR net485 sky130_fd_sc_hd__buf_2
XFILLER_19_517 VPWR VGND VPWR VGND sky130_ef_sc_hd__decap_12
XFILLER_48_77 VGND VGND VPWR VPWR sky130_fd_sc_hd__decap_6
XFILLER_0_29 VPWR VGND VPWR VGND sky130_ef_sc_hd__decap_12
XFILLER_46_347 VPWR VGND VPWR VGND sky130_ef_sc_hd__decap_12
XFILLER_104_94 VPWR VGND VPWR VGND sky130_ef_sc_hd__decap_12
XFILLER_104_83 VGND VGND VPWR VPWR sky130_fd_sc_hd__fill_1
XFILLER_73_166 VGND VGND VPWR VPWR sky130_fd_sc_hd__fill_2
XTAP_TAPCELL_ROW_64_1023 VGND VPWR sky130_fd_sc_hd__tapvpwrvgnd_1
XFILLER_61_328 VGND VGND VPWR VPWR sky130_fd_sc_hd__fill_1
XFILLER_54_380 VGND VGND VPWR VPWR sky130_fd_sc_hd__decap_3
XFILLER_9_27 VPWR VGND VPWR VGND sky130_ef_sc_hd__decap_12
XFILLER_80_20 VGND VGND VPWR VPWR sky130_fd_sc_hd__decap_8
XTAP_TAPCELL_ROW_12_401 VGND VPWR sky130_fd_sc_hd__tapvpwrvgnd_1
XFILLER_42_575 VGND VGND VPWR VPWR sky130_fd_sc_hd__decap_6
XTAP_TAPCELL_ROW_40_732 VGND VPWR sky130_fd_sc_hd__tapvpwrvgnd_1
XFILLER_6_421 VPWR VGND VPWR VGND sky130_ef_sc_hd__decap_12
XPHY_EDGE_ROW_108_Right_108 VGND VGND VPWR VPWR sky130_fd_sc_hd__decap_3
XTAP_TAPCELL_ROW_75_1152 VGND VPWR sky130_fd_sc_hd__tapvpwrvgnd_1
XFILLER_111_547 VGND VGND VPWR VPWR sky130_fd_sc_hd__fill_2
XFILLER_2_693 VGND VGND VPWR VPWR sky130_fd_sc_hd__decap_6
XFILLER_77_483 VPWR VGND VPWR VGND sky130_ef_sc_hd__decap_12
XFILLER_37_314 VGND VGND VPWR VPWR sky130_fd_sc_hd__decap_3
XFILLER_64_111 VGND VGND VPWR VPWR sky130_fd_sc_hd__decap_3
XTAP_TAPCELL_ROW_48_832 VGND VPWR sky130_fd_sc_hd__tapvpwrvgnd_1
XFILLER_92_486 VGND VGND VPWR VPWR sky130_fd_sc_hd__decap_8
X_5970_ _1504_ _1505_ VGND VGND VPWR VPWR _1506_ sky130_fd_sc_hd__nand2_4
XFILLER_64_155 VGND VGND VPWR VPWR sky130_fd_sc_hd__decap_8
XTAP_TAPCELL_ROW_86_1281 VGND VPWR sky130_fd_sc_hd__tapvpwrvgnd_1
X_4921_ _0664_ net687 _0652_ VGND VGND VPWR VPWR _0667_ sky130_fd_sc_hd__a21oi_2
X_4852_ net742 _0440_ VGND VGND VPWR VPWR _0599_ sky130_fd_sc_hd__or2_1
XFILLER_45_391 VGND VGND VPWR VPWR sky130_fd_sc_hd__fill_1
X_7640_ net167 _3088_ VGND VGND VPWR VPWR _3089_ sky130_fd_sc_hd__nor2_1
X_7571_ _2992_ _2994_ VGND VGND VPWR VPWR _3022_ sky130_fd_sc_hd__nand2b_1
X_4783_ _0529_ _0530_ _0531_ VGND VGND VPWR VPWR _0532_ sky130_fd_sc_hd__nand3_4
X_6522_ pe_array\[0\].u_pe.accum_reg\[26\] _1393_ VGND VGND VPWR VPWR _2041_ sky130_fd_sc_hd__nor2_1
X_9310_ clknet_leaf_5_clk _0422_ VGND VGND VPWR VPWR pe_accum\[2\]\[20\] sky130_fd_sc_hd__dfxtp_1
X_6453_ _1945_ _1949_ _1943_ VGND VGND VPWR VPWR _1975_ sky130_fd_sc_hd__o21ba_1
XFILLER_9_281 VPWR VGND VPWR VGND sky130_ef_sc_hd__decap_12
X_9241_ clknet_leaf_41_clk _0353_ VGND VGND VPWR VPWR pe_accum\[1\]\[27\] sky130_fd_sc_hd__dfxtp_1
X_9172_ clknet_leaf_21_clk _0284_ VGND VGND VPWR VPWR pe_accum\[0\]\[26\] sky130_fd_sc_hd__dfxtp_1
XFILLER_109_39 VPWR VGND VPWR VGND sky130_ef_sc_hd__decap_12
Xclkload40 clknet_leaf_9_clk VGND VGND VPWR VPWR clkload40/Y sky130_fd_sc_hd__clkinv_8
Xclkload51 clknet_leaf_33_clk VGND VGND VPWR VPWR clkload51/Y sky130_fd_sc_hd__inv_6
X_5404_ _1131_ _1132_ VGND VGND VPWR VPWR _1134_ sky130_fd_sc_hd__xor2_1
X_6384_ _1907_ _1906_ VGND VGND VPWR VPWR _1908_ sky130_fd_sc_hd__and2b_1
X_8123_ _3510_ _3511_ net680 VGND VGND VPWR VPWR _3514_ sky130_fd_sc_hd__o21ai_1
XFILLER_114_363 VGND VGND VPWR VPWR sky130_fd_sc_hd__fill_1
X_5335_ net288 _1065_ _1066_ VGND VGND VPWR VPWR _1067_ sky130_fd_sc_hd__nor3_1
XFILLER_87_225 VGND VGND VPWR VPWR sky130_fd_sc_hd__fill_1
X_8054_ _3444_ _3445_ VGND VGND VPWR VPWR _3447_ sky130_fd_sc_hd__xor2_1
X_5266_ _0964_ _0966_ _1000_ VGND VGND VPWR VPWR _1001_ sky130_fd_sc_hd__o21a_1
XFILLER_87_258 VGND VGND VPWR VPWR sky130_fd_sc_hd__fill_1
X_7005_ _2454_ _2470_ _2471_ VGND VGND VPWR VPWR _2473_ sky130_fd_sc_hd__nand3_2
X_5197_ _0932_ _0933_ VGND VGND VPWR VPWR _0934_ sky130_fd_sc_hd__or2_1
XFILLER_28_303 VGND VGND VPWR VPWR sky130_fd_sc_hd__decap_4
XFILLER_56_645 VPWR VGND VPWR VGND sky130_ef_sc_hd__decap_12
XFILLER_55_111 VGND VGND VPWR VPWR sky130_fd_sc_hd__fill_1
XFILLER_71_615 VGND VGND VPWR VPWR sky130_fd_sc_hd__fill_1
X_8956_ clknet_leaf_61_clk _0068_ VGND VGND VPWR VPWR pe_accum\[3\]\[24\] sky130_fd_sc_hd__dfxtp_1
XFILLER_28_369 VGND VGND VPWR VPWR sky130_fd_sc_hd__fill_1
X_7907_ _3296_ _3297_ _3302_ VGND VGND VPWR VPWR _3303_ sky130_fd_sc_hd__nand3_1
XFILLER_34_13 VPWR VGND VPWR VGND sky130_ef_sc_hd__decap_12
X_8887_ net1002 net214 _4224_ net387 VGND VGND VPWR VPWR _0433_ sky130_fd_sc_hd__o211a_1
XFILLER_70_169 VGND VGND VPWR VPWR sky130_fd_sc_hd__fill_2
X_7838_ _3233_ _3234_ _3232_ VGND VGND VPWR VPWR _3237_ sky130_fd_sc_hd__o21ai_1
XFILLER_24_586 VGND VGND VPWR VPWR sky130_fd_sc_hd__fill_2
X_7769_ net222 _2878_ VGND VGND VPWR VPWR _3194_ sky130_fd_sc_hd__nand2_1
XFILLER_109_113 VGND VGND VPWR VPWR sky130_fd_sc_hd__decap_4
Xclkload1 clknet_3_1__leaf_clk VGND VGND VPWR VPWR clkload1/Y sky130_fd_sc_hd__clkinvlp_4
XFILLER_117_190 VGND VGND VPWR VPWR sky130_fd_sc_hd__fill_2
XFILLER_59_43 VPWR VGND VPWR VGND sky130_ef_sc_hd__decap_12
XFILLER_1_3 VPWR VGND VPWR VGND sky130_ef_sc_hd__decap_12
Xfanout260 net261 VGND VGND VPWR VPWR net260 sky130_fd_sc_hd__buf_8
XFILLER_59_472 VGND VGND VPWR VPWR sky130_fd_sc_hd__decap_3
Xfanout282 net284 VGND VGND VPWR VPWR net282 sky130_fd_sc_hd__buf_6
Xfanout271 net273 VGND VGND VPWR VPWR net271 sky130_fd_sc_hd__buf_1
XFILLER_115_93 VPWR VGND VPWR VGND sky130_ef_sc_hd__decap_12
XFILLER_74_442 VPWR VGND VPWR VGND sky130_ef_sc_hd__decap_12
XTAP_TAPCELL_ROW_70_1093 VGND VPWR sky130_fd_sc_hd__tapvpwrvgnd_1
XFILLER_47_645 VGND VGND VPWR VPWR sky130_fd_sc_hd__decap_4
Xfanout293 net294 VGND VGND VPWR VPWR net293 sky130_fd_sc_hd__clkbuf_4
XTAP_TAPCELL_ROW_109_1557 VGND VPWR sky130_fd_sc_hd__tapvpwrvgnd_1
XFILLER_46_188 VGND VGND VPWR VPWR sky130_fd_sc_hd__fill_2
XFILLER_61_169 VGND VGND VPWR VPWR sky130_fd_sc_hd__fill_2
XTAP_TAPCELL_ROW_53_890 VGND VPWR sky130_fd_sc_hd__tapvpwrvgnd_1
XFILLER_42_394 VGND VGND VPWR VPWR sky130_fd_sc_hd__fill_2
XFILLER_115_105 VGND VGND VPWR VPWR sky130_fd_sc_hd__decap_6
XFILLER_69_225 VGND VGND VPWR VPWR sky130_fd_sc_hd__decap_6
X_5120_ _0857_ _0858_ _0859_ VGND VGND VPWR VPWR _0860_ sky130_fd_sc_hd__and3_1
XFILLER_34_3 VGND VGND VPWR VPWR sky130_fd_sc_hd__decap_4
X_5051_ _0789_ _0790_ _0750_ _0752_ VGND VGND VPWR VPWR _0793_ sky130_fd_sc_hd__a211o_1
XFILLER_38_601 VPWR VGND VPWR VGND sky130_ef_sc_hd__decap_12
XTAP_TAPCELL_ROW_88_1310 VGND VPWR sky130_fd_sc_hd__tapvpwrvgnd_1
XFILLER_37_111 VGND VGND VPWR VPWR sky130_fd_sc_hd__fill_1
XFILLER_38_645 VPWR VGND VPWR VGND sky130_ef_sc_hd__decap_12
X_8810_ net159 _4170_ _4168_ VGND VGND VPWR VPWR _4180_ sky130_fd_sc_hd__a21oi_1
XFILLER_65_464 VPWR VGND VPWR VGND sky130_ef_sc_hd__decap_12
XFILLER_38_678 VGND VGND VPWR VPWR sky130_fd_sc_hd__fill_2
X_8741_ _4112_ _4113_ VGND VGND VPWR VPWR _4114_ sky130_fd_sc_hd__nor2_1
XFILLER_37_188 VGND VGND VPWR VPWR sky130_fd_sc_hd__fill_1
XFILLER_37_199 VPWR VGND VPWR VGND sky130_ef_sc_hd__decap_12
XFILLER_80_456 VGND VGND VPWR VPWR sky130_fd_sc_hd__fill_1
X_5953_ _1481_ _1487_ _1488_ VGND VGND VPWR VPWR _1489_ sky130_fd_sc_hd__nand3_1
XFILLER_53_659 VGND VGND VPWR VPWR sky130_fd_sc_hd__fill_1
X_8672_ _4045_ _4046_ VGND VGND VPWR VPWR _4047_ sky130_fd_sc_hd__xnor2_1
X_5884_ _1381_ _1385_ _1387_ VGND VGND VPWR VPWR _1421_ sky130_fd_sc_hd__a21oi_1
XTAP_TAPCELL_ROW_23_529 VGND VPWR sky130_fd_sc_hd__tapvpwrvgnd_1
XFILLER_40_309 VGND VGND VPWR VPWR sky130_fd_sc_hd__decap_3
X_4904_ _0598_ _0649_ VGND VGND VPWR VPWR _0650_ sky130_fd_sc_hd__nor2_1
XFILLER_21_534 VGND VGND VPWR VPWR sky130_fd_sc_hd__decap_3
X_7623_ _2964_ _2962_ _3070_ _3071_ VGND VGND VPWR VPWR _3072_ sky130_fd_sc_hd__a211o_4
X_4835_ _0565_ _0580_ _0581_ VGND VGND VPWR VPWR _0583_ sky130_fd_sc_hd__nand3_1
X_7554_ _2975_ _2977_ _3004_ VGND VGND VPWR VPWR _3006_ sky130_fd_sc_hd__nor3_1
X_4766_ _0508_ _0513_ VGND VGND VPWR VPWR _0515_ sky130_fd_sc_hd__xor2_1
X_6505_ net177 _1997_ _1996_ VGND VGND VPWR VPWR _2025_ sky130_fd_sc_hd__a21oi_1
XFILLER_20_15 VGND VGND VPWR VPWR sky130_fd_sc_hd__decap_6
X_7485_ _2937_ _2938_ VGND VGND VPWR VPWR _2939_ sky130_fd_sc_hd__nor2_1
X_4697_ _0441_ _0446_ _0447_ VGND VGND VPWR VPWR _0448_ sky130_fd_sc_hd__nand3_2
X_6436_ _1955_ _1956_ _1923_ _1924_ VGND VGND VPWR VPWR _1958_ sky130_fd_sc_hd__a211oi_1
X_9224_ clknet_leaf_41_clk _0336_ VGND VGND VPWR VPWR pe_accum\[1\]\[10\] sky130_fd_sc_hd__dfxtp_1
X_6367_ _1835_ _1866_ _1865_ VGND VGND VPWR VPWR _1892_ sky130_fd_sc_hd__a21o_1
X_9155_ clknet_leaf_18_clk _0267_ VGND VGND VPWR VPWR pe_accum\[0\]\[9\] sky130_fd_sc_hd__dfxtp_1
XFILLER_88_523 VGND VGND VPWR VPWR sky130_fd_sc_hd__decap_8
X_8106_ net470 net311 net308 net476 VGND VGND VPWR VPWR _3497_ sky130_fd_sc_hd__a22oi_1
X_5318_ net748 _1049_ VGND VGND VPWR VPWR _1051_ sky130_fd_sc_hd__xnor2_1
XFILLER_102_344 VGND VGND VPWR VPWR sky130_fd_sc_hd__decap_8
X_6298_ _1822_ _1823_ net174 VGND VGND VPWR VPWR _1825_ sky130_fd_sc_hd__o21ai_1
XFILLER_0_449 VPWR VGND VPWR VGND sky130_ef_sc_hd__decap_12
X_9086_ clknet_leaf_66_clk _0198_ VGND VGND VPWR VPWR net36 sky130_fd_sc_hd__dfxtp_1
XFILLER_102_388 VGND VGND VPWR VPWR sky130_fd_sc_hd__fill_1
XFILLER_102_377 VGND VGND VPWR VPWR sky130_fd_sc_hd__decap_4
XFILLER_88_589 VGND VGND VPWR VPWR sky130_fd_sc_hd__fill_2
X_8037_ _3427_ _3428_ _3370_ _3373_ VGND VGND VPWR VPWR _3430_ sky130_fd_sc_hd__a211o_1
X_5249_ _0776_ _0811_ _0982_ _0895_ VGND VGND VPWR VPWR _0984_ sky130_fd_sc_hd__nand4b_1
XFILLER_29_57 VGND VGND VPWR VPWR sky130_fd_sc_hd__fill_2
XFILLER_68_291 VGND VGND VPWR VPWR sky130_fd_sc_hd__decap_4
XFILLER_29_79 VGND VGND VPWR VPWR sky130_fd_sc_hd__decap_6
XFILLER_29_656 VGND VGND VPWR VPWR sky130_fd_sc_hd__fill_2
XTAP_TAPCELL_ROW_3_287 VGND VPWR sky130_fd_sc_hd__tapvpwrvgnd_1
XFILLER_29_689 VGND VGND VPWR VPWR sky130_fd_sc_hd__fill_2
XFILLER_71_401 VPWR VGND VPWR VGND sky130_ef_sc_hd__decap_12
XFILLER_44_648 VGND VGND VPWR VPWR sky130_fd_sc_hd__decap_4
X_8939_ clknet_leaf_59_clk _0051_ VGND VGND VPWR VPWR pe_accum\[3\]\[7\] sky130_fd_sc_hd__dfxtp_1
XFILLER_43_158 VGND VGND VPWR VPWR sky130_fd_sc_hd__fill_2
XFILLER_12_501 VPWR VGND VPWR VGND sky130_ef_sc_hd__decap_12
XFILLER_43_169 VGND VGND VPWR VPWR sky130_fd_sc_hd__fill_2
XTAP_TAPCELL_ROW_104_1498 VGND VPWR sky130_fd_sc_hd__tapvpwrvgnd_1
XFILLER_61_77 VGND VGND VPWR VPWR sky130_fd_sc_hd__fill_2
XFILLER_61_55 VGND VGND VPWR VPWR sky130_fd_sc_hd__fill_1
XFILLER_12_589 VGND VGND VPWR VPWR sky130_fd_sc_hd__decap_6
XFILLER_3_210 VGND VGND VPWR VPWR sky130_fd_sc_hd__decap_4
XFILLER_113_609 VGND VGND VPWR VPWR sky130_fd_sc_hd__decap_6
XFILLER_98_309 VPWR VGND VPWR VGND sky130_ef_sc_hd__decap_12
XFILLER_79_501 VGND VGND VPWR VPWR sky130_fd_sc_hd__decap_3
XTAP_TAPCELL_ROW_72_1122 VGND VPWR sky130_fd_sc_hd__tapvpwrvgnd_1
XFILLER_94_515 VGND VGND VPWR VPWR sky130_fd_sc_hd__fill_1
XFILLER_86_85 VGND VGND VPWR VPWR sky130_fd_sc_hd__fill_2
XFILLER_74_261 VGND VGND VPWR VPWR sky130_fd_sc_hd__fill_1
XFILLER_62_412 VGND VGND VPWR VPWR sky130_fd_sc_hd__fill_2
XFILLER_19_166 VGND VGND VPWR VPWR sky130_fd_sc_hd__fill_2
XFILLER_35_626 VGND VGND VPWR VPWR sky130_fd_sc_hd__decap_8
XFILLER_74_294 VGND VGND VPWR VPWR sky130_fd_sc_hd__decap_8
XFILLER_62_467 VGND VGND VPWR VPWR sky130_fd_sc_hd__decap_8
XTAP_TAPCELL_ROW_83_1251 VGND VPWR sky130_fd_sc_hd__tapvpwrvgnd_1
XFILLER_62_489 VPWR VGND VPWR VGND sky130_ef_sc_hd__decap_12
XFILLER_15_361 VPWR VGND VPWR VGND sky130_ef_sc_hd__decap_12
XFILLER_22_309 VPWR VGND VPWR VGND sky130_ef_sc_hd__decap_12
X_4620_ _4382_ _4381_ _4325_ VGND VGND VPWR VPWR _4383_ sky130_fd_sc_hd__nand3_4
X_4551_ _4285_ _4315_ VGND VGND VPWR VPWR _4316_ sky130_fd_sc_hd__xnor2_1
Xhold505 pe_array\[0\].u_pe.tap_count\[3\] VGND VGND VPWR VPWR net1020 sky130_fd_sc_hd__dlygate4sd3_1
Xhold516 pe_array\[1\].u_pe.tap_count\[1\] VGND VGND VPWR VPWR net1031 sky130_fd_sc_hd__dlygate4sd3_1
X_7270_ pe_array\[1\].u_pe.accum_reg\[16\] net446 net338 VGND VGND VPWR VPWR _2731_
+ sky130_fd_sc_hd__and3_1
X_4482_ pe_array\[3\].u_pe.accum_reg\[0\] net306 net509 VGND VGND VPWR VPWR _4251_
+ sky130_fd_sc_hd__and3_1
XFILLER_116_469 VGND VGND VPWR VPWR sky130_fd_sc_hd__decap_6
X_6221_ _1711_ _1712_ _1742_ _1749_ VGND VGND VPWR VPWR _1750_ sky130_fd_sc_hd__a31o_1
XTAP_TAPCELL_ROW_94_1380 VGND VPWR sky130_fd_sc_hd__tapvpwrvgnd_1
X_6152_ net655 _1680_ VGND VGND VPWR VPWR _1683_ sky130_fd_sc_hd__xor2_1
XFILLER_106_29 VPWR VGND VPWR VGND sky130_ef_sc_hd__decap_12
X_5103_ net397 pe_array\[3\].u_pe.accum_reg\[18\] _0843_ net255 VGND VGND VPWR VPWR
+ _0844_ sky130_fd_sc_hd__o2bb2a_4
XFILLER_97_386 VGND VGND VPWR VPWR sky130_fd_sc_hd__decap_3
X_6083_ _1570_ _1571_ _1613_ _1614_ VGND VGND VPWR VPWR _1616_ sky130_fd_sc_hd__o211ai_1
XFILLER_97_397 VGND VGND VPWR VPWR sky130_fd_sc_hd__fill_1
X_5034_ _0713_ _0746_ VGND VGND VPWR VPWR _0777_ sky130_fd_sc_hd__nand2_1
XFILLER_93_581 VGND VGND VPWR VPWR sky130_fd_sc_hd__decap_3
XFILLER_53_401 VGND VGND VPWR VPWR sky130_fd_sc_hd__decap_6
XTAP_TAPCELL_ROW_0_246 VGND VPWR sky130_fd_sc_hd__tapvpwrvgnd_1
XTAP_TAPCELL_ROW_0_257 VGND VPWR sky130_fd_sc_hd__tapvpwrvgnd_1
X_6985_ _2444_ _2452_ VGND VGND VPWR VPWR _2453_ sky130_fd_sc_hd__nand2b_1
X_8724_ pe_array\[2\].u_pe.accum_reg\[28\] _3508_ VGND VGND VPWR VPWR _4097_ sky130_fd_sc_hd__nor2_1
XFILLER_80_253 VGND VGND VPWR VPWR sky130_fd_sc_hd__fill_2
X_5936_ _1470_ _1471_ VGND VGND VPWR VPWR _1472_ sky130_fd_sc_hd__xor2_1
XFILLER_15_15 VPWR VGND VPWR VGND sky130_ef_sc_hd__decap_12
XTAP_TAPCELL_ROW_36_687 VGND VPWR sky130_fd_sc_hd__tapvpwrvgnd_1
XFILLER_41_629 VPWR VGND VPWR VGND sky130_ef_sc_hd__decap_12
X_8655_ _4028_ _4029_ VGND VGND VPWR VPWR _4031_ sky130_fd_sc_hd__xnor2_1
X_5867_ _1388_ _1404_ VGND VGND VPWR VPWR _1405_ sky130_fd_sc_hd__nor2_1
XFILLER_21_364 VGND VGND VPWR VPWR sky130_fd_sc_hd__decap_6
X_7606_ net167 _3054_ VGND VGND VPWR VPWR _3056_ sky130_fd_sc_hd__nand2_1
X_8586_ _3960_ _3961_ _3962_ VGND VGND VPWR VPWR _3964_ sky130_fd_sc_hd__a21o_1
X_5798_ _1336_ _1337_ VGND VGND VPWR VPWR _1338_ sky130_fd_sc_hd__nand2_1
X_4818_ net293 net435 VGND VGND VPWR VPWR _0566_ sky130_fd_sc_hd__and2_1
X_7537_ _2988_ _2989_ VGND VGND VPWR VPWR _2990_ sky130_fd_sc_hd__nand2_2
X_4749_ _0496_ _0497_ _4442_ _0434_ VGND VGND VPWR VPWR _0499_ sky130_fd_sc_hd__o211a_1
XFILLER_107_447 VGND VGND VPWR VPWR sky130_fd_sc_hd__fill_1
X_7468_ _2922_ _2921_ VGND VGND VPWR VPWR _2923_ sky130_fd_sc_hd__and2b_1
X_6419_ _1939_ _1940_ VGND VGND VPWR VPWR _1942_ sky130_fd_sc_hd__xor2_1
Xoutput25 net25 VGND VGND VPWR VPWR result_data[102] sky130_fd_sc_hd__buf_2
X_9207_ clknet_leaf_42_clk _0319_ VGND VGND VPWR VPWR pe_array\[1\].u_pe.accum_reg\[25\]
+ sky130_fd_sc_hd__dfxtp_1
Xoutput58 net58 VGND VGND VPWR VPWR result_data[17] sky130_fd_sc_hd__buf_2
X_7399_ _2824_ _2825_ _2854_ _2855_ VGND VGND VPWR VPWR _2856_ sky130_fd_sc_hd__o211a_1
Xoutput47 net47 VGND VGND VPWR VPWR result_data[122] sky130_fd_sc_hd__buf_2
Xoutput36 net36 VGND VGND VPWR VPWR result_data[112] sky130_fd_sc_hd__buf_2
Xoutput69 net69 VGND VGND VPWR VPWR result_data[27] sky130_fd_sc_hd__buf_2
XFILLER_103_653 VGND VGND VPWR VPWR sky130_fd_sc_hd__fill_1
X_9138_ clknet_leaf_23_clk _0250_ VGND VGND VPWR VPWR pe_array\[0\].u_pe.accum_reg\[24\]
+ sky130_fd_sc_hd__dfxtp_1
XTAP_TAPCELL_ROW_8_346 VGND VPWR sky130_fd_sc_hd__tapvpwrvgnd_1
X_9069_ clknet_leaf_11_clk _0181_ VGND VGND VPWR VPWR net144 sky130_fd_sc_hd__dfxtp_1
XFILLER_88_353 VGND VGND VPWR VPWR sky130_fd_sc_hd__decap_6
XFILLER_76_515 VGND VGND VPWR VPWR sky130_fd_sc_hd__decap_6
XFILLER_0_279 VGND VGND VPWR VPWR sky130_fd_sc_hd__fill_1
XTAP_TAPCELL_ROW_106_1527 VGND VPWR sky130_fd_sc_hd__tapvpwrvgnd_1
XFILLER_91_529 VPWR VGND VPWR VGND sky130_ef_sc_hd__decap_12
XFILLER_84_570 VGND VGND VPWR VPWR sky130_fd_sc_hd__decap_3
XFILLER_56_261 VGND VGND VPWR VPWR sky130_fd_sc_hd__decap_3
XFILLER_56_77 VGND VGND VPWR VPWR sky130_fd_sc_hd__decap_6
XFILLER_16_114 VGND VGND VPWR VPWR sky130_fd_sc_hd__decap_8
XFILLER_17_659 VGND VGND VPWR VPWR sky130_fd_sc_hd__fill_1
XFILLER_112_83 VGND VGND VPWR VPWR sky130_fd_sc_hd__fill_1
XFILLER_44_489 VPWR VGND VPWR VGND sky130_ef_sc_hd__decap_12
XFILLER_8_302 VGND VGND VPWR VPWR sky130_fd_sc_hd__decap_6
XFILLER_8_379 VPWR VGND VPWR VGND sky130_ef_sc_hd__decap_12
XTAP_TAPCELL_ROW_117_1656 VGND VPWR sky130_fd_sc_hd__tapvpwrvgnd_1
XTAP_TAPCELL_ROW_117_1667 VGND VPWR sky130_fd_sc_hd__tapvpwrvgnd_1
XFILLER_113_406 VGND VGND VPWR VPWR sky130_fd_sc_hd__fill_1
XFILLER_98_106 VGND VGND VPWR VPWR sky130_fd_sc_hd__decap_6
XFILLER_98_139 VGND VGND VPWR VPWR sky130_fd_sc_hd__fill_1
XFILLER_97_51 VGND VGND VPWR VPWR sky130_fd_sc_hd__fill_1
XFILLER_94_345 VGND VGND VPWR VPWR sky130_fd_sc_hd__decap_3
XFILLER_82_507 VGND VGND VPWR VPWR sky130_fd_sc_hd__decap_6
XFILLER_54_209 VPWR VGND VPWR VGND sky130_ef_sc_hd__decap_12
XFILLER_35_423 VGND VGND VPWR VPWR sky130_fd_sc_hd__decap_4
XFILLER_47_250 VGND VGND VPWR VPWR sky130_fd_sc_hd__fill_2
XFILLER_62_253 VGND VGND VPWR VPWR sky130_fd_sc_hd__decap_4
X_6770_ _2241_ _2242_ _2224_ _2225_ VGND VGND VPWR VPWR _2244_ sky130_fd_sc_hd__a211o_1
XFILLER_50_415 VGND VGND VPWR VPWR sky130_fd_sc_hd__decap_4
X_5721_ _1250_ _1263_ VGND VGND VPWR VPWR _1264_ sky130_fd_sc_hd__nor2_1
XFILLER_22_139 VGND VGND VPWR VPWR sky130_fd_sc_hd__fill_1
XTAP_TAPCELL_ROW_33_646 VGND VPWR sky130_fd_sc_hd__tapvpwrvgnd_1
XTAP_TAPCELL_ROW_61_988 VGND VPWR sky130_fd_sc_hd__tapvpwrvgnd_1
X_8440_ _3821_ _3822_ VGND VGND VPWR VPWR _3823_ sky130_fd_sc_hd__nor2_2
X_5652_ net933 net365 VGND VGND VPWR VPWR _0193_ sky130_fd_sc_hd__and2_1
X_8371_ _3754_ _3755_ VGND VGND VPWR VPWR _3756_ sky130_fd_sc_hd__nand2_1
X_5583_ net1016 net378 VGND VGND VPWR VPWR _0124_ sky130_fd_sc_hd__and2_1
X_4603_ _4362_ _4365_ VGND VGND VPWR VPWR _4366_ sky130_fd_sc_hd__xnor2_1
X_7322_ net165 _2743_ _2742_ VGND VGND VPWR VPWR _2782_ sky130_fd_sc_hd__o21bai_1
X_4534_ net304 net487 net479 net306 VGND VGND VPWR VPWR _4299_ sky130_fd_sc_hd__a22oi_1
X_4465_ net17 _4240_ _4241_ net348 VGND VGND VPWR VPWR _0004_ sky130_fd_sc_hd__a22o_1
X_7253_ net165 _2713_ _2714_ VGND VGND VPWR VPWR _2715_ sky130_fd_sc_hd__or3_4
X_6204_ _1685_ _1698_ _1697_ VGND VGND VPWR VPWR _1734_ sky130_fd_sc_hd__a21bo_1
Xhold379 pe_accum\[0\]\[12\] VGND VGND VPWR VPWR net894 sky130_fd_sc_hd__dlygate4sd3_1
X_7184_ _2582_ _2584_ _2646_ _2647_ VGND VGND VPWR VPWR _2648_ sky130_fd_sc_hd__a211oi_2
XFILLER_100_601 VGND VGND VPWR VPWR sky130_fd_sc_hd__fill_1
XFILLER_97_161 VGND VGND VPWR VPWR sky130_fd_sc_hd__decap_6
X_6135_ _1664_ _1665_ _1606_ _1608_ VGND VGND VPWR VPWR _1667_ sky130_fd_sc_hd__o211a_1
XTAP_TAPCELL_ROW_5_316 VGND VPWR sky130_fd_sc_hd__tapvpwrvgnd_1
X_6066_ net349 net730 _1477_ VGND VGND VPWR VPWR _1599_ sky130_fd_sc_hd__a21oi_2
X_5017_ net206 _0727_ _0725_ VGND VGND VPWR VPWR _0760_ sky130_fd_sc_hd__a21o_1
XFILLER_73_529 VGND VGND VPWR VPWR sky130_fd_sc_hd__fill_1
XFILLER_66_581 VGND VGND VPWR VPWR sky130_fd_sc_hd__decap_6
XFILLER_26_412 VGND VGND VPWR VPWR sky130_fd_sc_hd__decap_8
XFILLER_26_456 VGND VGND VPWR VPWR sky130_fd_sc_hd__decap_6
X_8707_ _4064_ _4079_ VGND VGND VPWR VPWR _4081_ sky130_fd_sc_hd__xnor2_1
XFILLER_13_139 VGND VGND VPWR VPWR sky130_fd_sc_hd__fill_1
X_6968_ _2435_ _2436_ VGND VGND VPWR VPWR _2437_ sky130_fd_sc_hd__xnor2_1
X_5919_ _1421_ _1454_ _1455_ VGND VGND VPWR VPWR _1456_ sky130_fd_sc_hd__nor3_4
X_6899_ pe_array\[1\].u_pe.accum_reg\[7\] pe_array\[1\].u_pe.weight_in\[7\] VGND VGND
+ VPWR VPWR _2369_ sky130_fd_sc_hd__nand2_1
XTAP_TAPCELL_ROW_101_1468 VGND VPWR sky130_fd_sc_hd__tapvpwrvgnd_1
X_8638_ net264 _4012_ _4013_ VGND VGND VPWR VPWR _4014_ sky130_fd_sc_hd__or3_1
X_8569_ net420 _3947_ VGND VGND VPWR VPWR _0392_ sky130_fd_sc_hd__nor2_1
XFILLER_5_327 VGND VGND VPWR VPWR sky130_fd_sc_hd__decap_8
XFILLER_101_3 VPWR VGND VPWR VGND sky130_ef_sc_hd__decap_12
XFILLER_89_673 VGND VGND VPWR VPWR sky130_fd_sc_hd__decap_8
XFILLER_67_32 VGND VGND VPWR VPWR sky130_fd_sc_hd__fill_1
XTAP_TAPCELL_ROW_112_1597 VGND VPWR sky130_fd_sc_hd__tapvpwrvgnd_1
XFILLER_76_334 VGND VGND VPWR VPWR sky130_fd_sc_hd__decap_8
XFILLER_64_507 VGND VGND VPWR VPWR sky130_fd_sc_hd__decap_6
XFILLER_29_261 VGND VGND VPWR VPWR sky130_fd_sc_hd__fill_1
XFILLER_91_337 VGND VGND VPWR VPWR sky130_fd_sc_hd__fill_2
XFILLER_83_42 VPWR VGND VPWR VGND sky130_ef_sc_hd__decap_12
XTAP_TAPCELL_ROW_67_1054 VGND VPWR sky130_fd_sc_hd__tapvpwrvgnd_1
XTAP_TAPCELL_ROW_80_1210 VGND VPWR sky130_fd_sc_hd__tapvpwrvgnd_1
XFILLER_32_448 VGND VGND VPWR VPWR sky130_fd_sc_hd__fill_1
XPHY_EDGE_ROW_17_Left_135 VGND VGND VPWR VPWR sky130_fd_sc_hd__decap_3
XFILLER_9_644 VPWR VGND VPWR VGND sky130_ef_sc_hd__decap_12
XTAP_TAPCELL_ROW_30_616 VGND VPWR sky130_fd_sc_hd__tapvpwrvgnd_1
XTAP_TAPCELL_ROW_10_373 VGND VPWR sky130_fd_sc_hd__tapvpwrvgnd_1
XTAP_TAPCELL_ROW_78_1194 VGND VPWR sky130_fd_sc_hd__tapvpwrvgnd_1
XFILLER_99_459 VGND VGND VPWR VPWR sky130_fd_sc_hd__fill_1
XFILLER_4_393 VPWR VGND VPWR VGND sky130_ef_sc_hd__decap_12
XPHY_EDGE_ROW_26_Left_144 VGND VGND VPWR VPWR sky130_fd_sc_hd__decap_3
XTAP_TAPCELL_ROW_91_1350 VGND VPWR sky130_fd_sc_hd__tapvpwrvgnd_1
XFILLER_95_610 VGND VGND VPWR VPWR sky130_fd_sc_hd__decap_6
XFILLER_94_153 VPWR VGND VPWR VGND sky130_ef_sc_hd__decap_12
XFILLER_67_345 VGND VGND VPWR VPWR sky130_fd_sc_hd__fill_2
X_7940_ net474 net467 net322 net324 VGND VGND VPWR VPWR _3335_ sky130_fd_sc_hd__and4_1
XFILLER_55_529 VPWR VGND VPWR VGND sky130_ef_sc_hd__decap_12
XTAP_TAPCELL_ROW_38_705 VGND VPWR sky130_fd_sc_hd__tapvpwrvgnd_1
XFILLER_94_197 VGND VGND VPWR VPWR sky130_fd_sc_hd__decap_4
X_7871_ _3265_ _3266_ net496 net320 VGND VGND VPWR VPWR _3268_ sky130_fd_sc_hd__or4bb_4
X_6822_ pe_array\[1\].u_pe.accum_reg\[5\] net473 net343 VGND VGND VPWR VPWR _2294_
+ sky130_fd_sc_hd__nand3_1
XFILLER_63_584 VPWR VGND VPWR VGND sky130_ef_sc_hd__decap_12
XTAP_TAPCELL_ROW_18_473 VGND VPWR sky130_fd_sc_hd__tapvpwrvgnd_1
XFILLER_23_437 VGND VGND VPWR VPWR sky130_fd_sc_hd__fill_1
XPHY_EDGE_ROW_35_Left_153 VGND VGND VPWR VPWR sky130_fd_sc_hd__decap_3
X_6753_ _2216_ _2217_ VGND VGND VPWR VPWR _2228_ sky130_fd_sc_hd__nor2_1
X_6684_ _2184_ _2181_ _2197_ VGND VGND VPWR VPWR _2198_ sky130_fd_sc_hd__and3_1
X_5704_ net514 net354 _1245_ _1246_ VGND VGND VPWR VPWR _1248_ sky130_fd_sc_hd__o2bb2a_1
X_5635_ net970 net384 VGND VGND VPWR VPWR _0176_ sky130_fd_sc_hd__and2_1
X_8423_ net188 _3803_ _3805_ VGND VGND VPWR VPWR _3806_ sky130_fd_sc_hd__or3b_1
XFILLER_12_27 VGND VGND VPWR VPWR sky130_fd_sc_hd__fill_1
XFILLER_117_520 VGND VGND VPWR VPWR sky130_fd_sc_hd__decap_3
X_5566_ net941 net395 VGND VGND VPWR VPWR _0107_ sky130_fd_sc_hd__and2_1
X_8354_ _3735_ _3736_ _3704_ _3705_ VGND VGND VPWR VPWR _3739_ sky130_fd_sc_hd__a211o_1
X_8285_ pe_array\[2\].u_pe.accum_reg\[14\] net439 net313 VGND VGND VPWR VPWR _3672_
+ sky130_fd_sc_hd__and3_1
X_7305_ net425 _2765_ VGND VGND VPWR VPWR _0310_ sky130_fd_sc_hd__nor2_1
X_5497_ net249 _0748_ VGND VGND VPWR VPWR _1209_ sky130_fd_sc_hd__nand2_1
X_4517_ _4280_ _4281_ _4262_ VGND VGND VPWR VPWR _4283_ sky130_fd_sc_hd__a21o_1
XPHY_EDGE_ROW_44_Left_162 VGND VGND VPWR VPWR sky130_fd_sc_hd__decap_3
X_4448_ net462 VGND VGND VPWR VPWR _4229_ sky130_fd_sc_hd__inv_2
X_7236_ net170 VGND VGND VPWR VPWR _2698_ sky130_fd_sc_hd__inv_2
X_7167_ net446 net339 pe_array\[1\].u_pe.accum_reg\[13\] VGND VGND VPWR VPWR _2631_
+ sky130_fd_sc_hd__a21oi_1
XFILLER_86_643 VGND VGND VPWR VPWR sky130_fd_sc_hd__fill_1
X_6118_ pe_array\[0\].u_pe.accum_reg\[13\] net458 net361 VGND VGND VPWR VPWR _1650_
+ sky130_fd_sc_hd__and3_1
XFILLER_37_24 VGND VGND VPWR VPWR sky130_fd_sc_hd__decap_4
X_7098_ _2518_ _2520_ net520 net538 VGND VGND VPWR VPWR _2564_ sky130_fd_sc_hd__o211ai_4
XFILLER_46_507 VPWR VGND VPWR VGND sky130_ef_sc_hd__decap_12
XFILLER_100_486 VGND VGND VPWR VPWR sky130_fd_sc_hd__decap_8
XFILLER_100_475 VGND VGND VPWR VPWR sky130_fd_sc_hd__fill_1
X_6049_ _1580_ _1581_ _1566_ VGND VGND VPWR VPWR _1583_ sky130_fd_sc_hd__a21o_1
XFILLER_37_57 VPWR VGND VPWR VGND sky130_ef_sc_hd__decap_12
XFILLER_73_337 VPWR VGND VPWR VGND sky130_ef_sc_hd__decap_12
XPHY_EDGE_ROW_53_Left_171 VGND VGND VPWR VPWR sky130_fd_sc_hd__decap_3
XFILLER_26_286 VGND VGND VPWR VPWR sky130_fd_sc_hd__decap_3
XFILLER_41_289 VGND VGND VPWR VPWR sky130_fd_sc_hd__decap_3
XFILLER_10_621 VGND VGND VPWR VPWR sky130_fd_sc_hd__decap_4
XFILLER_5_113 VGND VGND VPWR VPWR sky130_fd_sc_hd__decap_6
XFILLER_108_531 VGND VGND VPWR VPWR sky130_fd_sc_hd__fill_1
XPHY_EDGE_ROW_62_Left_180 VGND VGND VPWR VPWR sky130_fd_sc_hd__decap_3
XFILLER_6_669 VPWR VGND VPWR VGND sky130_ef_sc_hd__decap_12
XTAP_TAPCELL_ROW_114_1626 VGND VPWR sky130_fd_sc_hd__tapvpwrvgnd_1
XFILLER_108_564 VGND VGND VPWR VPWR sky130_fd_sc_hd__decap_4
XFILLER_108_597 VPWR VGND VPWR VGND sky130_ef_sc_hd__decap_12
XFILLER_89_470 VPWR VGND VPWR VGND sky130_ef_sc_hd__decap_12
XFILLER_77_665 VGND VGND VPWR VPWR sky130_fd_sc_hd__decap_6
XFILLER_49_334 VGND VGND VPWR VPWR sky130_fd_sc_hd__fill_2
XFILLER_92_613 VPWR VGND VPWR VGND sky130_ef_sc_hd__decap_12
XFILLER_49_389 VGND VGND VPWR VPWR sky130_fd_sc_hd__decap_3
XFILLER_94_85 VGND VGND VPWR VPWR sky130_fd_sc_hd__fill_2
XFILLER_76_197 VGND VGND VPWR VPWR sky130_fd_sc_hd__decap_8
XFILLER_64_359 VGND VGND VPWR VPWR sky130_fd_sc_hd__decap_4
XFILLER_17_275 VGND VGND VPWR VPWR sky130_fd_sc_hd__decap_4
XTAP_TAPCELL_ROW_15_432 VGND VPWR sky130_fd_sc_hd__tapvpwrvgnd_1
XFILLER_20_418 VGND VGND VPWR VPWR sky130_fd_sc_hd__fill_2
XTAP_TAPCELL_ROW_43_774 VGND VPWR sky130_fd_sc_hd__tapvpwrvgnd_1
XFILLER_9_441 VGND VGND VPWR VPWR sky130_fd_sc_hd__decap_6
XFILLER_13_492 VGND VGND VPWR VPWR sky130_fd_sc_hd__decap_6
XFILLER_64_3 VPWR VGND VPWR VGND sky130_ef_sc_hd__decap_12
X_5420_ _1118_ _1149_ VGND VGND VPWR VPWR _1150_ sky130_fd_sc_hd__or2_1
X_5351_ net181 _1054_ _1052_ VGND VGND VPWR VPWR _1083_ sky130_fd_sc_hd__a21oi_1
X_8070_ _3423_ _3430_ _3429_ VGND VGND VPWR VPWR _3462_ sky130_fd_sc_hd__a21bo_1
X_5282_ _1013_ _1014_ net653 VGND VGND VPWR VPWR _1016_ sky130_fd_sc_hd__o21ai_1
X_7021_ net465 _2455_ _2457_ _2458_ VGND VGND VPWR VPWR _2488_ sky130_fd_sc_hd__o2bb2a_1
XFILLER_114_589 VPWR VGND VPWR VGND sky130_ef_sc_hd__decap_12
XFILLER_101_228 VGND VGND VPWR VPWR sky130_fd_sc_hd__decap_8
XFILLER_87_429 VGND VGND VPWR VPWR sky130_fd_sc_hd__decap_6
XFILLER_4_83 VGND VGND VPWR VPWR sky130_fd_sc_hd__fill_1
XFILLER_114_29 VPWR VGND VPWR VGND sky130_ef_sc_hd__decap_12
XFILLER_95_440 VGND VGND VPWR VPWR sky130_fd_sc_hd__decap_8
XFILLER_68_643 VGND VGND VPWR VPWR sky130_fd_sc_hd__fill_1
XFILLER_67_120 VGND VGND VPWR VPWR sky130_fd_sc_hd__fill_1
X_8972_ clknet_leaf_54_clk _0084_ VGND VGND VPWR VPWR pe_array\[1\].u_pe.weight_in\[7\]
+ sky130_fd_sc_hd__dfxtp_1
X_7923_ _3285_ _3316_ VGND VGND VPWR VPWR _3319_ sky130_fd_sc_hd__nor2_1
XFILLER_83_668 VGND VGND VPWR VPWR sky130_fd_sc_hd__decap_4
XFILLER_55_326 VGND VGND VPWR VPWR sky130_fd_sc_hd__decap_8
XFILLER_36_540 VGND VGND VPWR VPWR sky130_fd_sc_hd__fill_1
X_7854_ _3250_ _3251_ VGND VGND VPWR VPWR _3252_ sky130_fd_sc_hd__nand2b_1
XFILLER_70_329 VGND VGND VPWR VPWR sky130_fd_sc_hd__fill_2
XFILLER_23_223 VGND VGND VPWR VPWR sky130_fd_sc_hd__fill_1
X_6805_ _2250_ _2276_ VGND VGND VPWR VPWR _2278_ sky130_fd_sc_hd__nand2_1
XFILLER_51_554 VGND VGND VPWR VPWR sky130_fd_sc_hd__decap_6
X_7785_ net225 _3104_ VGND VGND VPWR VPWR _3202_ sky130_fd_sc_hd__nand2_1
X_6736_ _2211_ _2212_ VGND VGND VPWR VPWR _2213_ sky130_fd_sc_hd__or2_1
XFILLER_11_429 VPWR VGND VPWR VGND sky130_ef_sc_hd__decap_12
XFILLER_23_15 VGND VGND VPWR VPWR sky130_fd_sc_hd__decap_4
X_4997_ _0738_ _0739_ _0740_ VGND VGND VPWR VPWR _0741_ sky130_fd_sc_hd__and3_1
XFILLER_109_317 VPWR VGND VPWR VGND sky130_ef_sc_hd__decap_12
X_6667_ _2152_ _2180_ VGND VGND VPWR VPWR _2182_ sky130_fd_sc_hd__or2_1
X_6598_ _2114_ _2113_ VGND VGND VPWR VPWR _2115_ sky130_fd_sc_hd__and2b_1
X_8406_ _3748_ _3750_ VGND VGND VPWR VPWR _3790_ sky130_fd_sc_hd__and2_1
X_5618_ net963 net380 VGND VGND VPWR VPWR _0159_ sky130_fd_sc_hd__and2_1
X_5549_ net897 net392 VGND VGND VPWR VPWR _0090_ sky130_fd_sc_hd__and2_1
X_8337_ _3663_ _3688_ _3687_ VGND VGND VPWR VPWR _3723_ sky130_fd_sc_hd__o21ba_1
XFILLER_3_617 VPWR VGND VPWR VGND sky130_ef_sc_hd__decap_12
XFILLER_2_138 VGND VGND VPWR VPWR sky130_fd_sc_hd__fill_2
X_8268_ _3653_ _3654_ _3613_ VGND VGND VPWR VPWR _3656_ sky130_fd_sc_hd__a21oi_1
Xfanout420 net423 VGND VGND VPWR VPWR net420 sky130_fd_sc_hd__buf_2
XFILLER_105_589 VPWR VGND VPWR VGND sky130_ef_sc_hd__decap_12
Xfanout431 net432 VGND VGND VPWR VPWR net431 sky130_fd_sc_hd__clkbuf_4
X_8199_ _3580_ _3586_ VGND VGND VPWR VPWR _3588_ sky130_fd_sc_hd__xnor2_1
X_7219_ _2630_ _2643_ _2642_ VGND VGND VPWR VPWR _2682_ sky130_fd_sc_hd__a21bo_1
Xfanout453 net454 VGND VGND VPWR VPWR net453 sky130_fd_sc_hd__buf_8
Xfanout442 net445 VGND VGND VPWR VPWR net442 sky130_fd_sc_hd__buf_6
Xfanout475 net6 VGND VGND VPWR VPWR net475 sky130_fd_sc_hd__buf_8
Xfanout464 net468 VGND VGND VPWR VPWR net464 sky130_fd_sc_hd__buf_2
XFILLER_100_250 VGND VGND VPWR VPWR sky130_fd_sc_hd__fill_2
Xfanout497 net498 VGND VGND VPWR VPWR net497 sky130_fd_sc_hd__buf_6
XFILLER_86_473 VGND VGND VPWR VPWR sky130_fd_sc_hd__decap_3
XFILLER_58_164 VGND VGND VPWR VPWR sky130_fd_sc_hd__decap_4
Xfanout486 net4 VGND VGND VPWR VPWR net486 sky130_fd_sc_hd__buf_8
XFILLER_19_529 VPWR VGND VPWR VGND sky130_ef_sc_hd__decap_12
XFILLER_46_315 VPWR VGND VPWR VGND sky130_ef_sc_hd__decap_12
XFILLER_104_51 VPWR VGND VPWR VGND sky130_ef_sc_hd__decap_12
XFILLER_58_197 VGND VGND VPWR VPWR sky130_fd_sc_hd__decap_3
XFILLER_46_359 VGND VGND VPWR VPWR sky130_fd_sc_hd__decap_4
XFILLER_73_189 VGND VGND VPWR VPWR sky130_fd_sc_hd__fill_1
XTAP_TAPCELL_ROW_64_1024 VGND VPWR sky130_fd_sc_hd__tapvpwrvgnd_1
XFILLER_64_77 VGND VGND VPWR VPWR sky130_fd_sc_hd__fill_1
XTAP_TAPCELL_ROW_12_402 VGND VPWR sky130_fd_sc_hd__tapvpwrvgnd_1
XFILLER_9_39 VPWR VGND VPWR VGND sky130_ef_sc_hd__decap_12
XTAP_TAPCELL_ROW_40_733 VGND VPWR sky130_fd_sc_hd__tapvpwrvgnd_1
XFILLER_6_433 VPWR VGND VPWR VGND sky130_ef_sc_hd__decap_12
XFILLER_6_477 VGND VGND VPWR VPWR sky130_fd_sc_hd__decap_8
XTAP_TAPCELL_ROW_20_490 VGND VPWR sky130_fd_sc_hd__tapvpwrvgnd_1
XTAP_TAPCELL_ROW_75_1153 VGND VPWR sky130_fd_sc_hd__tapvpwrvgnd_1
XFILLER_6_488 VGND VGND VPWR VPWR sky130_fd_sc_hd__decap_6
XFILLER_89_96 VGND VGND VPWR VPWR sky130_fd_sc_hd__decap_8
XFILLER_65_602 VPWR VGND VPWR VGND sky130_ef_sc_hd__decap_12
XFILLER_77_495 VGND VGND VPWR VPWR sky130_fd_sc_hd__decap_8
XTAP_TAPCELL_ROW_48_833 VGND VPWR sky130_fd_sc_hd__tapvpwrvgnd_1
XFILLER_49_197 VGND VGND VPWR VPWR sky130_fd_sc_hd__fill_1
XFILLER_92_465 VGND VGND VPWR VPWR sky130_fd_sc_hd__decap_8
XFILLER_37_359 VGND VGND VPWR VPWR sky130_fd_sc_hd__decap_6
XTAP_TAPCELL_ROW_86_1282 VGND VPWR sky130_fd_sc_hd__tapvpwrvgnd_1
XFILLER_18_573 VGND VGND VPWR VPWR sky130_fd_sc_hd__fill_1
X_4920_ _0652_ _0665_ _0664_ VGND VGND VPWR VPWR _0666_ sky130_fd_sc_hd__and3_1
XTAP_TAPCELL_ROW_28_590 VGND VPWR sky130_fd_sc_hd__tapvpwrvgnd_1
XFILLER_33_554 VGND VGND VPWR VPWR sky130_fd_sc_hd__decap_6
X_4851_ net293 _0437_ net578 VGND VGND VPWR VPWR _0598_ sky130_fd_sc_hd__a21oi_4
XFILLER_33_598 VGND VGND VPWR VPWR sky130_fd_sc_hd__fill_1
X_4782_ _0481_ _0488_ _0487_ VGND VGND VPWR VPWR _0531_ sky130_fd_sc_hd__a21bo_1
X_7570_ net551 _3020_ VGND VGND VPWR VPWR _3021_ sky130_fd_sc_hd__xnor2_1
X_6521_ pe_array\[0\].u_pe.accum_reg\[26\] net612 net357 VGND VGND VPWR VPWR _2040_
+ sky130_fd_sc_hd__and3_1
X_6452_ _1973_ _1941_ VGND VGND VPWR VPWR _1974_ sky130_fd_sc_hd__xor2_1
XFILLER_9_293 VPWR VGND VPWR VGND sky130_ef_sc_hd__decap_12
X_9240_ clknet_leaf_41_clk _0352_ VGND VGND VPWR VPWR pe_accum\[1\]\[26\] sky130_fd_sc_hd__dfxtp_1
Xclkload41 clknet_leaf_11_clk VGND VGND VPWR VPWR clkload41/Y sky130_fd_sc_hd__inv_6
X_9171_ clknet_leaf_22_clk _0283_ VGND VGND VPWR VPWR pe_accum\[0\]\[25\] sky130_fd_sc_hd__dfxtp_1
Xclkload52 clknet_leaf_35_clk VGND VGND VPWR VPWR clkload52/Y sky130_fd_sc_hd__inv_6
Xclkload30 clknet_leaf_40_clk VGND VGND VPWR VPWR clkload30/Y sky130_fd_sc_hd__clkinvlp_4
X_5403_ _1131_ _1132_ VGND VGND VPWR VPWR _1133_ sky130_fd_sc_hd__and2_1
X_6383_ net202 _1877_ _1876_ VGND VGND VPWR VPWR _1907_ sky130_fd_sc_hd__a21oi_1
X_8122_ net680 _3510_ _3511_ VGND VGND VPWR VPWR _3513_ sky130_fd_sc_hd__or3_4
X_5334_ pe_array\[3\].u_pe.accum_reg\[27\] _0520_ VGND VGND VPWR VPWR _1066_ sky130_fd_sc_hd__nor2_1
XFILLER_87_215 VGND VGND VPWR VPWR sky130_fd_sc_hd__decap_8
X_8053_ _3444_ _3445_ VGND VGND VPWR VPWR _3446_ sky130_fd_sc_hd__nand2_1
X_5265_ net748 _0998_ VGND VGND VPWR VPWR _1000_ sky130_fd_sc_hd__xnor2_1
X_5196_ _0930_ _0931_ net205 VGND VGND VPWR VPWR _0933_ sky130_fd_sc_hd__a21oi_1
X_7004_ _2454_ _2471_ _2470_ VGND VGND VPWR VPWR _2472_ sky130_fd_sc_hd__and3_1
XFILLER_56_624 VGND VGND VPWR VPWR sky130_fd_sc_hd__decap_4
XFILLER_18_15 VPWR VGND VPWR VGND sky130_ef_sc_hd__decap_12
XFILLER_95_281 VGND VGND VPWR VPWR sky130_fd_sc_hd__decap_3
XFILLER_83_432 VPWR VGND VPWR VGND sky130_ef_sc_hd__decap_12
XFILLER_56_657 VPWR VGND VPWR VGND sky130_ef_sc_hd__decap_12
XFILLER_83_465 VGND VGND VPWR VPWR sky130_fd_sc_hd__fill_1
X_8955_ clknet_leaf_64_clk _0067_ VGND VGND VPWR VPWR pe_accum\[3\]\[23\] sky130_fd_sc_hd__dfxtp_1
XFILLER_43_307 VGND VGND VPWR VPWR sky130_fd_sc_hd__fill_1
X_8886_ _4191_ net214 VGND VGND VPWR VPWR _4224_ sky130_fd_sc_hd__nand2_1
X_7906_ _3298_ _3301_ VGND VGND VPWR VPWR _3302_ sky130_fd_sc_hd__xor2_1
X_7837_ _3235_ VGND VGND VPWR VPWR _3236_ sky130_fd_sc_hd__inv_2
XFILLER_70_137 VGND VGND VPWR VPWR sky130_fd_sc_hd__decap_3
XFILLER_34_25 VGND VGND VPWR VPWR sky130_fd_sc_hd__decap_3
XFILLER_36_392 VPWR VGND VPWR VGND sky130_ef_sc_hd__decap_12
X_7768_ net995 net222 _3193_ net373 VGND VGND VPWR VPWR _0345_ sky130_fd_sc_hd__o211a_1
X_6719_ net999 net234 VGND VGND VPWR VPWR _2201_ sky130_fd_sc_hd__nand2_1
Xclkload2 clknet_3_2__leaf_clk VGND VGND VPWR VPWR clkload2/Y sky130_fd_sc_hd__inv_6
X_7699_ net167 _3145_ VGND VGND VPWR VPWR _3146_ sky130_fd_sc_hd__xnor2_1
XFILLER_109_169 VGND VGND VPWR VPWR sky130_fd_sc_hd__decap_4
XFILLER_3_447 VGND VGND VPWR VPWR sky130_fd_sc_hd__fill_1
XFILLER_59_55 VGND VGND VPWR VPWR sky130_fd_sc_hd__fill_1
Xfanout250 net253 VGND VGND VPWR VPWR net250 sky130_fd_sc_hd__buf_2
XFILLER_93_229 VGND VGND VPWR VPWR sky130_fd_sc_hd__fill_1
Xfanout261 net682 VGND VGND VPWR VPWR net261 sky130_fd_sc_hd__buf_8
Xfanout283 net284 VGND VGND VPWR VPWR net283 sky130_fd_sc_hd__buf_4
Xfanout272 net273 VGND VGND VPWR VPWR net272 sky130_fd_sc_hd__clkbuf_4
XFILLER_101_581 VPWR VGND VPWR VGND sky130_ef_sc_hd__decap_12
XTAP_TAPCELL_ROW_70_1094 VGND VPWR sky130_fd_sc_hd__tapvpwrvgnd_1
XFILLER_59_484 VGND VGND VPWR VPWR sky130_fd_sc_hd__fill_1
Xfanout294 pe_array\[3\].u_pe.weight_in\[4\] VGND VGND VPWR VPWR net294 sky130_fd_sc_hd__clkbuf_2
XFILLER_19_337 VPWR VGND VPWR VGND sky130_ef_sc_hd__decap_12
XTAP_TAPCELL_ROW_109_1558 VGND VPWR sky130_fd_sc_hd__tapvpwrvgnd_1
XFILLER_75_65 VGND VGND VPWR VPWR sky130_fd_sc_hd__decap_3
XFILLER_46_145 VGND VGND VPWR VPWR sky130_fd_sc_hd__fill_1
XFILLER_61_126 VGND VGND VPWR VPWR sky130_fd_sc_hd__fill_2
XFILLER_91_53 VGND VGND VPWR VPWR sky130_fd_sc_hd__decap_3
XFILLER_15_565 VGND VGND VPWR VPWR sky130_fd_sc_hd__decap_8
XTAP_TAPCELL_ROW_53_891 VGND VPWR sky130_fd_sc_hd__tapvpwrvgnd_1
XFILLER_30_568 VPWR VGND VPWR VGND sky130_ef_sc_hd__decap_12
XFILLER_6_285 VPWR VGND VPWR VGND sky130_ef_sc_hd__decap_12
XFILLER_97_502 VGND VGND VPWR VPWR sky130_fd_sc_hd__fill_2
XFILLER_69_204 VGND VGND VPWR VPWR sky130_fd_sc_hd__decap_3
X_5050_ _0750_ _0752_ _0789_ _0790_ VGND VGND VPWR VPWR _0792_ sky130_fd_sc_hd__o211ai_1
XFILLER_27_3 VGND VGND VPWR VPWR sky130_fd_sc_hd__fill_2
XFILLER_38_613 VPWR VGND VPWR VGND sky130_ef_sc_hd__decap_12
XTAP_TAPCELL_ROW_88_1311 VGND VPWR sky130_fd_sc_hd__tapvpwrvgnd_1
XFILLER_77_281 VPWR VGND VPWR VGND sky130_ef_sc_hd__decap_12
XFILLER_92_240 VGND VGND VPWR VPWR sky130_fd_sc_hd__decap_4
XFILLER_1_51 VGND VGND VPWR VPWR sky130_fd_sc_hd__decap_4
XFILLER_25_307 VGND VGND VPWR VPWR sky130_fd_sc_hd__decap_4
XFILLER_37_134 VGND VGND VPWR VPWR sky130_fd_sc_hd__decap_8
XFILLER_38_657 VGND VGND VPWR VPWR sky130_fd_sc_hd__decap_4
X_8740_ _4076_ _4078_ _4111_ VGND VGND VPWR VPWR _4113_ sky130_fd_sc_hd__nor3_1
X_5952_ _1486_ _1485_ _1439_ _1441_ VGND VGND VPWR VPWR _1488_ sky130_fd_sc_hd__a211o_1
XFILLER_65_476 VPWR VGND VPWR VGND sky130_ef_sc_hd__decap_12
XPHY_EDGE_ROW_9_Left_127 VGND VGND VPWR VPWR sky130_fd_sc_hd__decap_3
X_4903_ _0647_ _0648_ VGND VGND VPWR VPWR _0649_ sky130_fd_sc_hd__or2_1
X_8671_ _3551_ _4018_ _4016_ VGND VGND VPWR VPWR _4046_ sky130_fd_sc_hd__a21oi_1
X_5883_ _1349_ _1409_ _1408_ VGND VGND VPWR VPWR _1420_ sky130_fd_sc_hd__a21bo_1
XFILLER_61_671 VGND VGND VPWR VPWR sky130_fd_sc_hd__fill_1
XFILLER_21_513 VGND VGND VPWR VPWR sky130_fd_sc_hd__fill_1
XFILLER_61_693 VGND VGND VPWR VPWR sky130_fd_sc_hd__decap_3
X_7622_ _2987_ _3013_ VGND VGND VPWR VPWR _3071_ sky130_fd_sc_hd__or2_1
X_4834_ _0565_ _0580_ _0581_ VGND VGND VPWR VPWR _0582_ sky130_fd_sc_hd__and3_1
XFILLER_21_557 VGND VGND VPWR VPWR sky130_fd_sc_hd__decap_3
X_7553_ _2975_ _2977_ _3004_ VGND VGND VPWR VPWR _3005_ sky130_fd_sc_hd__o21a_1
X_4765_ _0508_ _0513_ VGND VGND VPWR VPWR _0514_ sky130_fd_sc_hd__nand2_1
X_6504_ net177 _2022_ VGND VGND VPWR VPWR _2024_ sky130_fd_sc_hd__xnor2_1
XTAP_TAPCELL_ROW_99_1440 VGND VPWR sky130_fd_sc_hd__tapvpwrvgnd_1
X_7484_ _2935_ _2936_ _2905_ _2906_ VGND VGND VPWR VPWR _2938_ sky130_fd_sc_hd__a211oi_1
X_4696_ _0444_ _0445_ _4405_ _4407_ VGND VGND VPWR VPWR _0447_ sky130_fd_sc_hd__a211o_1
X_9223_ clknet_leaf_41_clk _0335_ VGND VGND VPWR VPWR pe_accum\[1\]\[9\] sky130_fd_sc_hd__dfxtp_1
XFILLER_106_139 VGND VGND VPWR VPWR sky130_fd_sc_hd__fill_1
X_6435_ _1923_ _1924_ _1955_ _1956_ VGND VGND VPWR VPWR _1957_ sky130_fd_sc_hd__o211a_1
XFILLER_20_49 VGND VGND VPWR VPWR sky130_fd_sc_hd__decap_4
X_6366_ _1890_ _1863_ VGND VGND VPWR VPWR _1891_ sky130_fd_sc_hd__xnor2_2
X_9154_ clknet_leaf_18_clk _0266_ VGND VGND VPWR VPWR pe_accum\[0\]\[8\] sky130_fd_sc_hd__dfxtp_1
XFILLER_115_673 VPWR VGND VPWR VGND sky130_ef_sc_hd__decap_12
X_8105_ net476 net470 net311 net308 VGND VGND VPWR VPWR _3496_ sky130_fd_sc_hd__and4_1
XFILLER_0_406 VPWR VGND VPWR VGND sky130_ef_sc_hd__decap_12
X_5317_ net185 _1049_ VGND VGND VPWR VPWR _1050_ sky130_fd_sc_hd__or2_1
X_9085_ clknet_leaf_68_clk _0197_ VGND VGND VPWR VPWR net35 sky130_fd_sc_hd__dfxtp_1
X_6297_ net173 _1822_ _1823_ VGND VGND VPWR VPWR _1824_ sky130_fd_sc_hd__or3_4
X_8036_ _3370_ _3373_ _3427_ _3428_ VGND VGND VPWR VPWR _3429_ sky130_fd_sc_hd__o211ai_2
X_5248_ _0897_ _0982_ VGND VGND VPWR VPWR _0983_ sky130_fd_sc_hd__nand2_1
XFILLER_29_69 VGND VGND VPWR VPWR sky130_fd_sc_hd__fill_1
X_5179_ net178 _0916_ VGND VGND VPWR VPWR _0917_ sky130_fd_sc_hd__xor2_1
XFILLER_28_112 VGND VGND VPWR VPWR sky130_fd_sc_hd__fill_1
XFILLER_28_156 VGND VGND VPWR VPWR sky130_fd_sc_hd__fill_1
XFILLER_83_262 VPWR VGND VPWR VGND sky130_ef_sc_hd__decap_12
XFILLER_71_413 VGND VGND VPWR VPWR sky130_fd_sc_hd__decap_6
X_8938_ clknet_leaf_59_clk _0050_ VGND VGND VPWR VPWR pe_accum\[3\]\[6\] sky130_fd_sc_hd__dfxtp_1
XTAP_TAPCELL_ROW_3_288 VGND VPWR sky130_fd_sc_hd__tapvpwrvgnd_1
XFILLER_44_616 VGND VGND VPWR VPWR sky130_fd_sc_hd__decap_8
XFILLER_45_57 VPWR VGND VPWR VGND sky130_ef_sc_hd__decap_12
X_8869_ net969 net212 _4215_ net383 VGND VGND VPWR VPWR _0424_ sky130_fd_sc_hd__o211a_1
XTAP_TAPCELL_ROW_104_1499 VGND VPWR sky130_fd_sc_hd__tapvpwrvgnd_1
XFILLER_52_682 VGND VGND VPWR VPWR sky130_fd_sc_hd__fill_2
XFILLER_51_181 VGND VGND VPWR VPWR sky130_fd_sc_hd__fill_2
XFILLER_12_524 VGND VGND VPWR VPWR sky130_fd_sc_hd__decap_4
XFILLER_12_513 VGND VGND VPWR VPWR sky130_fd_sc_hd__decap_4
XTAP_TAPCELL_ROW_50_850 VGND VPWR sky130_fd_sc_hd__tapvpwrvgnd_1
XFILLER_6_29 VPWR VGND VPWR VGND sky130_ef_sc_hd__decap_12
XFILLER_112_109 VPWR VGND VPWR VGND sky130_ef_sc_hd__decap_12
XTAP_TAPCELL_ROW_72_1123 VGND VPWR sky130_fd_sc_hd__tapvpwrvgnd_1
XTAP_TAPCELL_ROW_72_1112 VGND VPWR sky130_fd_sc_hd__tapvpwrvgnd_1
XFILLER_86_20 VGND VGND VPWR VPWR sky130_fd_sc_hd__decap_4
XFILLER_10_93 VGND VGND VPWR VPWR sky130_fd_sc_hd__fill_1
XFILLER_86_97 VGND VGND VPWR VPWR sky130_fd_sc_hd__fill_2
XFILLER_47_421 VGND VGND VPWR VPWR sky130_fd_sc_hd__decap_4
XFILLER_47_432 VGND VGND VPWR VPWR sky130_fd_sc_hd__fill_1
XTAP_TAPCELL_ROW_58_950 VGND VPWR sky130_fd_sc_hd__tapvpwrvgnd_1
XFILLER_47_443 VGND VGND VPWR VPWR sky130_fd_sc_hd__decap_4
XFILLER_74_251 VGND VGND VPWR VPWR sky130_fd_sc_hd__fill_1
XFILLER_62_424 VGND VGND VPWR VPWR sky130_fd_sc_hd__decap_8
XTAP_TAPCELL_ROW_83_1252 VGND VPWR sky130_fd_sc_hd__tapvpwrvgnd_1
XFILLER_15_373 VPWR VGND VPWR VGND sky130_ef_sc_hd__decap_12
XFILLER_30_343 VPWR VGND VPWR VGND sky130_ef_sc_hd__decap_12
XFILLER_30_365 VGND VGND VPWR VPWR sky130_fd_sc_hd__decap_3
X_4550_ _4313_ _4314_ VGND VGND VPWR VPWR _4315_ sky130_fd_sc_hd__and2b_1
Xhold517 pe_array\[0\].u_pe.accum_reg\[0\] VGND VGND VPWR VPWR net1032 sky130_fd_sc_hd__dlygate4sd3_1
Xhold506 pe_accum\[1\]\[5\] VGND VGND VPWR VPWR net1021 sky130_fd_sc_hd__dlygate4sd3_1
XFILLER_7_561 VGND VGND VPWR VPWR sky130_fd_sc_hd__fill_1
X_4481_ net1018 _4247_ _4250_ VGND VGND VPWR VPWR _0011_ sky130_fd_sc_hd__o21ba_1
X_6220_ _1706_ _1741_ _1748_ VGND VGND VPWR VPWR _1749_ sky130_fd_sc_hd__a21bo_1
XTAP_TAPCELL_ROW_94_1381 VGND VPWR sky130_fd_sc_hd__tapvpwrvgnd_1
X_6151_ net655 _1680_ VGND VGND VPWR VPWR _1682_ sky130_fd_sc_hd__or2_4
XFILLER_112_643 VGND VGND VPWR VPWR sky130_fd_sc_hd__fill_1
X_5102_ _0839_ net691 VGND VGND VPWR VPWR _0843_ sky130_fd_sc_hd__xor2_4
X_6082_ _1570_ _1571_ _1613_ _1614_ VGND VGND VPWR VPWR _1615_ sky130_fd_sc_hd__o211a_1
XFILLER_111_164 VGND VGND VPWR VPWR sky130_fd_sc_hd__decap_4
X_5033_ _0774_ _0775_ VGND VGND VPWR VPWR _0776_ sky130_fd_sc_hd__or2_1
XTAP_TAPCELL_ROW_0_236 VGND VPWR sky130_fd_sc_hd__tapvpwrvgnd_1
XFILLER_80_243 VGND VGND VPWR VPWR sky130_fd_sc_hd__fill_1
XTAP_TAPCELL_ROW_0_247 VGND VPWR sky130_fd_sc_hd__tapvpwrvgnd_1
XTAP_TAPCELL_ROW_0_258 VGND VPWR sky130_fd_sc_hd__tapvpwrvgnd_1
X_6984_ _2445_ _2450_ VGND VGND VPWR VPWR _2452_ sky130_fd_sc_hd__xnor2_1
X_8723_ pe_array\[2\].u_pe.accum_reg\[28\] net444 net318 VGND VGND VPWR VPWR _4096_
+ sky130_fd_sc_hd__and3_1
X_5935_ net494 _4232_ VGND VGND VPWR VPWR _1471_ sky130_fd_sc_hd__nor2_1
XFILLER_15_27 VPWR VGND VPWR VGND sky130_ef_sc_hd__decap_12
XFILLER_25_159 VGND VGND VPWR VPWR sky130_fd_sc_hd__decap_8
X_8654_ _4029_ _4028_ VGND VGND VPWR VPWR _4030_ sky130_fd_sc_hd__and2b_1
X_5866_ _1401_ _1402_ VGND VGND VPWR VPWR _1404_ sky130_fd_sc_hd__xor2_1
XTAP_TAPCELL_ROW_36_688 VGND VPWR sky130_fd_sc_hd__tapvpwrvgnd_1
Xclkbuf_leaf_60_clk clknet_3_0__leaf_clk VGND VGND VPWR VPWR clknet_leaf_60_clk sky130_fd_sc_hd__clkbuf_8
X_7605_ net167 _3054_ VGND VGND VPWR VPWR _3055_ sky130_fd_sc_hd__nor2_1
X_4817_ _0555_ _0563_ VGND VGND VPWR VPWR _0565_ sky130_fd_sc_hd__xnor2_1
X_8585_ _3960_ _3961_ _3962_ VGND VGND VPWR VPWR _3963_ sky130_fd_sc_hd__nand3_1
X_5797_ _1277_ _1304_ _1303_ VGND VGND VPWR VPWR _1337_ sky130_fd_sc_hd__a21o_1
X_7536_ _2962_ _2964_ _2987_ VGND VGND VPWR VPWR _2989_ sky130_fd_sc_hd__nand3_1
X_4748_ _4442_ _0434_ _0496_ _0497_ VGND VGND VPWR VPWR _0498_ sky130_fd_sc_hd__a211oi_4
X_4679_ net589 _4230_ VGND VGND VPWR VPWR _4440_ sky130_fd_sc_hd__nor2_1
X_7467_ net168 _2895_ _2894_ VGND VGND VPWR VPWR _2922_ sky130_fd_sc_hd__a21oi_1
X_6418_ _1940_ _1939_ VGND VGND VPWR VPWR _1941_ sky130_fd_sc_hd__and2b_1
XPHY_EDGE_ROW_1_Right_1 VGND VGND VPWR VPWR sky130_fd_sc_hd__decap_3
X_9206_ clknet_leaf_42_clk _0318_ VGND VGND VPWR VPWR pe_array\[1\].u_pe.accum_reg\[24\]
+ sky130_fd_sc_hd__dfxtp_1
X_9137_ clknet_leaf_26_clk _0249_ VGND VGND VPWR VPWR pe_array\[0\].u_pe.accum_reg\[23\]
+ sky130_fd_sc_hd__dfxtp_1
X_7398_ _2851_ _2852_ net267 VGND VGND VPWR VPWR _2855_ sky130_fd_sc_hd__o21ai_1
Xoutput26 net26 VGND VGND VPWR VPWR result_data[103] sky130_fd_sc_hd__buf_2
Xoutput48 net48 VGND VGND VPWR VPWR result_data[123] sky130_fd_sc_hd__buf_2
Xoutput37 net37 VGND VGND VPWR VPWR result_data[113] sky130_fd_sc_hd__buf_2
X_6349_ net280 _1871_ _1872_ VGND VGND VPWR VPWR _1874_ sky130_fd_sc_hd__or3_1
Xoutput59 net59 VGND VGND VPWR VPWR result_data[18] sky130_fd_sc_hd__buf_2
XTAP_TAPCELL_ROW_8_347 VGND VPWR sky130_fd_sc_hd__tapvpwrvgnd_1
XFILLER_0_225 VGND VGND VPWR VPWR sky130_fd_sc_hd__fill_2
X_9068_ clknet_leaf_11_clk _0180_ VGND VGND VPWR VPWR net143 sky130_fd_sc_hd__dfxtp_1
XFILLER_102_197 VGND VGND VPWR VPWR sky130_fd_sc_hd__decap_4
XFILLER_76_527 VGND VGND VPWR VPWR sky130_fd_sc_hd__decap_4
X_8019_ _3406_ _3411_ VGND VGND VPWR VPWR _3412_ sky130_fd_sc_hd__nand2_1
XFILLER_48_229 VGND VGND VPWR VPWR sky130_fd_sc_hd__decap_4
XFILLER_56_251 VGND VGND VPWR VPWR sky130_fd_sc_hd__fill_1
XTAP_TAPCELL_ROW_106_1528 VGND VPWR sky130_fd_sc_hd__tapvpwrvgnd_1
XFILLER_84_593 VGND VGND VPWR VPWR sky130_fd_sc_hd__fill_1
XFILLER_17_649 VGND VGND VPWR VPWR sky130_fd_sc_hd__decap_6
XFILLER_12_321 VGND VGND VPWR VPWR sky130_fd_sc_hd__decap_4
XFILLER_12_365 VPWR VGND VPWR VGND sky130_ef_sc_hd__decap_12
XFILLER_8_325 VGND VGND VPWR VPWR sky130_fd_sc_hd__decap_3
XTAP_TAPCELL_ROW_117_1668 VGND VPWR sky130_fd_sc_hd__tapvpwrvgnd_1
XTAP_TAPCELL_ROW_117_1657 VGND VPWR sky130_fd_sc_hd__tapvpwrvgnd_1
XFILLER_4_531 VGND VGND VPWR VPWR sky130_fd_sc_hd__fill_1
XFILLER_62_210 VGND VGND VPWR VPWR sky130_fd_sc_hd__decap_3
XFILLER_16_660 VGND VGND VPWR VPWR sky130_fd_sc_hd__decap_3
X_5720_ _1261_ _1262_ VGND VGND VPWR VPWR _1263_ sky130_fd_sc_hd__nand2_1
XPHY_EDGE_ROW_99_Left_217 VGND VGND VPWR VPWR sky130_fd_sc_hd__decap_3
XFILLER_94_3 VGND VGND VPWR VPWR sky130_fd_sc_hd__decap_8
XTAP_TAPCELL_ROW_33_647 VGND VPWR sky130_fd_sc_hd__tapvpwrvgnd_1
Xclkbuf_leaf_42_clk clknet_3_3__leaf_clk VGND VGND VPWR VPWR clknet_leaf_42_clk sky130_fd_sc_hd__clkbuf_8
XTAP_TAPCELL_ROW_61_989 VGND VPWR sky130_fd_sc_hd__tapvpwrvgnd_1
X_5651_ net943 net365 VGND VGND VPWR VPWR _0192_ sky130_fd_sc_hd__and2_1
XTAP_TAPCELL_ROW_96_1410 VGND VPWR sky130_fd_sc_hd__tapvpwrvgnd_1
X_8370_ _3750_ _3751_ _3752_ VGND VGND VPWR VPWR _3755_ sky130_fd_sc_hd__a21o_1
X_5582_ net1021 net378 VGND VGND VPWR VPWR _0123_ sky130_fd_sc_hd__and2_1
X_4602_ _4363_ _4364_ VGND VGND VPWR VPWR _4365_ sky130_fd_sc_hd__and2b_1
X_7321_ _2778_ _2779_ net165 VGND VGND VPWR VPWR _2781_ sky130_fd_sc_hd__o21ai_1
X_4533_ net306 net304 net487 net479 VGND VGND VPWR VPWR _4298_ sky130_fd_sc_hd__and4_1
X_7252_ _2710_ _2711_ _2712_ VGND VGND VPWR VPWR _2714_ sky130_fd_sc_hd__a21oi_1
XFILLER_117_29 VPWR VGND VPWR VGND sky130_ef_sc_hd__decap_12
X_6203_ _1730_ _1731_ net173 VGND VGND VPWR VPWR _1733_ sky130_fd_sc_hd__o21ai_1
X_4464_ net16 _4240_ _4241_ net350 VGND VGND VPWR VPWR _0003_ sky130_fd_sc_hd__a22o_1
XFILLER_89_129 VGND VGND VPWR VPWR sky130_fd_sc_hd__decap_4
X_7183_ _2644_ _2645_ _2597_ _2600_ VGND VGND VPWR VPWR _2647_ sky130_fd_sc_hd__o211a_1
XFILLER_97_151 VGND VGND VPWR VPWR sky130_fd_sc_hd__decap_6
X_6134_ _1606_ _1608_ _1664_ _1665_ VGND VGND VPWR VPWR _1666_ sky130_fd_sc_hd__a211oi_2
XTAP_TAPCELL_ROW_5_317 VGND VPWR sky130_fd_sc_hd__tapvpwrvgnd_1
XFILLER_85_335 VGND VGND VPWR VPWR sky130_fd_sc_hd__fill_1
X_6065_ _1560_ _1561_ _1559_ VGND VGND VPWR VPWR _1598_ sky130_fd_sc_hd__a21oi_1
XFILLER_100_657 VGND VGND VPWR VPWR sky130_fd_sc_hd__decap_8
X_5016_ _0756_ _0757_ net744 VGND VGND VPWR VPWR _0759_ sky130_fd_sc_hd__a21o_1
XFILLER_38_251 VGND VGND VPWR VPWR sky130_fd_sc_hd__fill_1
XFILLER_93_390 VGND VGND VPWR VPWR sky130_fd_sc_hd__fill_2
XFILLER_26_37 VGND VGND VPWR VPWR sky130_fd_sc_hd__decap_3
XFILLER_26_26 VGND VGND VPWR VPWR sky130_fd_sc_hd__fill_2
X_6967_ _2354_ _2387_ _2386_ VGND VGND VPWR VPWR _2436_ sky130_fd_sc_hd__a21oi_1
X_8706_ _4064_ _4079_ VGND VGND VPWR VPWR _4080_ sky130_fd_sc_hd__and2b_1
X_5918_ _1452_ _1453_ _1403_ _1405_ VGND VGND VPWR VPWR _1455_ sky130_fd_sc_hd__a211oi_2
Xclkbuf_leaf_33_clk clknet_3_6__leaf_clk VGND VGND VPWR VPWR clknet_leaf_33_clk sky130_fd_sc_hd__clkbuf_8
X_6898_ net450 net342 VGND VGND VPWR VPWR _2368_ sky130_fd_sc_hd__nand2_1
XTAP_TAPCELL_ROW_101_1469 VGND VPWR sky130_fd_sc_hd__tapvpwrvgnd_1
X_8637_ pe_array\[2\].u_pe.accum_reg\[25\] _3508_ VGND VGND VPWR VPWR _4013_ sky130_fd_sc_hd__nor2_1
X_5849_ _1347_ _1386_ VGND VGND VPWR VPWR _1387_ sky130_fd_sc_hd__and2b_1
X_8568_ net402 pe_array\[2\].u_pe.accum_reg\[22\] net218 _3946_ VGND VGND VPWR VPWR
+ _3947_ sky130_fd_sc_hd__o2bb2a_4
XFILLER_107_201 VGND VGND VPWR VPWR sky130_fd_sc_hd__decap_3
XFILLER_5_317 VGND VGND VPWR VPWR sky130_fd_sc_hd__decap_6
X_7519_ _2970_ _2971_ VGND VGND VPWR VPWR _2972_ sky130_fd_sc_hd__and2b_1
X_8499_ _3754_ _3757_ _3791_ VGND VGND VPWR VPWR _3880_ sky130_fd_sc_hd__a21oi_2
XFILLER_107_51 VGND VGND VPWR VPWR sky130_fd_sc_hd__decap_4
XTAP_TAPCELL_ROW_112_1598 VGND VPWR sky130_fd_sc_hd__tapvpwrvgnd_1
XFILLER_49_538 VGND VGND VPWR VPWR sky130_fd_sc_hd__decap_4
XFILLER_72_530 VGND VGND VPWR VPWR sky130_fd_sc_hd__fill_2
XFILLER_83_87 VGND VGND VPWR VPWR sky130_fd_sc_hd__fill_1
XFILLER_83_65 VGND VGND VPWR VPWR sky130_fd_sc_hd__decap_3
XFILLER_83_54 VGND VGND VPWR VPWR sky130_fd_sc_hd__fill_2
XTAP_TAPCELL_ROW_67_1055 VGND VPWR sky130_fd_sc_hd__tapvpwrvgnd_1
XTAP_TAPCELL_ROW_80_1211 VGND VPWR sky130_fd_sc_hd__tapvpwrvgnd_1
XTAP_TAPCELL_ROW_30_617 VGND VPWR sky130_fd_sc_hd__tapvpwrvgnd_1
XFILLER_9_656 VPWR VGND VPWR VGND sky130_ef_sc_hd__decap_12
XTAP_TAPCELL_ROW_10_374 VGND VPWR sky130_fd_sc_hd__tapvpwrvgnd_1
XTAP_TAPCELL_ROW_78_1195 VGND VPWR sky130_fd_sc_hd__tapvpwrvgnd_1
XTAP_TAPCELL_ROW_78_1184 VGND VPWR sky130_fd_sc_hd__tapvpwrvgnd_1
XFILLER_4_361 VGND VGND VPWR VPWR sky130_fd_sc_hd__decap_3
XTAP_TAPCELL_ROW_91_1340 VGND VPWR sky130_fd_sc_hd__tapvpwrvgnd_1
XFILLER_95_600 VGND VGND VPWR VPWR sky130_fd_sc_hd__decap_4
XTAP_TAPCELL_ROW_91_1351 VGND VPWR sky130_fd_sc_hd__tapvpwrvgnd_1
XFILLER_79_140 VGND VGND VPWR VPWR sky130_fd_sc_hd__fill_1
XFILLER_67_335 VGND VGND VPWR VPWR sky130_fd_sc_hd__fill_1
XFILLER_94_165 VGND VGND VPWR VPWR sky130_fd_sc_hd__fill_1
XTAP_TAPCELL_ROW_38_706 VGND VPWR sky130_fd_sc_hd__tapvpwrvgnd_1
X_7870_ _3265_ _3266_ net496 net320 VGND VGND VPWR VPWR _3267_ sky130_fd_sc_hd__and4bb_1
X_6821_ pe_array\[1\].u_pe.accum_reg\[5\] net473 net343 VGND VGND VPWR VPWR _2293_
+ sky130_fd_sc_hd__and3_1
XFILLER_90_371 VGND VGND VPWR VPWR sky130_fd_sc_hd__fill_1
XFILLER_63_596 VPWR VGND VPWR VGND sky130_ef_sc_hd__decap_12
XTAP_TAPCELL_ROW_18_474 VGND VPWR sky130_fd_sc_hd__tapvpwrvgnd_1
Xclkbuf_leaf_15_clk clknet_3_5__leaf_clk VGND VGND VPWR VPWR clknet_leaf_15_clk sky130_fd_sc_hd__clkbuf_8
X_6752_ _2225_ _2226_ VGND VGND VPWR VPWR _2227_ sky130_fd_sc_hd__nor2_1
XFILLER_50_257 VGND VGND VPWR VPWR sky130_fd_sc_hd__fill_1
X_6683_ _2178_ _2196_ VGND VGND VPWR VPWR _2197_ sky130_fd_sc_hd__xnor2_1
X_5703_ _1245_ _1246_ net514 net354 VGND VGND VPWR VPWR _1247_ sky130_fd_sc_hd__and4bb_1
XFILLER_50_279 VGND VGND VPWR VPWR sky130_fd_sc_hd__decap_6
X_5634_ net921 net383 VGND VGND VPWR VPWR _0175_ sky130_fd_sc_hd__and2_1
X_8422_ _3801_ _3802_ _3771_ _3772_ VGND VGND VPWR VPWR _3805_ sky130_fd_sc_hd__a211o_1
X_8353_ _3704_ _3705_ _3735_ _3736_ VGND VGND VPWR VPWR _3738_ sky130_fd_sc_hd__o211ai_1
XFILLER_117_554 VGND VGND VPWR VPWR sky130_fd_sc_hd__decap_6
X_5565_ net914 net395 VGND VGND VPWR VPWR _0106_ sky130_fd_sc_hd__and2_1
X_7304_ net407 pe_array\[1\].u_pe.accum_reg\[16\] net229 _2764_ VGND VGND VPWR VPWR
+ _2765_ sky130_fd_sc_hd__o2bb2a_1
X_8284_ net439 net313 pe_array\[2\].u_pe.accum_reg\[14\] VGND VGND VPWR VPWR _3671_
+ sky130_fd_sc_hd__a21oi_1
X_5496_ net929 net249 _1208_ net370 VGND VGND VPWR VPWR _0058_ sky130_fd_sc_hd__o211a_1
X_4516_ _4262_ _4280_ _4281_ VGND VGND VPWR VPWR _4282_ sky130_fd_sc_hd__nand3_1
X_4447_ net510 VGND VGND VPWR VPWR _4228_ sky130_fd_sc_hd__inv_2
X_7235_ _2575_ _2661_ _2664_ VGND VGND VPWR VPWR _2697_ sky130_fd_sc_hd__o21bai_1
XFILLER_104_259 VPWR VGND VPWR VGND sky130_ef_sc_hd__decap_12
X_7166_ _2621_ _2628_ VGND VGND VPWR VPWR _2630_ sky130_fd_sc_hd__xnor2_1
XFILLER_98_471 VGND VGND VPWR VPWR sky130_fd_sc_hd__fill_1
X_6117_ net458 net361 pe_array\[0\].u_pe.accum_reg\[13\] VGND VGND VPWR VPWR _1649_
+ sky130_fd_sc_hd__a21oi_1
X_7097_ _2560_ _2559_ _2494_ _2496_ VGND VGND VPWR VPWR _2563_ sky130_fd_sc_hd__o211ai_2
XFILLER_73_305 VGND VGND VPWR VPWR sky130_fd_sc_hd__decap_4
X_6048_ _1566_ _1580_ _1581_ VGND VGND VPWR VPWR _1582_ sky130_fd_sc_hd__nand3_2
XFILLER_46_519 VGND VGND VPWR VPWR sky130_fd_sc_hd__decap_6
XFILLER_73_349 VPWR VGND VPWR VGND sky130_ef_sc_hd__decap_12
XFILLER_54_530 VGND VGND VPWR VPWR sky130_fd_sc_hd__fill_2
XFILLER_37_69 VPWR VGND VPWR VGND sky130_ef_sc_hd__decap_12
X_7999_ _3364_ _3391_ VGND VGND VPWR VPWR _3393_ sky130_fd_sc_hd__xnor2_1
XFILLER_53_57 VPWR VGND VPWR VGND sky130_ef_sc_hd__decap_12
XFILLER_41_257 VGND VGND VPWR VPWR sky130_fd_sc_hd__fill_1
XTAP_TAPCELL_ROW_114_1627 VGND VPWR sky130_fd_sc_hd__tapvpwrvgnd_1
XTAP_TAPCELL_ROW_114_1616 VGND VPWR sky130_fd_sc_hd__tapvpwrvgnd_1
XFILLER_5_169 VGND VGND VPWR VPWR sky130_fd_sc_hd__fill_2
XFILLER_89_482 VGND VGND VPWR VPWR sky130_fd_sc_hd__fill_1
XFILLER_94_42 VGND VGND VPWR VPWR sky130_fd_sc_hd__decap_3
XFILLER_91_135 VPWR VGND VPWR VGND sky130_ef_sc_hd__decap_12
XFILLER_91_113 VPWR VGND VPWR VGND sky130_ef_sc_hd__decap_12
XFILLER_92_669 VGND VGND VPWR VPWR sky130_fd_sc_hd__fill_2
XFILLER_60_511 VGND VGND VPWR VPWR sky130_fd_sc_hd__decap_6
XTAP_TAPCELL_ROW_15_433 VGND VPWR sky130_fd_sc_hd__tapvpwrvgnd_1
XTAP_TAPCELL_ROW_43_764 VGND VPWR sky130_fd_sc_hd__tapvpwrvgnd_1
XTAP_TAPCELL_ROW_43_775 VGND VPWR sky130_fd_sc_hd__tapvpwrvgnd_1
X_5350_ net181 _1081_ VGND VGND VPWR VPWR _1082_ sky130_fd_sc_hd__xor2_1
X_5281_ net653 _1013_ _1014_ VGND VGND VPWR VPWR _1015_ sky130_fd_sc_hd__or3_1
X_7020_ _2448_ _2449_ _2446_ VGND VGND VPWR VPWR _2487_ sky130_fd_sc_hd__a21oi_1
XFILLER_101_207 VGND VGND VPWR VPWR sky130_fd_sc_hd__decap_8
Xclkbuf_leaf_4_clk clknet_3_4__leaf_clk VGND VGND VPWR VPWR clknet_leaf_4_clk sky130_fd_sc_hd__clkbuf_8
XFILLER_68_699 VGND VGND VPWR VPWR sky130_fd_sc_hd__fill_1
X_8971_ clknet_leaf_54_clk _0083_ VGND VGND VPWR VPWR pe_array\[1\].u_pe.weight_in\[6\]
+ sky130_fd_sc_hd__dfxtp_1
XFILLER_28_519 VGND VGND VPWR VPWR sky130_fd_sc_hd__fill_1
X_7922_ _3260_ _3286_ _3316_ VGND VGND VPWR VPWR _3318_ sky130_fd_sc_hd__or3_1
XFILLER_36_530 VGND VGND VPWR VPWR sky130_fd_sc_hd__fill_2
X_7853_ _3248_ _3249_ _3233_ VGND VGND VPWR VPWR _3251_ sky130_fd_sc_hd__a21o_1
XFILLER_51_500 VGND VGND VPWR VPWR sky130_fd_sc_hd__decap_4
XFILLER_63_393 VPWR VGND VPWR VGND sky130_ef_sc_hd__decap_12
X_6804_ _2250_ _2276_ VGND VGND VPWR VPWR _2277_ sky130_fd_sc_hd__or2_1
X_7784_ net1008 net225 _3201_ net376 VGND VGND VPWR VPWR _0353_ sky130_fd_sc_hd__o211a_1
X_4996_ _0682_ _0706_ _0705_ VGND VGND VPWR VPWR _0740_ sky130_fd_sc_hd__o21bai_1
X_6735_ net511 net342 pe_array\[1\].u_pe.accum_reg\[0\] VGND VGND VPWR VPWR _2212_
+ sky130_fd_sc_hd__a21oi_1
XFILLER_23_257 VGND VGND VPWR VPWR sky130_fd_sc_hd__fill_1
XFILLER_109_329 VGND VGND VPWR VPWR sky130_fd_sc_hd__decap_6
X_6666_ _2152_ _2180_ VGND VGND VPWR VPWR _2181_ sky130_fd_sc_hd__nand2_1
X_5617_ net1033 net386 VGND VGND VPWR VPWR _0158_ sky130_fd_sc_hd__and2_1
X_6597_ _2073_ _2074_ _2076_ VGND VGND VPWR VPWR _2114_ sky130_fd_sc_hd__a21oi_1
X_8405_ _3700_ _3788_ VGND VGND VPWR VPWR _3789_ sky130_fd_sc_hd__xnor2_1
X_5548_ net913 net393 VGND VGND VPWR VPWR _0089_ sky130_fd_sc_hd__and2_1
X_8336_ _3719_ _3720_ _3702_ VGND VGND VPWR VPWR _3722_ sky130_fd_sc_hd__o21a_1
XFILLER_117_373 VGND VGND VPWR VPWR sky130_fd_sc_hd__fill_1
XFILLER_105_513 VGND VGND VPWR VPWR sky130_fd_sc_hd__fill_1
X_8267_ _3613_ _3653_ _3654_ VGND VGND VPWR VPWR _3655_ sky130_fd_sc_hd__nand3_1
XFILLER_3_629 VPWR VGND VPWR VGND sky130_ef_sc_hd__decap_12
XFILLER_105_568 VGND VGND VPWR VPWR sky130_fd_sc_hd__fill_2
XFILLER_78_408 VGND VGND VPWR VPWR sky130_fd_sc_hd__fill_1
X_7218_ _2678_ _2679_ _2666_ VGND VGND VPWR VPWR _2681_ sky130_fd_sc_hd__a21o_1
X_5479_ net254 _4388_ VGND VGND VPWR VPWR _1200_ sky130_fd_sc_hd__nand2_1
Xfanout421 net422 VGND VGND VPWR VPWR net421 sky130_fd_sc_hd__clkbuf_4
Xfanout410 net413 VGND VGND VPWR VPWR net410 sky130_fd_sc_hd__clkbuf_2
X_8198_ _3581_ _3586_ VGND VGND VPWR VPWR _3587_ sky130_fd_sc_hd__nand2_1
Xfanout432 net9 VGND VGND VPWR VPWR net432 sky130_fd_sc_hd__clkbuf_4
Xfanout454 net608 VGND VGND VPWR VPWR net454 sky130_fd_sc_hd__buf_8
XFILLER_86_441 VPWR VGND VPWR VGND sky130_ef_sc_hd__decap_12
Xfanout443 net444 VGND VGND VPWR VPWR net443 sky130_fd_sc_hd__buf_6
Xfanout465 net468 VGND VGND VPWR VPWR net465 sky130_fd_sc_hd__clkbuf_2
X_7149_ _2524_ _2568_ _2567_ _2525_ VGND VGND VPWR VPWR _2614_ sky130_fd_sc_hd__or4_4
Xfanout498 net499 VGND VGND VPWR VPWR net498 sky130_fd_sc_hd__clkbuf_2
XFILLER_58_154 VGND VGND VPWR VPWR sky130_fd_sc_hd__fill_2
Xfanout476 net478 VGND VGND VPWR VPWR net476 sky130_fd_sc_hd__buf_2
Xfanout487 net489 VGND VGND VPWR VPWR net487 sky130_fd_sc_hd__buf_2
XFILLER_104_63 VGND VGND VPWR VPWR sky130_fd_sc_hd__decap_4
XFILLER_104_41 VGND VGND VPWR VPWR sky130_fd_sc_hd__decap_6
XFILLER_73_113 VGND VGND VPWR VPWR sky130_fd_sc_hd__fill_1
XFILLER_46_327 VGND VGND VPWR VPWR sky130_fd_sc_hd__decap_3
XFILLER_104_85 VGND VGND VPWR VPWR sky130_fd_sc_hd__fill_2
XTAP_TAPCELL_ROW_64_1025 VGND VPWR sky130_fd_sc_hd__tapvpwrvgnd_1
XTAP_TAPCELL_ROW_12_403 VGND VPWR sky130_fd_sc_hd__tapvpwrvgnd_1
XTAP_TAPCELL_ROW_40_734 VGND VPWR sky130_fd_sc_hd__tapvpwrvgnd_1
XFILLER_10_463 VPWR VGND VPWR VGND sky130_ef_sc_hd__decap_12
XFILLER_6_445 VPWR VGND VPWR VGND sky130_ef_sc_hd__decap_12
XTAP_TAPCELL_ROW_20_491 VGND VPWR sky130_fd_sc_hd__tapvpwrvgnd_1
XTAP_TAPCELL_ROW_75_1154 VGND VPWR sky130_fd_sc_hd__tapvpwrvgnd_1
XFILLER_111_538 VGND VGND VPWR VPWR sky130_fd_sc_hd__fill_2
XFILLER_111_505 VPWR VGND VPWR VGND sky130_ef_sc_hd__decap_12
XFILLER_65_614 VGND VGND VPWR VPWR sky130_fd_sc_hd__fill_2
XTAP_TAPCELL_ROW_48_834 VGND VPWR sky130_fd_sc_hd__tapvpwrvgnd_1
XFILLER_49_176 VGND VGND VPWR VPWR sky130_fd_sc_hd__fill_2
Xclkbuf_3_7__f_clk clknet_0_clk VGND VGND VPWR VPWR clknet_3_7__leaf_clk sky130_fd_sc_hd__clkbuf_16
XFILLER_92_477 VGND VGND VPWR VPWR sky130_fd_sc_hd__fill_1
XTAP_TAPCELL_ROW_86_1283 VGND VPWR sky130_fd_sc_hd__tapvpwrvgnd_1
X_4850_ _0559_ _0560_ _0558_ VGND VGND VPWR VPWR _0597_ sky130_fd_sc_hd__a21oi_1
XTAP_TAPCELL_ROW_28_591 VGND VPWR sky130_fd_sc_hd__tapvpwrvgnd_1
XFILLER_45_393 VPWR VGND VPWR VGND sky130_ef_sc_hd__decap_12
XFILLER_20_205 VGND VGND VPWR VPWR sky130_fd_sc_hd__fill_2
X_6520_ net429 _2039_ VGND VGND VPWR VPWR _0251_ sky130_fd_sc_hd__nor2_1
X_4781_ _0528_ _0527_ _0519_ VGND VGND VPWR VPWR _0530_ sky130_fd_sc_hd__a21o_1
XFILLER_20_249 VGND VGND VPWR VPWR sky130_fd_sc_hd__decap_3
X_6451_ _1970_ _1971_ VGND VGND VPWR VPWR _1973_ sky130_fd_sc_hd__xnor2_1
Xclkload20 clknet_leaf_67_clk VGND VGND VPWR VPWR clkload20/Y sky130_fd_sc_hd__inv_6
X_9170_ clknet_leaf_23_clk _0282_ VGND VGND VPWR VPWR pe_accum\[0\]\[24\] sky130_fd_sc_hd__dfxtp_1
Xclkload42 clknet_leaf_12_clk VGND VGND VPWR VPWR clkload42/Y sky130_fd_sc_hd__clkinv_8
X_6382_ net202 _1905_ VGND VGND VPWR VPWR _1906_ sky130_fd_sc_hd__xnor2_1
Xclkload53 clknet_leaf_36_clk VGND VGND VPWR VPWR clkload53/Y sky130_fd_sc_hd__clkinv_4
X_5402_ _1097_ _1099_ VGND VGND VPWR VPWR _1132_ sky130_fd_sc_hd__or2_1
Xclkload31 clknet_leaf_42_clk VGND VGND VPWR VPWR clkload31/Y sky130_fd_sc_hd__inv_6
X_8121_ net680 _3510_ _3511_ VGND VGND VPWR VPWR _3512_ sky130_fd_sc_hd__nor3_2
X_5333_ pe_array\[3\].u_pe.accum_reg\[27\] net301 net629 VGND VGND VPWR VPWR _1065_
+ sky130_fd_sc_hd__and3_1
XFILLER_114_365 VGND VGND VPWR VPWR sky130_fd_sc_hd__decap_3
XFILLER_87_205 VGND VGND VPWR VPWR sky130_fd_sc_hd__decap_6
XPHY_EDGE_ROW_81_Left_199 VGND VGND VPWR VPWR sky130_fd_sc_hd__decap_3
X_8052_ _3362_ _3397_ _3396_ VGND VGND VPWR VPWR _3445_ sky130_fd_sc_hd__a21o_1
X_5264_ net185 _0998_ VGND VGND VPWR VPWR _0999_ sky130_fd_sc_hd__nor2_1
X_5195_ net205 _0930_ _0931_ VGND VGND VPWR VPWR _0932_ sky130_fd_sc_hd__and3_1
X_7003_ _2468_ _2467_ _2469_ VGND VGND VPWR VPWR _2471_ sky130_fd_sc_hd__a21o_1
XFILLER_56_614 VGND VGND VPWR VPWR sky130_fd_sc_hd__fill_2
XFILLER_95_271 VGND VGND VPWR VPWR sky130_fd_sc_hd__decap_4
XFILLER_56_636 VGND VGND VPWR VPWR sky130_fd_sc_hd__decap_8
XFILLER_55_113 VPWR VGND VPWR VGND sky130_ef_sc_hd__decap_12
XFILLER_18_27 VGND VGND VPWR VPWR sky130_fd_sc_hd__fill_1
XFILLER_83_444 VGND VGND VPWR VPWR sky130_fd_sc_hd__decap_4
XFILLER_71_617 VPWR VGND VPWR VGND sky130_ef_sc_hd__decap_12
XFILLER_56_669 VPWR VGND VPWR VGND sky130_ef_sc_hd__decap_12
X_8954_ clknet_leaf_64_clk _0066_ VGND VGND VPWR VPWR pe_accum\[3\]\[22\] sky130_fd_sc_hd__dfxtp_1
X_8885_ net998 net214 _4223_ net386 VGND VGND VPWR VPWR _0432_ sky130_fd_sc_hd__o211a_1
X_7905_ net325 _3299_ _3300_ VGND VGND VPWR VPWR _3301_ sky130_fd_sc_hd__a21bo_1
X_7836_ _3232_ _3233_ _3234_ VGND VGND VPWR VPWR _3235_ sky130_fd_sc_hd__or3_2
XFILLER_51_374 VGND VGND VPWR VPWR sky130_fd_sc_hd__fill_1
XFILLER_24_566 VGND VGND VPWR VPWR sky130_fd_sc_hd__fill_2
X_7767_ _2849_ net222 VGND VGND VPWR VPWR _3193_ sky130_fd_sc_hd__nand2_1
X_4979_ net283 _0720_ _0721_ VGND VGND VPWR VPWR _0723_ sky130_fd_sc_hd__or3_4
X_6718_ net942 net233 _2185_ _0085_ VGND VGND VPWR VPWR _0288_ sky130_fd_sc_hd__a22o_1
Xclkload3 clknet_3_3__leaf_clk VGND VGND VPWR VPWR clkload3/Y sky130_fd_sc_hd__inv_8
X_7698_ _3143_ _3144_ VGND VGND VPWR VPWR _3145_ sky130_fd_sc_hd__nor2_1
X_6649_ _1393_ _2163_ VGND VGND VPWR VPWR _2164_ sky130_fd_sc_hd__xnor2_1
XFILLER_109_159 VGND VGND VPWR VPWR sky130_fd_sc_hd__decap_8
X_9299_ clknet_leaf_4_clk _0411_ VGND VGND VPWR VPWR pe_accum\[2\]\[9\] sky130_fd_sc_hd__dfxtp_1
X_8319_ net684 _3703_ _3704_ VGND VGND VPWR VPWR _3705_ sky130_fd_sc_hd__nor3_1
Xfanout240 net241 VGND VGND VPWR VPWR net240 sky130_fd_sc_hd__buf_2
XFILLER_115_51 VGND VGND VPWR VPWR sky130_fd_sc_hd__decap_4
Xfanout262 net265 VGND VGND VPWR VPWR net262 sky130_fd_sc_hd__buf_8
Xfanout251 net252 VGND VGND VPWR VPWR net251 sky130_fd_sc_hd__buf_2
Xfanout273 _2413_ VGND VGND VPWR VPWR net273 sky130_fd_sc_hd__buf_8
XFILLER_47_603 VGND VGND VPWR VPWR sky130_fd_sc_hd__fill_1
XFILLER_101_593 VPWR VGND VPWR VGND sky130_ef_sc_hd__decap_12
XFILLER_75_22 VGND VGND VPWR VPWR sky130_fd_sc_hd__fill_1
XTAP_TAPCELL_ROW_70_1095 VGND VPWR sky130_fd_sc_hd__tapvpwrvgnd_1
Xfanout295 net297 VGND VGND VPWR VPWR net295 sky130_fd_sc_hd__buf_2
Xfanout284 _0482_ VGND VGND VPWR VPWR net284 sky130_fd_sc_hd__buf_6
XTAP_TAPCELL_ROW_109_1559 VGND VPWR sky130_fd_sc_hd__tapvpwrvgnd_1
XFILLER_75_88 VPWR VGND VPWR VGND sky130_ef_sc_hd__decap_12
XFILLER_19_349 VPWR VGND VPWR VGND sky130_ef_sc_hd__decap_12
XTAP_TAPCELL_ROW_25_550 VGND VPWR sky130_fd_sc_hd__tapvpwrvgnd_1
XTAP_TAPCELL_ROW_53_892 VGND VPWR sky130_fd_sc_hd__tapvpwrvgnd_1
XFILLER_109_671 VGND VGND VPWR VPWR sky130_fd_sc_hd__fill_1
XFILLER_6_297 VGND VGND VPWR VPWR sky130_fd_sc_hd__decap_8
XFILLER_40_91 VGND VGND VPWR VPWR sky130_fd_sc_hd__fill_1
XFILLER_97_547 VGND VGND VPWR VPWR sky130_fd_sc_hd__fill_1
XTAP_TAPCELL_ROW_88_1312 VGND VPWR sky130_fd_sc_hd__tapvpwrvgnd_1
XFILLER_37_113 VGND VGND VPWR VPWR sky130_fd_sc_hd__decap_4
XFILLER_38_625 VPWR VGND VPWR VGND sky130_ef_sc_hd__decap_12
XFILLER_77_293 VGND VGND VPWR VPWR sky130_fd_sc_hd__decap_4
X_5951_ _1439_ _1441_ _1485_ _1486_ VGND VGND VPWR VPWR _1487_ sky130_fd_sc_hd__o211ai_2
XFILLER_65_488 VGND VGND VPWR VPWR sky130_fd_sc_hd__decap_4
XFILLER_52_105 VGND VGND VPWR VPWR sky130_fd_sc_hd__fill_2
X_8670_ net192 _4043_ VGND VGND VPWR VPWR _4045_ sky130_fd_sc_hd__xnor2_1
X_4902_ _0602_ _0645_ _0646_ VGND VGND VPWR VPWR _0648_ sky130_fd_sc_hd__a21oi_1
X_5882_ net428 _1419_ VGND VGND VPWR VPWR _0233_ sky130_fd_sc_hd__nor2_1
X_4833_ _0577_ _0578_ _0579_ VGND VGND VPWR VPWR _0581_ sky130_fd_sc_hd__a21o_1
X_7621_ _3038_ _3066_ VGND VGND VPWR VPWR _3070_ sky130_fd_sc_hd__or2_1
XFILLER_60_193 VGND VGND VPWR VPWR sky130_fd_sc_hd__decap_3
X_4764_ _0511_ _0512_ VGND VGND VPWR VPWR _0513_ sky130_fd_sc_hd__xnor2_1
X_7552_ _2700_ _3002_ VGND VGND VPWR VPWR _3004_ sky130_fd_sc_hd__xnor2_1
X_6503_ net654 _2022_ VGND VGND VPWR VPWR _2023_ sky130_fd_sc_hd__nor2_1
XTAP_TAPCELL_ROW_99_1441 VGND VPWR sky130_fd_sc_hd__tapvpwrvgnd_1
X_7483_ _2905_ _2906_ _2935_ _2936_ VGND VGND VPWR VPWR _2937_ sky130_fd_sc_hd__o211a_1
X_6434_ _1952_ _1953_ net279 VGND VGND VPWR VPWR _1956_ sky130_fd_sc_hd__o21ai_1
X_4695_ _4405_ _4407_ _0444_ _0445_ VGND VGND VPWR VPWR _0446_ sky130_fd_sc_hd__o211ai_2
X_9222_ clknet_leaf_41_clk _0334_ VGND VGND VPWR VPWR pe_accum\[1\]\[8\] sky130_fd_sc_hd__dfxtp_1
XFILLER_115_641 VPWR VGND VPWR VGND sky130_ef_sc_hd__decap_12
X_9153_ clknet_leaf_22_clk _0265_ VGND VGND VPWR VPWR pe_accum\[0\]\[7\] sky130_fd_sc_hd__dfxtp_1
X_6365_ _1888_ _1887_ VGND VGND VPWR VPWR _1890_ sky130_fd_sc_hd__xor2_2
XFILLER_115_685 VPWR VGND VPWR VGND sky130_ef_sc_hd__decap_12
XFILLER_114_162 VGND VGND VPWR VPWR sky130_fd_sc_hd__fill_2
X_6296_ _1819_ _1820_ _1821_ VGND VGND VPWR VPWR _1823_ sky130_fd_sc_hd__a21oi_1
X_8104_ net483 _4238_ VGND VGND VPWR VPWR _3495_ sky130_fd_sc_hd__or2_1
XFILLER_0_418 VGND VGND VPWR VPWR sky130_fd_sc_hd__fill_2
X_5316_ _1047_ _1048_ VGND VGND VPWR VPWR _1049_ sky130_fd_sc_hd__xnor2_1
X_9084_ clknet_leaf_68_clk _0196_ VGND VGND VPWR VPWR net34 sky130_fd_sc_hd__dfxtp_1
XFILLER_114_184 VGND VGND VPWR VPWR sky130_fd_sc_hd__decap_4
X_8035_ _3424_ _3425_ net463 net321 VGND VGND VPWR VPWR _3428_ sky130_fd_sc_hd__a2bb2o_1
X_5247_ _0921_ _0893_ _0947_ _0976_ VGND VGND VPWR VPWR _0982_ sky130_fd_sc_hd__nor4_4
XFILLER_88_569 VGND VGND VPWR VPWR sky130_fd_sc_hd__decap_4
X_5178_ _0913_ _0914_ VGND VGND VPWR VPWR _0916_ sky130_fd_sc_hd__xor2_1
XFILLER_29_614 VGND VGND VPWR VPWR sky130_fd_sc_hd__fill_2
XFILLER_83_241 VGND VGND VPWR VPWR sky130_fd_sc_hd__decap_4
XFILLER_83_274 VGND VGND VPWR VPWR sky130_fd_sc_hd__decap_6
X_8937_ clknet_leaf_59_clk _0049_ VGND VGND VPWR VPWR pe_accum\[3\]\[5\] sky130_fd_sc_hd__dfxtp_1
XTAP_TAPCELL_ROW_3_289 VGND VPWR sky130_fd_sc_hd__tapvpwrvgnd_1
XFILLER_45_69 VPWR VGND VPWR VGND sky130_ef_sc_hd__decap_12
X_8868_ net212 _3946_ VGND VGND VPWR VPWR _4215_ sky130_fd_sc_hd__nand2_2
X_7819_ net403 pe_array\[2\].u_pe.accum_reg\[0\] net219 _3219_ VGND VGND VPWR VPWR
+ _3220_ sky130_fd_sc_hd__o2bb2a_1
X_8799_ _4168_ _4169_ VGND VGND VPWR VPWR _4170_ sky130_fd_sc_hd__nor2_1
XFILLER_61_57 VPWR VGND VPWR VGND sky130_ef_sc_hd__decap_12
XTAP_TAPCELL_ROW_22_520 VGND VPWR sky130_fd_sc_hd__tapvpwrvgnd_1
XTAP_TAPCELL_ROW_50_851 VGND VPWR sky130_fd_sc_hd__tapvpwrvgnd_1
XTAP_TAPCELL_ROW_72_1113 VGND VPWR sky130_fd_sc_hd__tapvpwrvgnd_1
XFILLER_10_61 VGND VGND VPWR VPWR sky130_fd_sc_hd__decap_8
XFILLER_105_195 VGND VGND VPWR VPWR sky130_fd_sc_hd__fill_1
XFILLER_86_65 VGND VGND VPWR VPWR sky130_fd_sc_hd__fill_1
XFILLER_86_76 VGND VGND VPWR VPWR sky130_fd_sc_hd__decap_8
XFILLER_19_113 VGND VGND VPWR VPWR sky130_fd_sc_hd__fill_2
XFILLER_101_390 VGND VGND VPWR VPWR sky130_fd_sc_hd__fill_2
XTAP_TAPCELL_ROW_58_951 VGND VPWR sky130_fd_sc_hd__tapvpwrvgnd_1
XFILLER_19_146 VPWR VGND VPWR VGND sky130_ef_sc_hd__decap_12
XFILLER_35_617 VGND VGND VPWR VPWR sky130_fd_sc_hd__decap_4
XFILLER_47_488 VPWR VGND VPWR VGND sky130_ef_sc_hd__decap_12
XTAP_TAPCELL_ROW_83_1253 VGND VPWR sky130_fd_sc_hd__tapvpwrvgnd_1
XFILLER_96_7 VGND VGND VPWR VPWR sky130_fd_sc_hd__fill_1
XFILLER_70_491 VGND VGND VPWR VPWR sky130_fd_sc_hd__decap_4
XFILLER_15_385 VGND VGND VPWR VPWR sky130_fd_sc_hd__decap_6
XFILLER_30_355 VGND VGND VPWR VPWR sky130_fd_sc_hd__decap_4
Xhold518 pe_accum\[2\]\[8\] VGND VGND VPWR VPWR net1033 sky130_fd_sc_hd__dlygate4sd3_1
Xhold507 pe_array\[2\].u_pe.tap_count\[3\] VGND VGND VPWR VPWR net1022 sky130_fd_sc_hd__dlygate4sd3_1
X_4480_ pe_array\[3\].u_pe.tap_count\[3\] _4247_ net253 net416 VGND VGND VPWR VPWR
+ _4250_ sky130_fd_sc_hd__a211o_1
XTAP_TAPCELL_ROW_94_1382 VGND VPWR sky130_fd_sc_hd__tapvpwrvgnd_1
X_6150_ net655 _1680_ VGND VGND VPWR VPWR _1681_ sky130_fd_sc_hd__nand2_1
X_5101_ _0841_ _0839_ VGND VGND VPWR VPWR _0842_ sky130_fd_sc_hd__and2b_1
XFILLER_97_366 VPWR VGND VPWR VGND sky130_ef_sc_hd__decap_12
X_6081_ _1610_ _1611_ net656 VGND VGND VPWR VPWR _1614_ sky130_fd_sc_hd__o21ai_1
XFILLER_112_699 VGND VGND VPWR VPWR sky130_fd_sc_hd__fill_1
X_5032_ _0772_ _0773_ _0741_ VGND VGND VPWR VPWR _0775_ sky130_fd_sc_hd__a21oi_1
XFILLER_111_198 VPWR VGND VPWR VGND sky130_ef_sc_hd__decap_12
XFILLER_80_211 VGND VGND VPWR VPWR sky130_fd_sc_hd__fill_1
XTAP_TAPCELL_ROW_0_237 VGND VPWR sky130_fd_sc_hd__tapvpwrvgnd_1
XTAP_TAPCELL_ROW_0_248 VGND VPWR sky130_fd_sc_hd__tapvpwrvgnd_1
XTAP_TAPCELL_ROW_0_259 VGND VPWR sky130_fd_sc_hd__tapvpwrvgnd_1
X_6983_ _2445_ _2450_ VGND VGND VPWR VPWR _2451_ sky130_fd_sc_hd__nand2b_1
X_8722_ _4090_ _4093_ _4094_ _4085_ VGND VGND VPWR VPWR _4095_ sky130_fd_sc_hd__o211a_1
X_5934_ _1468_ _1469_ VGND VGND VPWR VPWR _1470_ sky130_fd_sc_hd__nor2_1
XFILLER_15_39 VPWR VGND VPWR VGND sky130_ef_sc_hd__decap_12
XFILLER_41_609 VGND VGND VPWR VPWR sky130_fd_sc_hd__decap_6
X_8653_ net159 _4000_ _3999_ VGND VGND VPWR VPWR _4029_ sky130_fd_sc_hd__a21oi_1
X_5865_ _1401_ _1402_ VGND VGND VPWR VPWR _1403_ sky130_fd_sc_hd__and2b_1
XTAP_TAPCELL_ROW_36_689 VGND VPWR sky130_fd_sc_hd__tapvpwrvgnd_1
XFILLER_61_491 VGND VGND VPWR VPWR sky130_fd_sc_hd__decap_4
X_7604_ _3052_ _3053_ VGND VGND VPWR VPWR _3054_ sky130_fd_sc_hd__xnor2_1
X_4816_ _0555_ _0563_ VGND VGND VPWR VPWR _0564_ sky130_fd_sc_hd__nand2b_1
X_8584_ net162 _3930_ _3929_ VGND VGND VPWR VPWR _3962_ sky130_fd_sc_hd__o21bai_1
X_5796_ _1334_ _1335_ VGND VGND VPWR VPWR _1336_ sky130_fd_sc_hd__nor2_2
X_7535_ _2964_ _2962_ _2987_ VGND VGND VPWR VPWR _2988_ sky130_fd_sc_hd__a21o_1
XFILLER_31_27 VGND VGND VPWR VPWR sky130_fd_sc_hd__decap_6
X_4747_ _0494_ _0495_ _0452_ _0454_ VGND VGND VPWR VPWR _0497_ sky130_fd_sc_hd__a211oi_2
X_4678_ _4437_ _4438_ VGND VGND VPWR VPWR _4439_ sky130_fd_sc_hd__nor2_1
X_7466_ net156 _2920_ VGND VGND VPWR VPWR _2921_ sky130_fd_sc_hd__xnor2_2
X_6417_ _1716_ _1913_ _1912_ VGND VGND VPWR VPWR _1940_ sky130_fd_sc_hd__a21oi_1
X_7397_ net267 _2851_ _2852_ VGND VGND VPWR VPWR _2854_ sky130_fd_sc_hd__or3_1
X_9205_ clknet_leaf_44_clk _0317_ VGND VGND VPWR VPWR pe_array\[1\].u_pe.accum_reg\[23\]
+ sky130_fd_sc_hd__dfxtp_1
X_9136_ clknet_leaf_26_clk _0248_ VGND VGND VPWR VPWR pe_array\[0\].u_pe.accum_reg\[22\]
+ sky130_fd_sc_hd__dfxtp_1
X_6348_ net707 _1871_ _1872_ VGND VGND VPWR VPWR _1873_ sky130_fd_sc_hd__nor3_1
Xoutput27 net27 VGND VGND VPWR VPWR result_data[104] sky130_fd_sc_hd__buf_2
Xoutput49 net49 VGND VGND VPWR VPWR result_data[124] sky130_fd_sc_hd__buf_2
Xoutput38 net38 VGND VGND VPWR VPWR result_data[114] sky130_fd_sc_hd__buf_2
XFILLER_103_611 VGND VGND VPWR VPWR sky130_fd_sc_hd__decap_4
XTAP_TAPCELL_ROW_8_348 VGND VPWR sky130_fd_sc_hd__tapvpwrvgnd_1
X_9067_ clknet_leaf_10_clk _0179_ VGND VGND VPWR VPWR net142 sky130_fd_sc_hd__dfxtp_1
X_6279_ _1804_ _1806_ VGND VGND VPWR VPWR _1807_ sky130_fd_sc_hd__nand2_1
XFILLER_69_580 VPWR VGND VPWR VGND sky130_ef_sc_hd__decap_12
X_8018_ _3407_ _3410_ VGND VGND VPWR VPWR _3411_ sky130_fd_sc_hd__xnor2_1
XFILLER_29_422 VGND VGND VPWR VPWR sky130_fd_sc_hd__decap_8
XTAP_TAPCELL_ROW_55_910 VGND VPWR sky130_fd_sc_hd__tapvpwrvgnd_1
XFILLER_17_606 VGND VGND VPWR VPWR sky130_fd_sc_hd__fill_2
XFILLER_17_617 VGND VGND VPWR VPWR sky130_fd_sc_hd__fill_2
XFILLER_29_466 VGND VGND VPWR VPWR sky130_fd_sc_hd__decap_4
XFILLER_112_41 VPWR VGND VPWR VGND sky130_ef_sc_hd__decap_12
XTAP_TAPCELL_ROW_106_1529 VGND VPWR sky130_fd_sc_hd__tapvpwrvgnd_1
XFILLER_56_296 VGND VGND VPWR VPWR sky130_fd_sc_hd__fill_1
XFILLER_112_85 VPWR VGND VPWR VGND sky130_ef_sc_hd__decap_12
XFILLER_25_650 VGND VGND VPWR VPWR sky130_fd_sc_hd__fill_1
XFILLER_12_388 VPWR VGND VPWR VGND sky130_ef_sc_hd__decap_12
XFILLER_12_377 VGND VGND VPWR VPWR sky130_fd_sc_hd__decap_3
XFILLER_12_355 VGND VGND VPWR VPWR sky130_fd_sc_hd__decap_8
XTAP_TAPCELL_ROW_117_1669 VGND VPWR sky130_fd_sc_hd__tapvpwrvgnd_1
XTAP_TAPCELL_ROW_117_1658 VGND VPWR sky130_fd_sc_hd__tapvpwrvgnd_1
XFILLER_98_119 VPWR VGND VPWR VGND sky130_ef_sc_hd__decap_12
XFILLER_4_587 VGND VGND VPWR VPWR sky130_fd_sc_hd__fill_1
XFILLER_79_388 VGND VGND VPWR VPWR sky130_fd_sc_hd__fill_1
XFILLER_94_336 VGND VGND VPWR VPWR sky130_fd_sc_hd__fill_1
XFILLER_75_561 VGND VGND VPWR VPWR sky130_fd_sc_hd__decap_8
XFILLER_90_586 VGND VGND VPWR VPWR sky130_fd_sc_hd__fill_2
XFILLER_16_694 VGND VGND VPWR VPWR sky130_fd_sc_hd__fill_2
Xclkbuf_0_clk clk VGND VGND VPWR VPWR clknet_0_clk sky130_fd_sc_hd__clkbuf_16
X_5650_ net930 net366 VGND VGND VPWR VPWR _0191_ sky130_fd_sc_hd__and2_1
XTAP_TAPCELL_ROW_33_648 VGND VPWR sky130_fd_sc_hd__tapvpwrvgnd_1
X_4601_ net304 net469 net460 net307 VGND VGND VPWR VPWR _4364_ sky130_fd_sc_hd__a22o_1
XFILLER_30_152 VGND VGND VPWR VPWR sky130_fd_sc_hd__decap_3
XTAP_TAPCELL_ROW_96_1400 VGND VPWR sky130_fd_sc_hd__tapvpwrvgnd_1
X_5581_ net1023 net378 VGND VGND VPWR VPWR _0122_ sky130_fd_sc_hd__and2_1
XTAP_TAPCELL_ROW_96_1411 VGND VPWR sky130_fd_sc_hd__tapvpwrvgnd_1
X_7320_ net165 _2778_ _2779_ VGND VGND VPWR VPWR _2780_ sky130_fd_sc_hd__or3_4
XFILLER_7_51 VGND VGND VPWR VPWR sky130_fd_sc_hd__decap_4
X_4532_ net416 _4297_ VGND VGND VPWR VPWR _0015_ sky130_fd_sc_hd__nor2_1
X_4463_ net15 _4240_ _4241_ net352 VGND VGND VPWR VPWR _0002_ sky130_fd_sc_hd__a22o_1
X_7251_ _2711_ _2710_ _2712_ VGND VGND VPWR VPWR _2713_ sky130_fd_sc_hd__and3_1
XFILLER_104_419 VGND VGND VPWR VPWR sky130_fd_sc_hd__fill_1
XFILLER_104_408 VGND VGND VPWR VPWR sky130_fd_sc_hd__fill_2
X_6202_ net173 _1730_ _1731_ VGND VGND VPWR VPWR _1732_ sky130_fd_sc_hd__or3_4
XPHY_EDGE_ROW_15_Right_15 VGND VGND VPWR VPWR sky130_fd_sc_hd__decap_3
X_7182_ _2597_ _2600_ _2644_ _2645_ VGND VGND VPWR VPWR _2646_ sky130_fd_sc_hd__a211oi_2
X_6133_ _1662_ _1663_ _1621_ _1624_ VGND VGND VPWR VPWR _1665_ sky130_fd_sc_hd__o211a_1
XTAP_TAPCELL_ROW_5_318 VGND VPWR sky130_fd_sc_hd__tapvpwrvgnd_1
XFILLER_100_614 VGND VGND VPWR VPWR sky130_fd_sc_hd__fill_2
X_6064_ _1550_ net151 _1593_ _1596_ VGND VGND VPWR VPWR _1597_ sky130_fd_sc_hd__a31o_4
XFILLER_58_517 VPWR VGND VPWR VGND sky130_ef_sc_hd__decap_12
XFILLER_85_347 VGND VGND VPWR VPWR sky130_fd_sc_hd__decap_8
X_5015_ net688 _0755_ _0757_ VGND VGND VPWR VPWR _0758_ sky130_fd_sc_hd__or3b_1
XFILLER_38_263 VGND VGND VPWR VPWR sky130_fd_sc_hd__decap_4
Xclone191 net281 VGND VGND VPWR VPWR net706 sky130_fd_sc_hd__clkbuf_1
XFILLER_53_222 VGND VGND VPWR VPWR sky130_fd_sc_hd__fill_2
XFILLER_53_266 VGND VGND VPWR VPWR sky130_fd_sc_hd__fill_2
XFILLER_53_233 VGND VGND VPWR VPWR sky130_fd_sc_hd__decap_3
XPHY_EDGE_ROW_24_Right_24 VGND VGND VPWR VPWR sky130_fd_sc_hd__decap_3
X_6966_ _2395_ _2433_ VGND VGND VPWR VPWR _2435_ sky130_fd_sc_hd__xor2_1
X_8705_ net176 _4077_ VGND VGND VPWR VPWR _4079_ sky130_fd_sc_hd__xnor2_1
X_5917_ _1403_ _1405_ _1452_ _1453_ VGND VGND VPWR VPWR _1454_ sky130_fd_sc_hd__o211a_2
XFILLER_22_620 VGND VGND VPWR VPWR sky130_fd_sc_hd__decap_8
XFILLER_22_642 VGND VGND VPWR VPWR sky130_fd_sc_hd__fill_2
XFILLER_42_15 VPWR VGND VPWR VGND sky130_ef_sc_hd__decap_12
X_6897_ net449 net341 VGND VGND VPWR VPWR _2367_ sky130_fd_sc_hd__and2_2
X_8636_ pe_array\[2\].u_pe.accum_reg\[25\] net442 net316 VGND VGND VPWR VPWR _4012_
+ sky130_fd_sc_hd__and3_1
X_5848_ _1381_ _1385_ VGND VGND VPWR VPWR _1386_ sky130_fd_sc_hd__xor2_1
X_8567_ _3945_ _3944_ VGND VGND VPWR VPWR _3946_ sky130_fd_sc_hd__or2_4
X_5779_ _1317_ _1318_ VGND VGND VPWR VPWR _1319_ sky130_fd_sc_hd__nor2_1
XFILLER_21_196 VGND VGND VPWR VPWR sky130_fd_sc_hd__fill_1
X_7518_ _2968_ _2969_ _2933_ _2934_ VGND VGND VPWR VPWR _2971_ sky130_fd_sc_hd__a211o_1
X_8498_ _3823_ _3851_ VGND VGND VPWR VPWR _3879_ sky130_fd_sc_hd__nand2_1
XFILLER_107_279 VGND VGND VPWR VPWR sky130_fd_sc_hd__fill_1
X_7449_ net447 net340 pe_array\[1\].u_pe.accum_reg\[22\] VGND VGND VPWR VPWR _2904_
+ sky130_fd_sc_hd__a21oi_1
XPHY_EDGE_ROW_33_Right_33 VGND VGND VPWR VPWR sky130_fd_sc_hd__decap_3
XFILLER_88_130 VGND VGND VPWR VPWR sky130_fd_sc_hd__decap_8
X_9119_ clknet_leaf_18_clk _0231_ VGND VGND VPWR VPWR pe_array\[0\].u_pe.accum_reg\[5\]
+ sky130_fd_sc_hd__dfxtp_1
XTAP_TAPCELL_ROW_112_1599 VGND VPWR sky130_fd_sc_hd__tapvpwrvgnd_1
XFILLER_67_78 VPWR VGND VPWR VGND sky130_ef_sc_hd__decap_12
XFILLER_57_561 VPWR VGND VPWR VGND sky130_ef_sc_hd__decap_12
XFILLER_84_391 VGND VGND VPWR VPWR sky130_fd_sc_hd__decap_3
XFILLER_84_380 VGND VGND VPWR VPWR sky130_fd_sc_hd__decap_4
XPHY_EDGE_ROW_42_Right_42 VGND VGND VPWR VPWR sky130_fd_sc_hd__decap_3
XFILLER_44_211 VGND VGND VPWR VPWR sky130_fd_sc_hd__decap_4
XFILLER_44_222 VGND VGND VPWR VPWR sky130_fd_sc_hd__decap_3
XTAP_TAPCELL_ROW_67_1056 VGND VPWR sky130_fd_sc_hd__tapvpwrvgnd_1
XFILLER_17_447 VGND VGND VPWR VPWR sky130_fd_sc_hd__fill_1
XFILLER_44_233 VGND VGND VPWR VPWR sky130_fd_sc_hd__fill_2
XFILLER_16_60 VGND VGND VPWR VPWR sky130_fd_sc_hd__decap_4
XTAP_TAPCELL_ROW_80_1212 VGND VPWR sky130_fd_sc_hd__tapvpwrvgnd_1
XFILLER_12_141 VGND VGND VPWR VPWR sky130_fd_sc_hd__decap_4
XTAP_TAPCELL_ROW_30_618 VGND VPWR sky130_fd_sc_hd__tapvpwrvgnd_1
XFILLER_9_668 VGND VGND VPWR VPWR sky130_fd_sc_hd__decap_4
XPHY_EDGE_ROW_51_Right_51 VGND VGND VPWR VPWR sky130_fd_sc_hd__decap_3
XTAP_TAPCELL_ROW_10_375 VGND VPWR sky130_fd_sc_hd__tapvpwrvgnd_1
XTAP_TAPCELL_ROW_78_1185 VGND VPWR sky130_fd_sc_hd__tapvpwrvgnd_1
XFILLER_59_7 VPWR VGND VPWR VGND sky130_ef_sc_hd__decap_12
XTAP_TAPCELL_ROW_91_1341 VGND VPWR sky130_fd_sc_hd__tapvpwrvgnd_1
XFILLER_95_623 VGND VGND VPWR VPWR sky130_fd_sc_hd__fill_2
XPHY_EDGE_ROW_60_Right_60 VGND VGND VPWR VPWR sky130_fd_sc_hd__decap_3
XTAP_TAPCELL_ROW_38_707 VGND VPWR sky130_fd_sc_hd__tapvpwrvgnd_1
XFILLER_48_583 VGND VGND VPWR VPWR sky130_fd_sc_hd__decap_4
X_6820_ net473 net343 pe_array\[1\].u_pe.accum_reg\[5\] VGND VGND VPWR VPWR _2292_
+ sky130_fd_sc_hd__a21oi_1
XFILLER_35_233 VGND VGND VPWR VPWR sky130_fd_sc_hd__fill_2
XFILLER_63_575 VGND VGND VPWR VPWR sky130_fd_sc_hd__fill_1
XTAP_TAPCELL_ROW_18_464 VGND VPWR sky130_fd_sc_hd__tapvpwrvgnd_1
XTAP_TAPCELL_ROW_18_475 VGND VPWR sky130_fd_sc_hd__tapvpwrvgnd_1
XFILLER_23_417 VGND VGND VPWR VPWR sky130_fd_sc_hd__decap_8
X_6751_ net591 net336 _2223_ _2224_ VGND VGND VPWR VPWR _2226_ sky130_fd_sc_hd__o2bb2a_1
XFILLER_35_299 VGND VGND VPWR VPWR sky130_fd_sc_hd__fill_1
XFILLER_50_247 VGND VGND VPWR VPWR sky130_fd_sc_hd__decap_4
X_5702_ pe_array\[0\].u_pe.accum_reg\[1\] net505 net356 VGND VGND VPWR VPWR _1246_
+ sky130_fd_sc_hd__and3_1
X_6682_ _2187_ _2195_ VGND VGND VPWR VPWR _2196_ sky130_fd_sc_hd__xnor2_1
X_5633_ net916 net383 VGND VGND VPWR VPWR _0174_ sky130_fd_sc_hd__and2_1
X_8421_ _3771_ _3772_ _3801_ _3802_ VGND VGND VPWR VPWR _3804_ sky130_fd_sc_hd__o211ai_1
X_5564_ net909 net395 VGND VGND VPWR VPWR _0105_ sky130_fd_sc_hd__and2_1
X_8352_ _3704_ _3705_ _3735_ _3736_ VGND VGND VPWR VPWR _3737_ sky130_fd_sc_hd__o211a_1
XFILLER_12_29 VPWR VGND VPWR VGND sky130_ef_sc_hd__decap_12
XFILLER_117_533 VGND VGND VPWR VPWR sky130_fd_sc_hd__fill_1
X_7303_ _2757_ _2763_ VGND VGND VPWR VPWR _2764_ sky130_fd_sc_hd__xnor2_1
X_4515_ _4277_ _4278_ net500 net302 VGND VGND VPWR VPWR _4281_ sky130_fd_sc_hd__a2bb2o_1
XPHY_EDGE_ROW_103_Right_103 VGND VGND VPWR VPWR sky130_fd_sc_hd__decap_3
X_8283_ _3581_ net176 _3628_ VGND VGND VPWR VPWR _3670_ sky130_fd_sc_hd__mux2_1
X_5495_ net249 _0716_ VGND VGND VPWR VPWR _1208_ sky130_fd_sc_hd__nand2_1
X_7234_ net427 _2696_ VGND VGND VPWR VPWR _0308_ sky130_fd_sc_hd__nor2_1
X_4446_ pe_array\[3\].u_pe.accum_reg\[1\] VGND VGND VPWR VPWR _4227_ sky130_fd_sc_hd__inv_2
X_7165_ _2621_ _2628_ VGND VGND VPWR VPWR _2629_ sky130_fd_sc_hd__and2b_1
X_6116_ _1639_ _1646_ VGND VGND VPWR VPWR _1648_ sky130_fd_sc_hd__xnor2_1
XFILLER_58_303 VGND VGND VPWR VPWR sky130_fd_sc_hd__fill_1
XFILLER_98_494 VPWR VGND VPWR VGND sky130_ef_sc_hd__decap_12
XFILLER_86_667 VPWR VGND VPWR VGND sky130_ef_sc_hd__decap_12
X_7096_ _2494_ _2496_ _2560_ _2559_ VGND VGND VPWR VPWR _2562_ sky130_fd_sc_hd__a211o_4
XFILLER_37_15 VGND VGND VPWR VPWR sky130_fd_sc_hd__decap_6
XFILLER_100_477 VGND VGND VPWR VPWR sky130_fd_sc_hd__fill_2
XFILLER_86_689 VGND VGND VPWR VPWR sky130_fd_sc_hd__decap_8
X_6047_ _1577_ _1578_ _1579_ VGND VGND VPWR VPWR _1581_ sky130_fd_sc_hd__a21o_1
XFILLER_73_317 VPWR VGND VPWR VGND sky130_ef_sc_hd__decap_12
XFILLER_37_48 VGND VGND VPWR VPWR sky130_fd_sc_hd__decap_3
XFILLER_39_594 VGND VGND VPWR VPWR sky130_fd_sc_hd__fill_1
X_7998_ _3391_ _3364_ VGND VGND VPWR VPWR _3392_ sky130_fd_sc_hd__nand2b_1
XFILLER_41_203 VGND VGND VPWR VPWR sky130_fd_sc_hd__fill_1
XFILLER_53_69 VPWR VGND VPWR VGND sky130_ef_sc_hd__decap_12
XFILLER_41_225 VGND VGND VPWR VPWR sky130_fd_sc_hd__fill_2
XFILLER_41_236 VGND VGND VPWR VPWR sky130_fd_sc_hd__fill_1
X_6949_ _2414_ _2415_ net272 VGND VGND VPWR VPWR _2418_ sky130_fd_sc_hd__o21ai_1
X_8619_ net162 _3995_ VGND VGND VPWR VPWR _3996_ sky130_fd_sc_hd__nor2_1
XFILLER_10_678 VGND VGND VPWR VPWR sky130_fd_sc_hd__fill_1
XFILLER_6_605 VPWR VGND VPWR VGND sky130_ef_sc_hd__decap_12
Xrebuffer231 net747 VGND VGND VPWR VPWR net746 sky130_fd_sc_hd__buf_2
XFILLER_108_544 VGND VGND VPWR VPWR sky130_fd_sc_hd__fill_1
Xrebuffer253 _2615_ VGND VGND VPWR VPWR net768 sky130_fd_sc_hd__buf_6
XTAP_TAPCELL_ROW_114_1617 VGND VPWR sky130_fd_sc_hd__tapvpwrvgnd_1
XFILLER_91_125 VGND VGND VPWR VPWR sky130_fd_sc_hd__decap_4
XFILLER_91_147 VPWR VGND VPWR VGND sky130_ef_sc_hd__decap_12
XTAP_TAPCELL_ROW_15_434 VGND VPWR sky130_fd_sc_hd__tapvpwrvgnd_1
XFILLER_17_299 VGND VGND VPWR VPWR sky130_fd_sc_hd__decap_6
XFILLER_60_589 VGND VGND VPWR VPWR sky130_fd_sc_hd__decap_3
XFILLER_13_461 VPWR VGND VPWR VGND sky130_ef_sc_hd__decap_12
XFILLER_32_269 VGND VGND VPWR VPWR sky130_fd_sc_hd__fill_2
XTAP_TAPCELL_ROW_43_765 VGND VPWR sky130_fd_sc_hd__tapvpwrvgnd_1
XFILLER_114_503 VGND VGND VPWR VPWR sky130_fd_sc_hd__fill_2
XFILLER_99_203 VGND VGND VPWR VPWR sky130_fd_sc_hd__fill_1
XFILLER_5_671 VGND VGND VPWR VPWR sky130_fd_sc_hd__fill_1
X_5280_ pe_array\[3\].u_pe.accum_reg\[25\] _0520_ VGND VGND VPWR VPWR _1014_ sky130_fd_sc_hd__nor2_1
XFILLER_4_41 VPWR VGND VPWR VGND sky130_ef_sc_hd__decap_12
XFILLER_68_601 VPWR VGND VPWR VGND sky130_ef_sc_hd__decap_12
XFILLER_4_85 VGND VGND VPWR VPWR sky130_fd_sc_hd__decap_8
XFILLER_68_645 VPWR VGND VPWR VGND sky130_ef_sc_hd__decap_12
X_8970_ clknet_leaf_54_clk _0082_ VGND VGND VPWR VPWR pe_array\[1\].u_pe.weight_in\[5\]
+ sky130_fd_sc_hd__dfxtp_1
XFILLER_95_486 VPWR VGND VPWR VGND sky130_ef_sc_hd__decap_12
X_7921_ _3260_ _3286_ _3316_ _3285_ VGND VGND VPWR VPWR _3317_ sky130_fd_sc_hd__o211a_1
XFILLER_67_177 VGND VGND VPWR VPWR sky130_fd_sc_hd__decap_3
XFILLER_55_317 VGND VGND VPWR VPWR sky130_fd_sc_hd__fill_2
XFILLER_48_380 VGND VGND VPWR VPWR sky130_fd_sc_hd__fill_1
XFILLER_70_309 VPWR VGND VPWR VGND sky130_ef_sc_hd__decap_12
X_7852_ _3233_ _3248_ _3249_ VGND VGND VPWR VPWR _3250_ sky130_fd_sc_hd__and3_1
XFILLER_90_191 VGND VGND VPWR VPWR sky130_fd_sc_hd__decap_4
X_6803_ _2247_ _2275_ VGND VGND VPWR VPWR _2276_ sky130_fd_sc_hd__xnor2_1
XFILLER_23_225 VPWR VGND VPWR VGND sky130_ef_sc_hd__decap_12
X_7783_ _3068_ net225 VGND VGND VPWR VPWR _3201_ sky130_fd_sc_hd__nand2_1
X_4995_ _0736_ _0737_ _0719_ VGND VGND VPWR VPWR _0739_ sky130_fd_sc_hd__a21o_1
X_6734_ pe_array\[1\].u_pe.accum_reg\[0\] net511 net342 VGND VGND VPWR VPWR _2211_
+ sky130_fd_sc_hd__and3_1
XFILLER_51_589 VGND VGND VPWR VPWR sky130_fd_sc_hd__decap_8
X_6665_ _2178_ _2179_ VGND VGND VPWR VPWR _2180_ sky130_fd_sc_hd__and2_1
X_8404_ _3786_ _3787_ VGND VGND VPWR VPWR _3788_ sky130_fd_sc_hd__nand2_1
X_5616_ net950 net385 VGND VGND VPWR VPWR _0157_ sky130_fd_sc_hd__and2_1
X_6596_ net177 _2111_ VGND VGND VPWR VPWR _2113_ sky130_fd_sc_hd__xnor2_1
XFILLER_117_352 VGND VGND VPWR VPWR sky130_fd_sc_hd__decap_8
X_5547_ net898 net392 VGND VGND VPWR VPWR _0088_ sky130_fd_sc_hd__and2_1
X_8335_ _3702_ _3719_ _3720_ VGND VGND VPWR VPWR _3721_ sky130_fd_sc_hd__nor3_1
XFILLER_117_385 VGND VGND VPWR VPWR sky130_fd_sc_hd__decap_3
X_8266_ _3651_ _3652_ _3609_ _3611_ VGND VGND VPWR VPWR _3654_ sky130_fd_sc_hd__o211ai_2
XFILLER_2_107 VGND VGND VPWR VPWR sky130_fd_sc_hd__fill_1
XFILLER_2_129 VGND VGND VPWR VPWR sky130_fd_sc_hd__fill_1
X_5478_ net927 net251 _1199_ net367 VGND VGND VPWR VPWR _0049_ sky130_fd_sc_hd__o211a_1
XFILLER_105_558 VGND VGND VPWR VPWR sky130_fd_sc_hd__fill_2
X_7217_ _2666_ _2678_ _2679_ VGND VGND VPWR VPWR _2680_ sky130_fd_sc_hd__nand3_1
Xfanout411 net413 VGND VGND VPWR VPWR net411 sky130_fd_sc_hd__buf_2
Xfanout422 net423 VGND VGND VPWR VPWR net422 sky130_fd_sc_hd__buf_4
X_8197_ _3582_ _3585_ VGND VGND VPWR VPWR _3586_ sky130_fd_sc_hd__xor2_1
Xfanout400 net405 VGND VGND VPWR VPWR net400 sky130_fd_sc_hd__buf_1
Xfanout444 net563 VGND VGND VPWR VPWR net444 sky130_fd_sc_hd__buf_8
Xfanout455 net457 VGND VGND VPWR VPWR net455 sky130_fd_sc_hd__buf_4
Xfanout466 net467 VGND VGND VPWR VPWR net466 sky130_fd_sc_hd__buf_2
Xfanout433 net436 VGND VGND VPWR VPWR net433 sky130_fd_sc_hd__clkbuf_2
X_7148_ _2524_ _2566_ VGND VGND VPWR VPWR _2613_ sky130_fd_sc_hd__nand2_1
Xfanout499 net3 VGND VGND VPWR VPWR net499 sky130_fd_sc_hd__buf_6
XFILLER_86_453 VPWR VGND VPWR VGND sky130_ef_sc_hd__decap_12
Xfanout488 net489 VGND VGND VPWR VPWR net488 sky130_fd_sc_hd__buf_1
Xfanout477 net478 VGND VGND VPWR VPWR net477 sky130_fd_sc_hd__buf_2
X_7079_ net525 pe_array\[1\].u_pe.accum_reg\[11\] net339 VGND VGND VPWR VPWR _2545_
+ sky130_fd_sc_hd__and3_1
XPHY_EDGE_ROW_100_Left_218 VGND VGND VPWR VPWR sky130_fd_sc_hd__decap_3
XFILLER_104_75 VGND VGND VPWR VPWR sky130_fd_sc_hd__decap_8
XFILLER_73_158 VGND VGND VPWR VPWR sky130_fd_sc_hd__decap_8
XFILLER_54_372 VGND VGND VPWR VPWR sky130_fd_sc_hd__decap_8
XFILLER_27_575 VGND VGND VPWR VPWR sky130_fd_sc_hd__decap_6
XTAP_TAPCELL_ROW_64_1026 VGND VPWR sky130_fd_sc_hd__tapvpwrvgnd_1
XFILLER_42_589 VPWR VGND VPWR VGND sky130_ef_sc_hd__decap_12
XTAP_TAPCELL_ROW_40_735 VGND VPWR sky130_fd_sc_hd__tapvpwrvgnd_1
XFILLER_13_50 VGND VGND VPWR VPWR sky130_fd_sc_hd__decap_6
XFILLER_10_475 VGND VGND VPWR VPWR sky130_fd_sc_hd__fill_1
XFILLER_6_457 VPWR VGND VPWR VGND sky130_ef_sc_hd__decap_12
XTAP_TAPCELL_ROW_20_492 VGND VPWR sky130_fd_sc_hd__tapvpwrvgnd_1
XTAP_TAPCELL_ROW_75_1155 VGND VPWR sky130_fd_sc_hd__tapvpwrvgnd_1
XFILLER_111_517 VGND VGND VPWR VPWR sky130_fd_sc_hd__decap_6
XFILLER_77_464 VGND VGND VPWR VPWR sky130_fd_sc_hd__fill_2
XFILLER_77_442 VGND VGND VPWR VPWR sky130_fd_sc_hd__fill_2
XFILLER_38_80 VGND VGND VPWR VPWR sky130_fd_sc_hd__decap_4
XTAP_TAPCELL_ROW_48_824 VGND VPWR sky130_fd_sc_hd__tapvpwrvgnd_1
XTAP_TAPCELL_ROW_48_835 VGND VPWR sky130_fd_sc_hd__tapvpwrvgnd_1
XFILLER_18_531 VGND VGND VPWR VPWR sky130_fd_sc_hd__fill_1
XFILLER_18_586 VGND VGND VPWR VPWR sky130_fd_sc_hd__fill_2
XTAP_TAPCELL_ROW_86_1284 VGND VPWR sky130_fd_sc_hd__tapvpwrvgnd_1
XTAP_TAPCELL_ROW_28_592 VGND VPWR sky130_fd_sc_hd__tapvpwrvgnd_1
X_4780_ _0519_ _0527_ _0528_ VGND VGND VPWR VPWR _0529_ sky130_fd_sc_hd__nand3_1
X_6450_ _1971_ _1970_ VGND VGND VPWR VPWR _1972_ sky130_fd_sc_hd__and2b_1
Xclkload10 clknet_leaf_59_clk VGND VGND VPWR VPWR clkload10/Y sky130_fd_sc_hd__clkinvlp_4
X_6381_ _1903_ _1904_ VGND VGND VPWR VPWR _1905_ sky130_fd_sc_hd__nand2_1
Xclkload43 clknet_leaf_13_clk VGND VGND VPWR VPWR clkload43/Y sky130_fd_sc_hd__inv_6
Xclkload32 clknet_leaf_1_clk VGND VGND VPWR VPWR clkload32/Y sky130_fd_sc_hd__inv_12
X_5401_ net630 _1129_ VGND VGND VPWR VPWR _1131_ sky130_fd_sc_hd__xnor2_1
Xclkload21 clknet_leaf_68_clk VGND VGND VPWR VPWR clkload21/Y sky130_fd_sc_hd__clkinv_2
Xclkload54 clknet_leaf_23_clk VGND VGND VPWR VPWR clkload54/Y sky130_fd_sc_hd__inv_16
X_8120_ net679 net317 pe_array\[2\].u_pe.accum_reg\[10\] VGND VGND VPWR VPWR _3511_
+ sky130_fd_sc_hd__a21oi_1
X_5332_ _1064_ net416 VGND VGND VPWR VPWR _0038_ sky130_fd_sc_hd__nor2_1
XFILLER_114_333 VPWR VGND VPWR VGND sky130_ef_sc_hd__decap_12
X_8051_ _3442_ _3443_ VGND VGND VPWR VPWR _3444_ sky130_fd_sc_hd__nor2_1
X_5263_ _0995_ _0996_ VGND VGND VPWR VPWR _0998_ sky130_fd_sc_hd__xor2_1
X_5194_ _0928_ _0929_ _0902_ _0903_ VGND VGND VPWR VPWR _0931_ sky130_fd_sc_hd__a211o_1
X_7002_ _2467_ _2468_ _2469_ VGND VGND VPWR VPWR _2470_ sky130_fd_sc_hd__nand3_2
XFILLER_56_604 VGND VGND VPWR VPWR sky130_fd_sc_hd__fill_1
XFILLER_55_125 VGND VGND VPWR VPWR sky130_fd_sc_hd__decap_6
X_8953_ clknet_leaf_64_clk _0065_ VGND VGND VPWR VPWR pe_accum\[3\]\[21\] sky130_fd_sc_hd__dfxtp_1
X_8884_ _4177_ net214 VGND VGND VPWR VPWR _4223_ sky130_fd_sc_hd__nand2_1
X_7904_ net480 net322 net324 net474 VGND VGND VPWR VPWR _3300_ sky130_fd_sc_hd__a22o_1
XFILLER_71_629 VPWR VGND VPWR VGND sky130_ef_sc_hd__decap_12
X_7835_ net513 net320 pe_array\[2\].u_pe.accum_reg\[2\] VGND VGND VPWR VPWR _3234_
+ sky130_fd_sc_hd__a21oi_1
XFILLER_24_556 VGND VGND VPWR VPWR sky130_fd_sc_hd__fill_1
X_7766_ net949 net222 _3192_ net375 VGND VGND VPWR VPWR _0344_ sky130_fd_sc_hd__o211a_1
X_4978_ net283 _0720_ _0721_ VGND VGND VPWR VPWR _0722_ sky130_fd_sc_hd__nor3_1
X_6717_ net920 net234 net242 _2159_ VGND VGND VPWR VPWR _0287_ sky130_fd_sc_hd__o2bb2ai_1
Xclkload4 clknet_3_4__leaf_clk VGND VGND VPWR VPWR clkload4/Y sky130_fd_sc_hd__inv_6
X_7697_ _3112_ _3114_ _3142_ VGND VGND VPWR VPWR _3144_ sky130_fd_sc_hd__a21oi_1
XFILLER_50_15 VPWR VGND VPWR VGND sky130_ef_sc_hd__decap_12
X_6648_ pe_array\[0\].u_pe.accum_reg\[30\] net274 VGND VGND VPWR VPWR _2163_ sky130_fd_sc_hd__xor2_1
X_6579_ _2091_ _2094_ _2095_ _2086_ VGND VGND VPWR VPWR _2096_ sky130_fd_sc_hd__o211ai_1
X_8318_ pe_array\[2\].u_pe.accum_reg\[15\] net439 net313 VGND VGND VPWR VPWR _3704_
+ sky130_fd_sc_hd__and3_4
XFILLER_3_405 VPWR VGND VPWR VGND sky130_ef_sc_hd__decap_12
XFILLER_117_182 VGND VGND VPWR VPWR sky130_fd_sc_hd__decap_8
X_9298_ clknet_leaf_2_clk _0410_ VGND VGND VPWR VPWR pe_accum\[2\]\[8\] sky130_fd_sc_hd__dfxtp_1
XFILLER_3_449 VPWR VGND VPWR VGND sky130_ef_sc_hd__decap_12
X_8249_ net259 _3634_ _3635_ VGND VGND VPWR VPWR _3637_ sky130_fd_sc_hd__or3_4
XFILLER_59_57 VPWR VGND VPWR VGND sky130_ef_sc_hd__decap_12
Xfanout241 _1232_ VGND VGND VPWR VPWR net241 sky130_fd_sc_hd__clkbuf_2
Xfanout230 _2203_ VGND VGND VPWR VPWR net230 sky130_fd_sc_hd__dlymetal6s2s_1
Xfanout274 net275 VGND VGND VPWR VPWR net274 sky130_fd_sc_hd__buf_8
Xfanout263 net265 VGND VGND VPWR VPWR net263 sky130_fd_sc_hd__buf_2
XFILLER_59_464 VGND VGND VPWR VPWR sky130_fd_sc_hd__decap_8
Xfanout252 net253 VGND VGND VPWR VPWR net252 sky130_fd_sc_hd__clkbuf_2
XFILLER_101_561 VGND VGND VPWR VPWR sky130_fd_sc_hd__fill_2
XTAP_TAPCELL_ROW_70_1096 VGND VPWR sky130_fd_sc_hd__tapvpwrvgnd_1
Xfanout285 _0482_ VGND VGND VPWR VPWR net285 sky130_fd_sc_hd__buf_2
Xfanout296 net297 VGND VGND VPWR VPWR net296 sky130_fd_sc_hd__buf_2
XFILLER_47_615 VGND VGND VPWR VPWR sky130_fd_sc_hd__fill_1
XFILLER_47_626 VGND VGND VPWR VPWR sky130_fd_sc_hd__fill_2
XFILLER_34_309 VPWR VGND VPWR VGND sky130_ef_sc_hd__decap_12
XTAP_TAPCELL_ROW_25_551 VGND VPWR sky130_fd_sc_hd__tapvpwrvgnd_1
XFILLER_91_88 VGND VGND VPWR VPWR sky130_fd_sc_hd__fill_1
XTAP_TAPCELL_ROW_53_893 VGND VPWR sky130_fd_sc_hd__tapvpwrvgnd_1
XFILLER_30_515 VGND VGND VPWR VPWR sky130_fd_sc_hd__fill_1
XFILLER_42_375 VGND VGND VPWR VPWR sky130_fd_sc_hd__decap_6
XFILLER_109_683 VGND VGND VPWR VPWR sky130_fd_sc_hd__fill_1
XFILLER_69_217 VGND VGND VPWR VPWR sky130_fd_sc_hd__decap_6
XFILLER_84_209 VPWR VGND VPWR VGND sky130_ef_sc_hd__decap_12
XFILLER_77_250 VGND VGND VPWR VPWR sky130_fd_sc_hd__decap_8
XTAP_TAPCELL_ROW_88_1313 VGND VPWR sky130_fd_sc_hd__tapvpwrvgnd_1
XFILLER_37_103 VGND VGND VPWR VPWR sky130_fd_sc_hd__decap_8
XFILLER_38_637 VGND VGND VPWR VPWR sky130_fd_sc_hd__decap_6
XFILLER_65_445 VGND VGND VPWR VPWR sky130_fd_sc_hd__decap_3
X_5950_ _1482_ _1483_ net274 VGND VGND VPWR VPWR _1486_ sky130_fd_sc_hd__o21ai_1
XFILLER_18_361 VGND VGND VPWR VPWR sky130_fd_sc_hd__decap_3
XFILLER_37_169 VGND VGND VPWR VPWR sky130_fd_sc_hd__decap_6
X_4901_ _0602_ _0645_ _0646_ VGND VGND VPWR VPWR _0647_ sky130_fd_sc_hd__and3_1
X_5881_ net409 pe_array\[0\].u_pe.accum_reg\[7\] net238 _1418_ VGND VGND VPWR VPWR
+ _1419_ sky130_fd_sc_hd__o2bb2a_1
XFILLER_61_673 VPWR VGND VPWR VGND sky130_ef_sc_hd__decap_12
XFILLER_33_364 VGND VGND VPWR VPWR sky130_fd_sc_hd__decap_3
X_7620_ net424 _3069_ VGND VGND VPWR VPWR _0321_ sky130_fd_sc_hd__nor2_1
XFILLER_21_526 VGND VGND VPWR VPWR sky130_fd_sc_hd__fill_1
X_4832_ _0577_ _0578_ _0579_ VGND VGND VPWR VPWR _0580_ sky130_fd_sc_hd__nand3_2
X_4763_ net483 _4230_ VGND VGND VPWR VPWR _0512_ sky130_fd_sc_hd__nor2_1
X_7551_ net167 _3002_ VGND VGND VPWR VPWR _3003_ sky130_fd_sc_hd__nor2_1
X_6502_ _2019_ _2020_ VGND VGND VPWR VPWR _2022_ sky130_fd_sc_hd__xnor2_1
XTAP_TAPCELL_ROW_99_1442 VGND VPWR sky130_fd_sc_hd__tapvpwrvgnd_1
X_7482_ _2932_ _2933_ net269 VGND VGND VPWR VPWR _2936_ sky130_fd_sc_hd__o21ai_1
X_4694_ net302 net461 _0442_ _0443_ VGND VGND VPWR VPWR _0445_ sky130_fd_sc_hd__a22o_1
X_6433_ net279 _1952_ _1953_ VGND VGND VPWR VPWR _1955_ sky130_fd_sc_hd__or3_1
X_9221_ clknet_leaf_40_clk _0333_ VGND VGND VPWR VPWR pe_accum\[1\]\[7\] sky130_fd_sc_hd__dfxtp_1
XFILLER_20_29 VGND VGND VPWR VPWR sky130_fd_sc_hd__fill_2
XFILLER_115_653 VPWR VGND VPWR VGND sky130_ef_sc_hd__decap_12
X_6364_ _1888_ _1887_ VGND VGND VPWR VPWR _1889_ sky130_fd_sc_hd__and2b_1
X_9152_ clknet_leaf_20_clk _0264_ VGND VGND VPWR VPWR pe_accum\[0\]\[6\] sky130_fd_sc_hd__dfxtp_1
XFILLER_114_141 VGND VGND VPWR VPWR sky130_fd_sc_hd__decap_4
X_6295_ _1819_ _1820_ _1821_ VGND VGND VPWR VPWR _1822_ sky130_fd_sc_hd__and3_1
X_8103_ net470 net560 _3417_ VGND VGND VPWR VPWR _3494_ sky130_fd_sc_hd__a21o_1
X_9083_ clknet_leaf_64_clk _0195_ VGND VGND VPWR VPWR net32 sky130_fd_sc_hd__dfxtp_1
X_5315_ net208 _1019_ _1017_ VGND VGND VPWR VPWR _1048_ sky130_fd_sc_hd__a21oi_1
XFILLER_115_697 VGND VGND VPWR VPWR sky130_fd_sc_hd__decap_3
X_8034_ _4229_ _3424_ _3425_ net321 VGND VGND VPWR VPWR _3427_ sky130_fd_sc_hd__or4b_1
X_5246_ _0947_ _0949_ _0976_ _0980_ _0975_ VGND VGND VPWR VPWR _0981_ sky130_fd_sc_hd__o311a_1
XPHY_EDGE_ROW_89_Right_89 VGND VGND VPWR VPWR sky130_fd_sc_hd__decap_3
XFILLER_29_27 VGND VGND VPWR VPWR sky130_fd_sc_hd__fill_2
XFILLER_96_581 VGND VGND VPWR VPWR sky130_fd_sc_hd__fill_1
X_5177_ _0913_ _0914_ VGND VGND VPWR VPWR _0915_ sky130_fd_sc_hd__and2_1
XFILLER_83_220 VGND VGND VPWR VPWR sky130_fd_sc_hd__decap_4
XFILLER_28_136 VGND VGND VPWR VPWR sky130_fd_sc_hd__fill_1
X_8936_ clknet_leaf_58_clk _0048_ VGND VGND VPWR VPWR pe_accum\[3\]\[4\] sky130_fd_sc_hd__dfxtp_1
XFILLER_16_309 VPWR VGND VPWR VGND sky130_ef_sc_hd__decap_12
XFILLER_43_106 VGND VGND VPWR VPWR sky130_fd_sc_hd__decap_6
XFILLER_45_15 VPWR VGND VPWR VGND sky130_ef_sc_hd__decap_12
X_8867_ net931 net212 _4214_ net384 VGND VGND VPWR VPWR _0423_ sky130_fd_sc_hd__o211a_1
X_7818_ _3217_ _3218_ VGND VGND VPWR VPWR _3219_ sky130_fd_sc_hd__or2_1
XPHY_EDGE_ROW_98_Right_98 VGND VGND VPWR VPWR sky130_fd_sc_hd__decap_3
X_8798_ _4137_ _4140_ _4167_ VGND VGND VPWR VPWR _4169_ sky130_fd_sc_hd__nor3_1
XTAP_TAPCELL_ROW_22_521 VGND VPWR sky130_fd_sc_hd__tapvpwrvgnd_1
X_7749_ net224 _2529_ VGND VGND VPWR VPWR _3184_ sky130_fd_sc_hd__nand2_1
XTAP_TAPCELL_ROW_50_852 VGND VPWR sky130_fd_sc_hd__tapvpwrvgnd_1
XFILLER_61_69 VGND VGND VPWR VPWR sky130_fd_sc_hd__decap_8
XFILLER_117_3 VPWR VGND VPWR VGND sky130_ef_sc_hd__decap_12
XTAP_TAPCELL_ROW_72_1114 VGND VPWR sky130_fd_sc_hd__tapvpwrvgnd_1
XFILLER_105_185 VGND VGND VPWR VPWR sky130_fd_sc_hd__fill_1
XFILLER_105_163 VGND VGND VPWR VPWR sky130_fd_sc_hd__fill_2
XFILLER_3_279 VGND VGND VPWR VPWR sky130_fd_sc_hd__fill_1
XFILLER_87_570 VGND VGND VPWR VPWR sky130_fd_sc_hd__fill_1
XFILLER_59_261 VGND VGND VPWR VPWR sky130_fd_sc_hd__fill_1
XFILLER_47_401 VGND VGND VPWR VPWR sky130_fd_sc_hd__decap_3
XTAP_TAPCELL_ROW_58_952 VGND VPWR sky130_fd_sc_hd__tapvpwrvgnd_1
XFILLER_74_253 VGND VGND VPWR VPWR sky130_fd_sc_hd__decap_8
XFILLER_62_404 VGND VGND VPWR VPWR sky130_fd_sc_hd__decap_8
XFILLER_19_158 VGND VGND VPWR VPWR sky130_fd_sc_hd__decap_8
XTAP_TAPCELL_ROW_83_1254 VGND VPWR sky130_fd_sc_hd__tapvpwrvgnd_1
XFILLER_27_191 VGND VGND VPWR VPWR sky130_fd_sc_hd__fill_1
XFILLER_43_640 VGND VGND VPWR VPWR sky130_fd_sc_hd__fill_1
XFILLER_42_161 VGND VGND VPWR VPWR sky130_fd_sc_hd__fill_1
XFILLER_11_581 VPWR VGND VPWR VGND sky130_ef_sc_hd__decap_12
XFILLER_116_417 VGND VGND VPWR VPWR sky130_fd_sc_hd__decap_3
Xhold508 pe_accum\[1\]\[4\] VGND VGND VPWR VPWR net1023 sky130_fd_sc_hd__dlygate4sd3_1
Xhold519 pe_array\[0\].u_pe.tap_count\[0\] VGND VGND VPWR VPWR net1034 sky130_fd_sc_hd__dlygate4sd3_1
XFILLER_112_601 VPWR VGND VPWR VGND sky130_ef_sc_hd__decap_12
XTAP_TAPCELL_ROW_94_1383 VGND VPWR sky130_fd_sc_hd__tapvpwrvgnd_1
XFILLER_97_334 VGND VGND VPWR VPWR sky130_fd_sc_hd__fill_2
X_6080_ net278 _1610_ _1611_ VGND VGND VPWR VPWR _1613_ sky130_fd_sc_hd__or3_4
X_5100_ _0811_ _0783_ _0840_ VGND VGND VPWR VPWR _0841_ sky130_fd_sc_hd__a21oi_4
XFILLER_32_3 VGND VGND VPWR VPWR sky130_fd_sc_hd__decap_6
XFILLER_112_645 VPWR VGND VPWR VGND sky130_ef_sc_hd__decap_12
XFILLER_111_122 VGND VGND VPWR VPWR sky130_fd_sc_hd__decap_6
X_5031_ _0741_ _0772_ _0773_ VGND VGND VPWR VPWR _0774_ sky130_fd_sc_hd__and3_1
XFILLER_97_378 VGND VGND VPWR VPWR sky130_fd_sc_hd__decap_8
XFILLER_65_220 VGND VGND VPWR VPWR sky130_fd_sc_hd__decap_4
XFILLER_38_434 VGND VGND VPWR VPWR sky130_fd_sc_hd__decap_6
XFILLER_38_456 VGND VGND VPWR VPWR sky130_fd_sc_hd__decap_4
XFILLER_93_573 VGND VGND VPWR VPWR sky130_fd_sc_hd__decap_8
XFILLER_38_489 VGND VGND VPWR VPWR sky130_fd_sc_hd__decap_3
X_8721_ _4055_ _4084_ _4057_ VGND VGND VPWR VPWR _4094_ sky130_fd_sc_hd__o21ai_1
XTAP_TAPCELL_ROW_0_238 VGND VPWR sky130_fd_sc_hd__tapvpwrvgnd_1
XTAP_TAPCELL_ROW_0_249 VGND VPWR sky130_fd_sc_hd__tapvpwrvgnd_1
X_6982_ _2448_ _2449_ VGND VGND VPWR VPWR _2450_ sky130_fd_sc_hd__xor2_1
X_5933_ net491 net481 net347 net344 VGND VGND VPWR VPWR _1469_ sky130_fd_sc_hd__and4_1
X_8652_ net155 _4027_ VGND VGND VPWR VPWR _4028_ sky130_fd_sc_hd__xnor2_1
XFILLER_80_278 VGND VGND VPWR VPWR sky130_fd_sc_hd__fill_1
X_5864_ _1356_ _1363_ _1362_ VGND VGND VPWR VPWR _1402_ sky130_fd_sc_hd__a21bo_1
X_8583_ _3958_ _3959_ net162 VGND VGND VPWR VPWR _3961_ sky130_fd_sc_hd__o21ai_1
X_7603_ net194 _3024_ _3023_ VGND VGND VPWR VPWR _3053_ sky130_fd_sc_hd__o21ai_1
X_4815_ _0556_ _0561_ VGND VGND VPWR VPWR _0563_ sky130_fd_sc_hd__xor2_1
XTAP_TAPCELL_ROW_103_1490 VGND VPWR sky130_fd_sc_hd__tapvpwrvgnd_1
X_5795_ _1332_ _1333_ _1315_ VGND VGND VPWR VPWR _1335_ sky130_fd_sc_hd__a21oi_1
X_7534_ _2952_ _2985_ VGND VGND VPWR VPWR _2987_ sky130_fd_sc_hd__xnor2_1
X_4746_ _0452_ _0454_ _0494_ _0495_ VGND VGND VPWR VPWR _0496_ sky130_fd_sc_hd__o211a_1
XFILLER_107_406 VPWR VGND VPWR VGND sky130_ef_sc_hd__decap_12
X_4677_ net483 net292 net290 net493 VGND VGND VPWR VPWR _4438_ sky130_fd_sc_hd__a22oi_1
X_7465_ _2917_ _2918_ VGND VGND VPWR VPWR _2920_ sky130_fd_sc_hd__xnor2_2
X_6416_ net158 _1938_ VGND VGND VPWR VPWR _1939_ sky130_fd_sc_hd__xnor2_1
X_7396_ net267 _2851_ _2852_ VGND VGND VPWR VPWR _2853_ sky130_fd_sc_hd__nor3_1
X_9204_ clknet_leaf_45_clk _0316_ VGND VGND VPWR VPWR pe_array\[1\].u_pe.accum_reg\[22\]
+ sky130_fd_sc_hd__dfxtp_1
X_9135_ clknet_leaf_26_clk _0247_ VGND VGND VPWR VPWR pe_array\[0\].u_pe.accum_reg\[21\]
+ sky130_fd_sc_hd__dfxtp_1
X_6347_ pe_array\[0\].u_pe.accum_reg\[20\] net457 net360 VGND VGND VPWR VPWR _1872_
+ sky130_fd_sc_hd__and3_1
Xoutput28 net28 VGND VGND VPWR VPWR result_data[105] sky130_fd_sc_hd__buf_2
Xoutput39 net39 VGND VGND VPWR VPWR result_data[115] sky130_fd_sc_hd__buf_2
XTAP_TAPCELL_ROW_8_349 VGND VPWR sky130_fd_sc_hd__tapvpwrvgnd_1
X_9066_ clknet_leaf_10_clk _0178_ VGND VGND VPWR VPWR net141 sky130_fd_sc_hd__dfxtp_1
X_6278_ _1802_ _1803_ _1773_ VGND VGND VPWR VPWR _1806_ sky130_fd_sc_hd__o21bai_1
XFILLER_0_238 VGND VGND VPWR VPWR sky130_fd_sc_hd__decap_3
XFILLER_69_570 VGND VGND VPWR VPWR sky130_fd_sc_hd__decap_3
X_8017_ _3408_ _3409_ VGND VGND VPWR VPWR _3410_ sky130_fd_sc_hd__nor2_1
X_5229_ _0962_ _0963_ VGND VGND VPWR VPWR _0965_ sky130_fd_sc_hd__xnor2_1
XFILLER_69_592 VPWR VGND VPWR VGND sky130_ef_sc_hd__decap_12
XFILLER_56_253 VGND VGND VPWR VPWR sky130_fd_sc_hd__decap_8
XTAP_TAPCELL_ROW_55_911 VGND VPWR sky130_fd_sc_hd__tapvpwrvgnd_1
XFILLER_44_404 VPWR VGND VPWR VGND sky130_ef_sc_hd__decap_12
XFILLER_16_139 VGND VGND VPWR VPWR sky130_fd_sc_hd__fill_1
XFILLER_112_53 VPWR VGND VPWR VGND sky130_ef_sc_hd__decap_12
X_8919_ clknet_leaf_65_clk _0031_ VGND VGND VPWR VPWR pe_array\[3\].u_pe.accum_reg\[19\]
+ sky130_fd_sc_hd__dfxtp_1
XFILLER_112_97 VPWR VGND VPWR VGND sky130_ef_sc_hd__decap_12
XFILLER_24_161 VPWR VGND VPWR VGND sky130_ef_sc_hd__decap_12
XFILLER_25_673 VGND VGND VPWR VPWR sky130_fd_sc_hd__fill_1
XPHY_EDGE_ROW_117_Right_117 VGND VGND VPWR VPWR sky130_fd_sc_hd__decap_3
XTAP_TAPCELL_ROW_117_1659 VGND VPWR sky130_fd_sc_hd__tapvpwrvgnd_1
XFILLER_21_83 VGND VGND VPWR VPWR sky130_fd_sc_hd__fill_1
XFILLER_35_404 VGND VGND VPWR VPWR sky130_fd_sc_hd__decap_6
XFILLER_47_242 VGND VGND VPWR VPWR sky130_fd_sc_hd__decap_8
XFILLER_90_521 VGND VGND VPWR VPWR sky130_fd_sc_hd__decap_8
XFILLER_62_201 VGND VGND VPWR VPWR sky130_fd_sc_hd__fill_1
XTAP_TAPCELL_ROW_33_649 VGND VPWR sky130_fd_sc_hd__tapvpwrvgnd_1
X_4600_ net307 net304 net469 net460 VGND VGND VPWR VPWR _4363_ sky130_fd_sc_hd__and4_1
XTAP_TAPCELL_ROW_96_1401 VGND VPWR sky130_fd_sc_hd__tapvpwrvgnd_1
X_5580_ net1012 net390 VGND VGND VPWR VPWR _0121_ sky130_fd_sc_hd__and2_1
X_4531_ net399 pe_array\[3\].u_pe.accum_reg\[3\] net257 _4296_ VGND VGND VPWR VPWR
+ _4297_ sky130_fd_sc_hd__o2bb2a_1
X_4462_ net14 _4240_ _4241_ net355 VGND VGND VPWR VPWR _0001_ sky130_fd_sc_hd__a22o_1
XFILLER_7_393 VPWR VGND VPWR VGND sky130_ef_sc_hd__decap_12
X_7250_ net195 _2674_ _2672_ VGND VGND VPWR VPWR _2712_ sky130_fd_sc_hd__a21o_1
X_6201_ _1727_ _1728_ _1729_ VGND VGND VPWR VPWR _1731_ sky130_fd_sc_hd__a21oi_1
X_7181_ _2642_ _2643_ _2630_ VGND VGND VPWR VPWR _2645_ sky130_fd_sc_hd__a21oi_1
XFILLER_112_442 VGND VGND VPWR VPWR sky130_fd_sc_hd__decap_8
X_6132_ _1621_ _1624_ _1662_ _1663_ VGND VGND VPWR VPWR _1664_ sky130_fd_sc_hd__a211oi_2
XTAP_TAPCELL_ROW_5_319 VGND VPWR sky130_fd_sc_hd__tapvpwrvgnd_1
XTAP_TAPCELL_ROW_5_308 VGND VPWR sky130_fd_sc_hd__tapvpwrvgnd_1
X_6063_ _1547_ _1549_ _1592_ VGND VGND VPWR VPWR _1596_ sky130_fd_sc_hd__o21a_1
XFILLER_58_529 VGND VGND VPWR VPWR sky130_fd_sc_hd__decap_3
XFILLER_85_337 VGND VGND VPWR VPWR sky130_fd_sc_hd__decap_4
X_5014_ _0753_ _0754_ _0721_ _0722_ VGND VGND VPWR VPWR _0757_ sky130_fd_sc_hd__a211o_1
XFILLER_38_242 VGND VGND VPWR VPWR sky130_fd_sc_hd__fill_2
Xclone192 _1438_ VGND VGND VPWR VPWR net707 sky130_fd_sc_hd__clkbuf_1
XFILLER_81_521 VGND VGND VPWR VPWR sky130_fd_sc_hd__decap_8
XFILLER_81_565 VGND VGND VPWR VPWR sky130_fd_sc_hd__fill_1
X_6965_ _2433_ _2395_ VGND VGND VPWR VPWR _2434_ sky130_fd_sc_hd__nand2b_1
X_8704_ net163 _4077_ VGND VGND VPWR VPWR _4078_ sky130_fd_sc_hd__nor2_1
XFILLER_81_598 VGND VGND VPWR VPWR sky130_fd_sc_hd__decap_3
XFILLER_81_576 VGND VGND VPWR VPWR sky130_fd_sc_hd__decap_8
X_5916_ _1450_ _1451_ _1432_ VGND VGND VPWR VPWR _1453_ sky130_fd_sc_hd__a21o_1
XFILLER_41_418 VPWR VGND VPWR VGND sky130_ef_sc_hd__decap_12
X_8635_ net420 _4011_ VGND VGND VPWR VPWR _0394_ sky130_fd_sc_hd__nor2_1
XFILLER_34_492 VGND VGND VPWR VPWR sky130_fd_sc_hd__fill_1
X_6896_ _2325_ _2365_ VGND VGND VPWR VPWR _2366_ sky130_fd_sc_hd__xnor2_1
X_5847_ _1346_ _1384_ VGND VGND VPWR VPWR _1385_ sky130_fd_sc_hd__xnor2_1
XFILLER_42_27 VGND VGND VPWR VPWR sky130_fd_sc_hd__fill_1
X_8566_ _3912_ _3915_ _3943_ VGND VGND VPWR VPWR _3945_ sky130_fd_sc_hd__and3_1
X_5778_ net490 net352 net350 net497 VGND VGND VPWR VPWR _1318_ sky130_fd_sc_hd__a22oi_1
X_8497_ _3848_ _3876_ VGND VGND VPWR VPWR _3878_ sky130_fd_sc_hd__xnor2_1
X_7517_ _2933_ _2934_ _2968_ _2969_ VGND VGND VPWR VPWR _2970_ sky130_fd_sc_hd__o211a_1
X_4729_ _0469_ _0477_ VGND VGND VPWR VPWR _0479_ sky130_fd_sc_hd__xnor2_1
XFILLER_107_225 VGND VGND VPWR VPWR sky130_fd_sc_hd__fill_2
X_7448_ net425 _2903_ VGND VGND VPWR VPWR _0315_ sky130_fd_sc_hd__nor2_1
XFILLER_107_247 VGND VGND VPWR VPWR sky130_fd_sc_hd__fill_1
X_7379_ net166 _2805_ _2804_ VGND VGND VPWR VPWR _2837_ sky130_fd_sc_hd__o21bai_1
XFILLER_1_503 VGND VGND VPWR VPWR sky130_fd_sc_hd__fill_1
X_9118_ clknet_leaf_18_clk _0230_ VGND VGND VPWR VPWR pe_array\[0\].u_pe.accum_reg\[4\]
+ sky130_fd_sc_hd__dfxtp_1
XFILLER_89_687 VGND VGND VPWR VPWR sky130_fd_sc_hd__decap_4
X_9049_ clknet_leaf_4_clk _0161_ VGND VGND VPWR VPWR net122 sky130_fd_sc_hd__dfxtp_1
XFILLER_57_573 VGND VGND VPWR VPWR sky130_fd_sc_hd__decap_4
XFILLER_72_510 VPWR VGND VPWR VGND sky130_ef_sc_hd__decap_12
XTAP_TAPCELL_ROW_67_1057 VGND VPWR sky130_fd_sc_hd__tapvpwrvgnd_1
XFILLER_17_459 VGND VGND VPWR VPWR sky130_fd_sc_hd__fill_1
XTAP_TAPCELL_ROW_80_1213 VGND VPWR sky130_fd_sc_hd__tapvpwrvgnd_1
XFILLER_16_83 VGND VGND VPWR VPWR sky130_fd_sc_hd__fill_1
XTAP_TAPCELL_ROW_30_608 VGND VPWR sky130_fd_sc_hd__tapvpwrvgnd_1
XTAP_TAPCELL_ROW_30_619 VGND VPWR sky130_fd_sc_hd__tapvpwrvgnd_1
XFILLER_40_473 VGND VGND VPWR VPWR sky130_fd_sc_hd__decap_3
XFILLER_12_197 VGND VGND VPWR VPWR sky130_fd_sc_hd__fill_2
XFILLER_8_179 VGND VGND VPWR VPWR sky130_fd_sc_hd__fill_1
XTAP_TAPCELL_ROW_10_376 VGND VPWR sky130_fd_sc_hd__tapvpwrvgnd_1
XTAP_TAPCELL_ROW_78_1186 VGND VPWR sky130_fd_sc_hd__tapvpwrvgnd_1
XTAP_TAPCELL_ROW_91_1342 VGND VPWR sky130_fd_sc_hd__tapvpwrvgnd_1
XFILLER_79_175 VGND VGND VPWR VPWR sky130_fd_sc_hd__fill_1
XFILLER_95_646 VGND VGND VPWR VPWR sky130_fd_sc_hd__fill_2
XFILLER_67_337 VGND VGND VPWR VPWR sky130_fd_sc_hd__decap_8
XFILLER_82_307 VGND VGND VPWR VPWR sky130_fd_sc_hd__fill_1
XFILLER_67_359 VPWR VGND VPWR VGND sky130_ef_sc_hd__decap_12
XTAP_TAPCELL_ROW_38_708 VGND VPWR sky130_fd_sc_hd__tapvpwrvgnd_1
XFILLER_35_223 VGND VGND VPWR VPWR sky130_fd_sc_hd__fill_1
X_6750_ _2223_ _2224_ net503 net337 VGND VGND VPWR VPWR _2225_ sky130_fd_sc_hd__and4bb_1
XTAP_TAPCELL_ROW_18_465 VGND VPWR sky130_fd_sc_hd__tapvpwrvgnd_1
X_5701_ net504 net356 pe_array\[0\].u_pe.accum_reg\[1\] VGND VGND VPWR VPWR _1245_
+ sky130_fd_sc_hd__a21oi_1
X_6681_ _2188_ _2194_ VGND VGND VPWR VPWR _2195_ sky130_fd_sc_hd__xnor2_1
X_5632_ net984 net383 VGND VGND VPWR VPWR _0173_ sky130_fd_sc_hd__and2_1
X_8420_ _3771_ _3772_ _3801_ _3802_ VGND VGND VPWR VPWR _3803_ sky130_fd_sc_hd__o211a_1
X_5563_ net904 net395 VGND VGND VPWR VPWR _0104_ sky130_fd_sc_hd__and2_1
X_8351_ _3732_ _3733_ net684 VGND VGND VPWR VPWR _3736_ sky130_fd_sc_hd__o21ai_1
X_7302_ _2762_ _2761_ VGND VGND VPWR VPWR _2763_ sky130_fd_sc_hd__or2_4
X_4514_ _4277_ _4278_ net592 net302 VGND VGND VPWR VPWR _4280_ sky130_fd_sc_hd__or4bb_4
X_8282_ _3666_ _3667_ VGND VGND VPWR VPWR _3669_ sky130_fd_sc_hd__nand2_1
X_5494_ net992 net246 _1207_ net364 VGND VGND VPWR VPWR _0057_ sky130_fd_sc_hd__o211a_1
XFILLER_117_589 VPWR VGND VPWR VGND sky130_ef_sc_hd__decap_12
X_4445_ pe_array\[0\].u_pe.accum_reg\[31\] VGND VGND VPWR VPWR _4226_ sky130_fd_sc_hd__inv_2
X_7233_ net408 pe_array\[1\].u_pe.accum_reg\[14\] net229 _2695_ VGND VGND VPWR VPWR
+ _2696_ sky130_fd_sc_hd__o2bb2a_4
X_7164_ _2575_ _2627_ VGND VGND VPWR VPWR _2628_ sky130_fd_sc_hd__xnor2_1
X_6115_ _1639_ _1646_ VGND VGND VPWR VPWR _1647_ sky130_fd_sc_hd__and2b_1
XPHY_EDGE_ROW_13_Left_131 VGND VGND VPWR VPWR sky130_fd_sc_hd__decap_3
XFILLER_100_412 VGND VGND VPWR VPWR sky130_fd_sc_hd__decap_4
X_7095_ _2494_ _2496_ _2559_ _2560_ VGND VGND VPWR VPWR _2561_ sky130_fd_sc_hd__a211oi_1
X_6046_ _1577_ _1578_ _1579_ VGND VGND VPWR VPWR _1580_ sky130_fd_sc_hd__nand3_2
XFILLER_39_551 VGND VGND VPWR VPWR sky130_fd_sc_hd__decap_8
XFILLER_73_329 VGND VGND VPWR VPWR sky130_fd_sc_hd__decap_6
XFILLER_54_554 VGND VGND VPWR VPWR sky130_fd_sc_hd__decap_3
XFILLER_54_543 VGND VGND VPWR VPWR sky130_fd_sc_hd__decap_3
XFILLER_81_362 VGND VGND VPWR VPWR sky130_fd_sc_hd__decap_3
X_7997_ _3381_ _3389_ VGND VGND VPWR VPWR _3391_ sky130_fd_sc_hd__xnor2_1
XFILLER_53_15 VPWR VGND VPWR VGND sky130_ef_sc_hd__decap_12
XFILLER_26_256 VGND VGND VPWR VPWR sky130_fd_sc_hd__decap_3
X_6948_ net272 _2414_ _2415_ VGND VGND VPWR VPWR _2417_ sky130_fd_sc_hd__or3_4
X_6879_ _2348_ _2349_ VGND VGND VPWR VPWR _2350_ sky130_fd_sc_hd__nand2_1
XPHY_EDGE_ROW_22_Left_140 VGND VGND VPWR VPWR sky130_fd_sc_hd__decap_3
X_8618_ _3992_ _3993_ VGND VGND VPWR VPWR _3995_ sky130_fd_sc_hd__xnor2_1
X_8549_ _3896_ net192 _3894_ VGND VGND VPWR VPWR _3928_ sky130_fd_sc_hd__a21o_1
Xrebuffer232 _0436_ VGND VGND VPWR VPWR net747 sky130_fd_sc_hd__buf_1
XFILLER_6_617 VPWR VGND VPWR VGND sky130_ef_sc_hd__decap_12
XTAP_TAPCELL_ROW_114_1618 VGND VPWR sky130_fd_sc_hd__tapvpwrvgnd_1
XFILLER_108_589 VGND VGND VPWR VPWR sky130_fd_sc_hd__decap_4
XFILLER_110_209 VGND VGND VPWR VPWR sky130_fd_sc_hd__fill_1
XFILLER_49_326 VGND VGND VPWR VPWR sky130_fd_sc_hd__decap_8
XFILLER_49_337 VPWR VGND VPWR VGND sky130_ef_sc_hd__decap_12
XFILLER_92_605 VGND VGND VPWR VPWR sky130_fd_sc_hd__fill_2
XFILLER_64_307 VGND VGND VPWR VPWR sky130_fd_sc_hd__fill_1
XFILLER_76_189 VGND VGND VPWR VPWR sky130_fd_sc_hd__decap_6
XFILLER_45_521 VGND VGND VPWR VPWR sky130_fd_sc_hd__decap_8
XFILLER_91_159 VGND VGND VPWR VPWR sky130_fd_sc_hd__decap_4
XFILLER_72_340 VGND VGND VPWR VPWR sky130_fd_sc_hd__fill_1
XFILLER_17_223 VGND VGND VPWR VPWR sky130_fd_sc_hd__fill_1
XFILLER_45_554 VGND VGND VPWR VPWR sky130_fd_sc_hd__decap_3
XFILLER_45_576 VPWR VGND VPWR VGND sky130_ef_sc_hd__decap_12
XTAP_TAPCELL_ROW_15_435 VGND VPWR sky130_fd_sc_hd__tapvpwrvgnd_1
XTAP_TAPCELL_ROW_43_766 VGND VPWR sky130_fd_sc_hd__tapvpwrvgnd_1
XFILLER_43_81 VGND VGND VPWR VPWR sky130_fd_sc_hd__decap_4
XFILLER_71_7 VGND VGND VPWR VPWR sky130_fd_sc_hd__decap_8
XFILLER_40_281 VGND VGND VPWR VPWR sky130_fd_sc_hd__decap_8
XFILLER_9_488 VGND VGND VPWR VPWR sky130_fd_sc_hd__fill_1
XFILLER_114_515 VPWR VGND VPWR VGND sky130_ef_sc_hd__decap_12
XFILLER_4_182 VGND VGND VPWR VPWR sky130_fd_sc_hd__decap_4
XFILLER_68_613 VPWR VGND VPWR VGND sky130_ef_sc_hd__decap_12
XFILLER_4_53 VPWR VGND VPWR VGND sky130_ef_sc_hd__decap_12
XFILLER_68_657 VPWR VGND VPWR VGND sky130_ef_sc_hd__decap_12
XFILLER_67_134 VGND VGND VPWR VPWR sky130_fd_sc_hd__decap_8
XFILLER_55_307 VGND VGND VPWR VPWR sky130_fd_sc_hd__fill_2
XFILLER_95_498 VGND VGND VPWR VPWR sky130_fd_sc_hd__decap_6
X_7920_ _3313_ _3314_ VGND VGND VPWR VPWR _3316_ sky130_fd_sc_hd__xnor2_2
X_7851_ _3245_ _3246_ net504 net320 VGND VGND VPWR VPWR _3249_ sky130_fd_sc_hd__a2bb2o_1
XFILLER_91_671 VGND VGND VPWR VPWR sky130_fd_sc_hd__fill_1
X_6802_ _2273_ _2274_ VGND VGND VPWR VPWR _2275_ sky130_fd_sc_hd__nor2_1
XFILLER_36_587 VGND VGND VPWR VPWR sky130_fd_sc_hd__fill_1
XFILLER_23_215 VGND VGND VPWR VPWR sky130_fd_sc_hd__decap_8
XFILLER_23_237 VGND VGND VPWR VPWR sky130_fd_sc_hd__decap_3
X_7782_ net956 net225 _3200_ net377 VGND VGND VPWR VPWR _0352_ sky130_fd_sc_hd__o211a_1
X_4994_ _0719_ _0736_ _0737_ VGND VGND VPWR VPWR _0738_ sky130_fd_sc_hd__nand3_1
X_6733_ net1024 _2207_ _2210_ VGND VGND VPWR VPWR _0293_ sky130_fd_sc_hd__o21ba_1
XFILLER_51_568 VGND VGND VPWR VPWR sky130_fd_sc_hd__decap_6
X_6664_ _2145_ _2148_ _2177_ VGND VGND VPWR VPWR _2179_ sky130_fd_sc_hd__or3_1
X_5615_ net918 net385 VGND VGND VPWR VPWR _0156_ sky130_fd_sc_hd__and2_1
X_8403_ _3783_ _3784_ _3785_ VGND VGND VPWR VPWR _3787_ sky130_fd_sc_hd__a21o_1
X_6595_ net657 _2111_ VGND VGND VPWR VPWR _2112_ sky130_fd_sc_hd__nor2_1
X_5546_ net900 net392 VGND VGND VPWR VPWR _0087_ sky130_fd_sc_hd__and2_1
X_8334_ _3716_ _3717_ _3718_ VGND VGND VPWR VPWR _3720_ sky130_fd_sc_hd__a21oi_1
XFILLER_3_609 VGND VGND VPWR VPWR sky130_fd_sc_hd__decap_6
X_8265_ _3611_ _3609_ _3651_ _3652_ VGND VGND VPWR VPWR _3653_ sky130_fd_sc_hd__a211o_4
X_5477_ net254 _4352_ VGND VGND VPWR VPWR _1199_ sky130_fd_sc_hd__nand2_1
X_7216_ _2675_ _2676_ _2677_ VGND VGND VPWR VPWR _2679_ sky130_fd_sc_hd__a21o_1
Xfanout401 net405 VGND VGND VPWR VPWR net401 sky130_fd_sc_hd__buf_2
Xfanout412 net413 VGND VGND VPWR VPWR net412 sky130_fd_sc_hd__clkbuf_2
X_8196_ _3583_ _3584_ VGND VGND VPWR VPWR _3585_ sky130_fd_sc_hd__nor2_1
Xfanout423 net9 VGND VGND VPWR VPWR net423 sky130_fd_sc_hd__buf_4
XFILLER_48_15 VPWR VGND VPWR VGND sky130_ef_sc_hd__decap_12
Xfanout445 net596 VGND VGND VPWR VPWR net445 sky130_fd_sc_hd__buf_12
Xfanout456 net457 VGND VGND VPWR VPWR net456 sky130_fd_sc_hd__clkbuf_2
XFILLER_98_292 VGND VGND VPWR VPWR sky130_fd_sc_hd__fill_1
Xfanout434 net436 VGND VGND VPWR VPWR net434 sky130_fd_sc_hd__clkbuf_2
X_7147_ _2564_ _2609_ VGND VGND VPWR VPWR _2612_ sky130_fd_sc_hd__xor2_1
XFILLER_86_465 VGND VGND VPWR VPWR sky130_fd_sc_hd__decap_8
Xfanout467 net468 VGND VGND VPWR VPWR net467 sky130_fd_sc_hd__buf_2
Xfanout489 net4 VGND VGND VPWR VPWR net489 sky130_fd_sc_hd__clkbuf_2
Xfanout478 net5 VGND VGND VPWR VPWR net478 sky130_fd_sc_hd__buf_2
X_7078_ net525 net339 pe_array\[1\].u_pe.accum_reg\[11\] VGND VGND VPWR VPWR _2544_
+ sky130_fd_sc_hd__a21oi_1
X_6029_ _1557_ _1562_ VGND VGND VPWR VPWR _1563_ sky130_fd_sc_hd__nand2_1
XFILLER_39_381 VGND VGND VPWR VPWR sky130_fd_sc_hd__decap_3
XFILLER_54_362 VGND VGND VPWR VPWR sky130_fd_sc_hd__fill_2
XFILLER_14_204 VPWR VGND VPWR VGND sky130_ef_sc_hd__decap_12
XTAP_TAPCELL_ROW_64_1027 VGND VPWR sky130_fd_sc_hd__tapvpwrvgnd_1
XTAP_TAPCELL_ROW_64_1016 VGND VPWR sky130_fd_sc_hd__tapvpwrvgnd_1
XFILLER_42_568 VGND VGND VPWR VPWR sky130_fd_sc_hd__fill_2
XTAP_TAPCELL_ROW_40_736 VGND VPWR sky130_fd_sc_hd__tapvpwrvgnd_1
XFILLER_10_421 VPWR VGND VPWR VGND sky130_ef_sc_hd__decap_12
XFILLER_22_281 VPWR VGND VPWR VGND sky130_ef_sc_hd__decap_12
XFILLER_108_353 VGND VGND VPWR VPWR sky130_fd_sc_hd__decap_3
XFILLER_89_11 VGND VGND VPWR VPWR sky130_fd_sc_hd__fill_1
XFILLER_6_469 VGND VGND VPWR VPWR sky130_fd_sc_hd__fill_1
XTAP_TAPCELL_ROW_20_493 VGND VPWR sky130_fd_sc_hd__tapvpwrvgnd_1
XFILLER_108_397 VGND VGND VPWR VPWR sky130_fd_sc_hd__decap_4
XFILLER_89_88 VGND VGND VPWR VPWR sky130_fd_sc_hd__fill_2
XTAP_TAPCELL_ROW_75_1156 VGND VPWR sky130_fd_sc_hd__tapvpwrvgnd_1
XFILLER_89_270 VGND VGND VPWR VPWR sky130_fd_sc_hd__decap_8
XTAP_TAPCELL_ROW_48_825 VGND VPWR sky130_fd_sc_hd__tapvpwrvgnd_1
XFILLER_80_608 VPWR VGND VPWR VGND sky130_ef_sc_hd__decap_12
XFILLER_18_565 VGND VGND VPWR VPWR sky130_fd_sc_hd__decap_8
XTAP_TAPCELL_ROW_86_1285 VGND VPWR sky130_fd_sc_hd__tapvpwrvgnd_1
XTAP_TAPCELL_ROW_28_593 VGND VPWR sky130_fd_sc_hd__tapvpwrvgnd_1
XFILLER_13_270 VGND VGND VPWR VPWR sky130_fd_sc_hd__decap_8
X_6380_ _1901_ _1902_ _1872_ _1873_ VGND VGND VPWR VPWR _1904_ sky130_fd_sc_hd__a211o_1
Xclkload44 clknet_leaf_15_clk VGND VGND VPWR VPWR clkload44/Y sky130_fd_sc_hd__inv_12
Xclkload33 clknet_leaf_2_clk VGND VGND VPWR VPWR clkload33/Y sky130_fd_sc_hd__clkinv_8
Xclkload11 clknet_leaf_60_clk VGND VGND VPWR VPWR clkload11/Y sky130_fd_sc_hd__clkinvlp_4
X_5400_ net303 net438 _1129_ VGND VGND VPWR VPWR _1130_ sky130_fd_sc_hd__and3_1
Xclkload22 clknet_leaf_44_clk VGND VGND VPWR VPWR clkload22/Y sky130_fd_sc_hd__inv_12
Xclkload55 clknet_leaf_25_clk VGND VGND VPWR VPWR clkload55/Y sky130_fd_sc_hd__inv_16
X_5331_ net399 pe_array\[3\].u_pe.accum_reg\[26\] net258 _1063_ VGND VGND VPWR VPWR
+ _1064_ sky130_fd_sc_hd__o2bb2a_4
XFILLER_114_345 VPWR VGND VPWR VGND sky130_ef_sc_hd__decap_12
X_8050_ _3440_ _3441_ _3392_ _3394_ VGND VGND VPWR VPWR _3443_ sky130_fd_sc_hd__o211a_1
X_5262_ _0996_ _0995_ VGND VGND VPWR VPWR _0997_ sky130_fd_sc_hd__and2b_1
X_7001_ _2412_ _2421_ _2420_ VGND VGND VPWR VPWR _2469_ sky130_fd_sc_hd__a21bo_1
XFILLER_68_421 VPWR VGND VPWR VGND sky130_ef_sc_hd__decap_12
X_5193_ _0902_ _0903_ _0928_ _0929_ VGND VGND VPWR VPWR _0930_ sky130_fd_sc_hd__o211ai_1
XFILLER_110_551 VGND VGND VPWR VPWR sky130_fd_sc_hd__decap_8
XFILLER_18_29 VGND VGND VPWR VPWR sky130_fd_sc_hd__decap_6
XFILLER_28_307 VGND VGND VPWR VPWR sky130_fd_sc_hd__fill_1
X_8952_ clknet_leaf_64_clk _0064_ VGND VGND VPWR VPWR pe_accum\[3\]\[20\] sky130_fd_sc_hd__dfxtp_1
X_8883_ net936 net213 _4222_ net385 VGND VGND VPWR VPWR _0431_ sky130_fd_sc_hd__o211a_1
X_7903_ net480 net474 net322 VGND VGND VPWR VPWR _3299_ sky130_fd_sc_hd__and3_1
XFILLER_24_502 VGND VGND VPWR VPWR sky130_fd_sc_hd__decap_4
XFILLER_36_351 VPWR VGND VPWR VGND sky130_ef_sc_hd__decap_12
X_7834_ pe_array\[2\].u_pe.accum_reg\[2\] net513 net320 VGND VGND VPWR VPWR _3233_
+ sky130_fd_sc_hd__and3_1
XFILLER_51_310 VGND VGND VPWR VPWR sky130_fd_sc_hd__fill_1
XFILLER_51_343 VGND VGND VPWR VPWR sky130_fd_sc_hd__fill_1
X_7765_ net222 _2821_ VGND VGND VPWR VPWR _3192_ sky130_fd_sc_hd__nand2_1
X_6716_ net915 net233 _2127_ net242 VGND VGND VPWR VPWR _0286_ sky130_fd_sc_hd__o2bb2ai_1
X_4977_ pe_array\[3\].u_pe.accum_reg\[15\] net298 net435 VGND VGND VPWR VPWR _0721_
+ sky130_fd_sc_hd__and3_1
Xclkload5 clknet_3_6__leaf_clk VGND VGND VPWR VPWR clkload5/Y sky130_fd_sc_hd__clkinv_2
X_7696_ _3112_ _3114_ _3142_ VGND VGND VPWR VPWR _3143_ sky130_fd_sc_hd__and3_1
X_6647_ _2135_ _2137_ VGND VGND VPWR VPWR _2162_ sky130_fd_sc_hd__or2_1
XFILLER_50_27 VGND VGND VPWR VPWR sky130_fd_sc_hd__fill_1
X_6578_ _2057_ _2085_ _2059_ VGND VGND VPWR VPWR _2095_ sky130_fd_sc_hd__o21ai_1
X_8317_ net439 net313 pe_array\[2\].u_pe.accum_reg\[15\] VGND VGND VPWR VPWR _3703_
+ sky130_fd_sc_hd__a21oi_1
X_5529_ net252 _1192_ VGND VGND VPWR VPWR _1225_ sky130_fd_sc_hd__nand2_1
XFILLER_3_417 VPWR VGND VPWR VGND sky130_ef_sc_hd__decap_12
X_9297_ clknet_leaf_10_clk _0409_ VGND VGND VPWR VPWR pe_accum\[2\]\[7\] sky130_fd_sc_hd__dfxtp_1
X_8248_ net683 _3634_ _3635_ VGND VGND VPWR VPWR _3636_ sky130_fd_sc_hd__nor3_1
Xfanout220 _3209_ VGND VGND VPWR VPWR net220 sky130_fd_sc_hd__dlymetal6s2s_1
X_8179_ _3567_ _3565_ _3519_ _3522_ VGND VGND VPWR VPWR _3569_ sky130_fd_sc_hd__o211a_1
XFILLER_59_69 VPWR VGND VPWR VGND sky130_ef_sc_hd__decap_12
Xfanout231 _2203_ VGND VGND VPWR VPWR net231 sky130_fd_sc_hd__buf_2
Xfanout242 net243 VGND VGND VPWR VPWR net242 sky130_fd_sc_hd__clkbuf_4
Xfanout264 net265 VGND VGND VPWR VPWR net264 sky130_fd_sc_hd__clkbuf_4
XFILLER_86_240 VPWR VGND VPWR VGND sky130_ef_sc_hd__decap_12
Xfanout253 net254 VGND VGND VPWR VPWR net253 sky130_fd_sc_hd__clkbuf_4
Xfanout275 net281 VGND VGND VPWR VPWR net275 sky130_fd_sc_hd__buf_8
XTAP_TAPCELL_ROW_70_1097 VGND VPWR sky130_fd_sc_hd__tapvpwrvgnd_1
Xfanout297 net298 VGND VGND VPWR VPWR net297 sky130_fd_sc_hd__clkbuf_2
Xfanout286 _0482_ VGND VGND VPWR VPWR net286 sky130_fd_sc_hd__buf_4
XFILLER_75_57 VGND VGND VPWR VPWR sky130_fd_sc_hd__decap_8
XFILLER_74_468 VGND VGND VPWR VPWR sky130_fd_sc_hd__fill_2
XFILLER_55_671 VGND VGND VPWR VPWR sky130_fd_sc_hd__fill_1
XFILLER_15_557 VGND VGND VPWR VPWR sky130_fd_sc_hd__decap_3
XTAP_TAPCELL_ROW_53_894 VGND VPWR sky130_fd_sc_hd__tapvpwrvgnd_1
XTAP_TAPCELL_ROW_25_552 VGND VPWR sky130_fd_sc_hd__tapvpwrvgnd_1
XFILLER_42_365 VGND VGND VPWR VPWR sky130_fd_sc_hd__decap_6
XFILLER_6_233 VGND VGND VPWR VPWR sky130_fd_sc_hd__fill_1
XFILLER_109_673 VGND VGND VPWR VPWR sky130_fd_sc_hd__decap_3
XFILLER_108_161 VPWR VGND VPWR VGND sky130_ef_sc_hd__decap_12
XFILLER_97_505 VPWR VGND VPWR VGND sky130_ef_sc_hd__decap_12
XFILLER_111_337 VPWR VGND VPWR VGND sky130_ef_sc_hd__decap_12
XFILLER_34_7 VGND VGND VPWR VPWR sky130_fd_sc_hd__fill_1
XTAP_TAPCELL_ROW_88_1314 VGND VPWR sky130_fd_sc_hd__tapvpwrvgnd_1
XFILLER_92_232 VGND VGND VPWR VPWR sky130_fd_sc_hd__fill_1
XFILLER_53_608 VGND VGND VPWR VPWR sky130_fd_sc_hd__decap_3
X_5880_ _1416_ _1417_ VGND VGND VPWR VPWR _1418_ sky130_fd_sc_hd__or2_1
XFILLER_65_90 VGND VGND VPWR VPWR sky130_fd_sc_hd__decap_3
X_4900_ net460 pe_array\[3\].u_pe.weight_in\[7\] VGND VGND VPWR VPWR _0646_ sky130_fd_sc_hd__and2b_1
X_4831_ _0519_ _0528_ _0527_ VGND VGND VPWR VPWR _0579_ sky130_fd_sc_hd__a21bo_1
XFILLER_61_685 VGND VGND VPWR VPWR sky130_fd_sc_hd__decap_8
XFILLER_60_162 VGND VGND VPWR VPWR sky130_fd_sc_hd__decap_6
XFILLER_21_505 VGND VGND VPWR VPWR sky130_fd_sc_hd__decap_8
X_4762_ _0509_ _0510_ VGND VGND VPWR VPWR _0511_ sky130_fd_sc_hd__nand2b_1
XFILLER_33_398 VPWR VGND VPWR VGND sky130_ef_sc_hd__decap_12
X_7550_ _2999_ _3000_ VGND VGND VPWR VPWR _3002_ sky130_fd_sc_hd__xnor2_1
X_6501_ _2019_ _2020_ VGND VGND VPWR VPWR _2021_ sky130_fd_sc_hd__and2_1
XTAP_TAPCELL_ROW_99_1443 VGND VPWR sky130_fd_sc_hd__tapvpwrvgnd_1
X_7481_ net268 _2932_ _2933_ VGND VGND VPWR VPWR _2935_ sky130_fd_sc_hd__or3_1
X_4693_ net302 net461 _0442_ _0443_ VGND VGND VPWR VPWR _0444_ sky130_fd_sc_hd__nand4_2
X_6432_ net279 _1952_ _1953_ VGND VGND VPWR VPWR _1954_ sky130_fd_sc_hd__nor3_1
X_9220_ clknet_leaf_39_clk _0332_ VGND VGND VPWR VPWR pe_accum\[1\]\[6\] sky130_fd_sc_hd__dfxtp_1
X_9151_ clknet_leaf_21_clk _0263_ VGND VGND VPWR VPWR pe_accum\[0\]\[5\] sky130_fd_sc_hd__dfxtp_1
X_6363_ _1858_ _1860_ VGND VGND VPWR VPWR _1888_ sky130_fd_sc_hd__and2_1
X_8102_ net419 _3493_ VGND VGND VPWR VPWR _0379_ sky130_fd_sc_hd__nor2_1
XFILLER_115_665 VGND VGND VPWR VPWR sky130_fd_sc_hd__decap_6
XFILLER_114_131 VGND VGND VPWR VPWR sky130_fd_sc_hd__fill_1
X_6294_ net200 _1788_ _1786_ VGND VGND VPWR VPWR _1821_ sky130_fd_sc_hd__a21o_1
X_5314_ net208 _1045_ VGND VGND VPWR VPWR _1047_ sky130_fd_sc_hd__xnor2_1
X_9082_ clknet_leaf_66_clk _0194_ VGND VGND VPWR VPWR net31 sky130_fd_sc_hd__dfxtp_1
XFILLER_102_304 VGND VGND VPWR VPWR sky130_fd_sc_hd__decap_4
X_8033_ _3424_ _3425_ net463 net321 VGND VGND VPWR VPWR _3426_ sky130_fd_sc_hd__and4bb_1
X_5245_ _0944_ _0974_ _0946_ VGND VGND VPWR VPWR _0980_ sky130_fd_sc_hd__o21ai_1
X_5176_ net186 _0883_ _0882_ VGND VGND VPWR VPWR _0914_ sky130_fd_sc_hd__a21o_1
XFILLER_28_104 VGND VGND VPWR VPWR sky130_fd_sc_hd__decap_8
XFILLER_110_370 VGND VGND VPWR VPWR sky130_fd_sc_hd__fill_1
XFILLER_68_295 VGND VGND VPWR VPWR sky130_fd_sc_hd__fill_1
XFILLER_56_446 VGND VGND VPWR VPWR sky130_fd_sc_hd__fill_1
XTAP_TAPCELL_ROW_108_1550 VGND VPWR sky130_fd_sc_hd__tapvpwrvgnd_1
X_8935_ clknet_leaf_52_clk _0047_ VGND VGND VPWR VPWR pe_accum\[3\]\[3\] sky130_fd_sc_hd__dfxtp_1
XFILLER_45_27 VPWR VGND VPWR VGND sky130_ef_sc_hd__decap_12
X_8866_ net212 _3916_ VGND VGND VPWR VPWR _4214_ sky130_fd_sc_hd__nand2_2
Xclkbuf_leaf_63_clk clknet_3_0__leaf_clk VGND VGND VPWR VPWR clknet_leaf_63_clk sky130_fd_sc_hd__clkbuf_8
XFILLER_24_321 VPWR VGND VPWR VGND sky130_ef_sc_hd__decap_12
X_7817_ net513 net325 pe_array\[2\].u_pe.accum_reg\[0\] VGND VGND VPWR VPWR _3218_
+ sky130_fd_sc_hd__a21oi_1
XFILLER_101_55 VGND VGND VPWR VPWR sky130_fd_sc_hd__fill_1
X_8797_ _4137_ _4140_ _4167_ VGND VGND VPWR VPWR _4168_ sky130_fd_sc_hd__o21a_1
XTAP_TAPCELL_ROW_22_522 VGND VPWR sky130_fd_sc_hd__tapvpwrvgnd_1
X_7748_ net978 net225 _3183_ net377 VGND VGND VPWR VPWR _0335_ sky130_fd_sc_hd__o211a_1
X_7679_ _3126_ _3125_ VGND VGND VPWR VPWR _3127_ sky130_fd_sc_hd__and2b_1
XTAP_TAPCELL_ROW_50_853 VGND VPWR sky130_fd_sc_hd__tapvpwrvgnd_1
XFILLER_3_214 VGND VGND VPWR VPWR sky130_fd_sc_hd__fill_1
XTAP_TAPCELL_ROW_72_1115 VGND VPWR sky130_fd_sc_hd__tapvpwrvgnd_1
XFILLER_10_41 VGND VGND VPWR VPWR sky130_fd_sc_hd__decap_6
XPHY_EDGE_ROW_5_Left_123 VGND VGND VPWR VPWR sky130_fd_sc_hd__decap_3
XFILLER_79_527 VGND VGND VPWR VPWR sky130_fd_sc_hd__fill_1
XFILLER_10_85 VGND VGND VPWR VPWR sky130_fd_sc_hd__decap_8
XFILLER_59_240 VGND VGND VPWR VPWR sky130_fd_sc_hd__decap_3
XFILLER_101_370 VPWR VGND VPWR VGND sky130_ef_sc_hd__decap_12
XFILLER_19_50 VGND VGND VPWR VPWR sky130_fd_sc_hd__fill_1
XFILLER_74_243 VGND VGND VPWR VPWR sky130_fd_sc_hd__decap_8
XTAP_TAPCELL_ROW_58_953 VGND VPWR sky130_fd_sc_hd__tapvpwrvgnd_1
XTAP_TAPCELL_ROW_2_280 VGND VPWR sky130_fd_sc_hd__tapvpwrvgnd_1
XTAP_TAPCELL_ROW_83_1244 VGND VPWR sky130_fd_sc_hd__tapvpwrvgnd_1
Xclkbuf_leaf_54_clk clknet_3_1__leaf_clk VGND VGND VPWR VPWR clknet_leaf_54_clk sky130_fd_sc_hd__clkbuf_8
XTAP_TAPCELL_ROW_83_1255 VGND VPWR sky130_fd_sc_hd__tapvpwrvgnd_1
XFILLER_51_81 VPWR VGND VPWR VGND sky130_ef_sc_hd__decap_12
XFILLER_11_593 VGND VGND VPWR VPWR sky130_fd_sc_hd__fill_1
Xhold509 pe_array\[1\].u_pe.tap_count\[3\] VGND VGND VPWR VPWR net1024 sky130_fd_sc_hd__dlygate4sd3_1
XFILLER_109_470 VGND VGND VPWR VPWR sky130_fd_sc_hd__fill_2
XTAP_TAPCELL_ROW_94_1384 VGND VPWR sky130_fd_sc_hd__tapvpwrvgnd_1
XFILLER_112_613 VPWR VGND VPWR VGND sky130_ef_sc_hd__decap_12
XFILLER_111_101 VGND VGND VPWR VPWR sky130_fd_sc_hd__fill_2
XFILLER_112_657 VPWR VGND VPWR VGND sky130_ef_sc_hd__decap_12
X_5030_ _0768_ _0769_ _0770_ VGND VGND VPWR VPWR _0773_ sky130_fd_sc_hd__a21o_1
XFILLER_25_3 VPWR VGND VPWR VGND sky130_ef_sc_hd__decap_12
XFILLER_26_608 VGND VGND VPWR VPWR sky130_fd_sc_hd__fill_1
X_6981_ net495 _4234_ VGND VGND VPWR VPWR _2449_ sky130_fd_sc_hd__nor2_1
X_8720_ _4005_ _4033_ _4032_ VGND VGND VPWR VPWR _4093_ sky130_fd_sc_hd__o21a_1
XPHY_EDGE_ROW_69_Left_187 VGND VGND VPWR VPWR sky130_fd_sc_hd__decap_3
X_5932_ net481 net346 net344 net491 VGND VGND VPWR VPWR _1468_ sky130_fd_sc_hd__a22oi_1
XTAP_TAPCELL_ROW_0_239 VGND VPWR sky130_fd_sc_hd__tapvpwrvgnd_1
XFILLER_19_671 VGND VGND VPWR VPWR sky130_fd_sc_hd__fill_1
XFILLER_53_449 VGND VGND VPWR VPWR sky130_fd_sc_hd__fill_2
Xclkbuf_leaf_45_clk clknet_3_2__leaf_clk VGND VGND VPWR VPWR clknet_leaf_45_clk sky130_fd_sc_hd__clkbuf_8
X_8651_ _4025_ _4026_ VGND VGND VPWR VPWR _4027_ sky130_fd_sc_hd__nor2_1
X_5863_ _1392_ _1400_ VGND VGND VPWR VPWR _1401_ sky130_fd_sc_hd__xnor2_1
X_8582_ net162 _3958_ _3959_ VGND VGND VPWR VPWR _3960_ sky130_fd_sc_hd__or3_1
X_5794_ _1315_ _1332_ _1333_ VGND VGND VPWR VPWR _1334_ sky130_fd_sc_hd__and3_1
X_7602_ net197 _3050_ VGND VGND VPWR VPWR _3052_ sky130_fd_sc_hd__xnor2_1
X_4814_ _0556_ _0561_ VGND VGND VPWR VPWR _0562_ sky130_fd_sc_hd__nand2_1
XTAP_TAPCELL_ROW_103_1491 VGND VPWR sky130_fd_sc_hd__tapvpwrvgnd_1
X_7533_ _2952_ _2985_ VGND VGND VPWR VPWR _2986_ sky130_fd_sc_hd__nand2_1
X_4745_ _0492_ _0493_ _0479_ VGND VGND VPWR VPWR _0495_ sky130_fd_sc_hd__a21o_1
XFILLER_107_418 VGND VGND VPWR VPWR sky130_fd_sc_hd__decap_8
XPHY_EDGE_ROW_78_Left_196 VGND VGND VPWR VPWR sky130_fd_sc_hd__decap_3
X_4676_ net493 net483 net292 net290 VGND VGND VPWR VPWR _4437_ sky130_fd_sc_hd__and4_1
X_7464_ _2918_ _2917_ VGND VGND VPWR VPWR _2919_ sky130_fd_sc_hd__and2b_1
X_6415_ _1935_ _1936_ VGND VGND VPWR VPWR _1938_ sky130_fd_sc_hd__xnor2_1
X_9203_ clknet_leaf_46_clk _0315_ VGND VGND VPWR VPWR pe_array\[1\].u_pe.accum_reg\[21\]
+ sky130_fd_sc_hd__dfxtp_1
X_7395_ pe_array\[1\].u_pe.accum_reg\[20\] net447 net340 VGND VGND VPWR VPWR _2852_
+ sky130_fd_sc_hd__and3_1
X_9134_ clknet_leaf_26_clk _0246_ VGND VGND VPWR VPWR pe_array\[0\].u_pe.accum_reg\[20\]
+ sky130_fd_sc_hd__dfxtp_1
X_6346_ net457 net360 pe_array\[0\].u_pe.accum_reg\[20\] VGND VGND VPWR VPWR _1871_
+ sky130_fd_sc_hd__a21oi_1
Xoutput29 net29 VGND VGND VPWR VPWR result_data[106] sky130_fd_sc_hd__buf_2
X_9065_ clknet_leaf_10_clk _0177_ VGND VGND VPWR VPWR net140 sky130_fd_sc_hd__dfxtp_1
XFILLER_88_302 VGND VGND VPWR VPWR sky130_fd_sc_hd__decap_6
XFILLER_103_657 VPWR VGND VPWR VGND sky130_ef_sc_hd__decap_12
XFILLER_102_145 VGND VGND VPWR VPWR sky130_fd_sc_hd__decap_4
X_6277_ _1802_ _1803_ _1773_ VGND VGND VPWR VPWR _1805_ sky130_fd_sc_hd__o21ba_1
X_8016_ net485 net310 net309 net493 VGND VGND VPWR VPWR _3409_ sky130_fd_sc_hd__a22oi_1
X_5228_ _0962_ _0963_ VGND VGND VPWR VPWR _0964_ sky130_fd_sc_hd__and2_1
X_5159_ _0895_ _0811_ _0783_ _0897_ VGND VGND VPWR VPWR _0898_ sky130_fd_sc_hd__a31o_4
XFILLER_29_413 VGND VGND VPWR VPWR sky130_fd_sc_hd__fill_2
XFILLER_29_446 VGND VGND VPWR VPWR sky130_fd_sc_hd__fill_2
XFILLER_84_541 VGND VGND VPWR VPWR sky130_fd_sc_hd__fill_2
XFILLER_56_287 VGND VGND VPWR VPWR sky130_fd_sc_hd__fill_1
XTAP_TAPCELL_ROW_55_912 VGND VPWR sky130_fd_sc_hd__tapvpwrvgnd_1
XFILLER_44_416 VGND VGND VPWR VPWR sky130_fd_sc_hd__decap_4
XFILLER_112_65 VPWR VGND VPWR VGND sky130_ef_sc_hd__decap_12
Xclkbuf_leaf_36_clk clknet_3_6__leaf_clk VGND VGND VPWR VPWR clknet_leaf_36_clk sky130_fd_sc_hd__clkbuf_8
X_8918_ clknet_leaf_66_clk _0030_ VGND VGND VPWR VPWR pe_array\[3\].u_pe.accum_reg\[18\]
+ sky130_fd_sc_hd__dfxtp_1
XFILLER_72_36 VGND VGND VPWR VPWR sky130_fd_sc_hd__decap_3
X_8849_ net1019 net209 _4205_ net382 VGND VGND VPWR VPWR _0414_ sky130_fd_sc_hd__o211a_1
XFILLER_24_173 VGND VGND VPWR VPWR sky130_fd_sc_hd__decap_8
XFILLER_24_195 VGND VGND VPWR VPWR sky130_fd_sc_hd__fill_1
XFILLER_79_302 VGND VGND VPWR VPWR sky130_fd_sc_hd__decap_8
XFILLER_4_589 VPWR VGND VPWR VGND sky130_ef_sc_hd__decap_12
XFILLER_106_495 VGND VGND VPWR VPWR sky130_fd_sc_hd__fill_2
XFILLER_97_88 VGND VGND VPWR VPWR sky130_fd_sc_hd__fill_1
XFILLER_90_533 VPWR VGND VPWR VGND sky130_ef_sc_hd__decap_12
XFILLER_90_500 VGND VGND VPWR VPWR sky130_fd_sc_hd__decap_8
XFILLER_35_427 VGND VGND VPWR VPWR sky130_fd_sc_hd__fill_1
Xclkbuf_leaf_27_clk clknet_3_7__leaf_clk VGND VGND VPWR VPWR clknet_leaf_27_clk sky130_fd_sc_hd__clkbuf_8
XFILLER_62_257 VGND VGND VPWR VPWR sky130_fd_sc_hd__fill_1
XFILLER_16_652 VGND VGND VPWR VPWR sky130_fd_sc_hd__decap_8
XFILLER_50_419 VGND VGND VPWR VPWR sky130_fd_sc_hd__fill_1
XFILLER_31_600 VPWR VGND VPWR VGND sky130_ef_sc_hd__decap_12
XFILLER_31_655 VGND VGND VPWR VPWR sky130_fd_sc_hd__decap_6
XFILLER_31_699 VGND VGND VPWR VPWR sky130_fd_sc_hd__fill_1
XTAP_TAPCELL_ROW_96_1402 VGND VPWR sky130_fd_sc_hd__tapvpwrvgnd_1
X_4530_ _4273_ _4295_ VGND VGND VPWR VPWR _4296_ sky130_fd_sc_hd__xnor2_1
X_4461_ net13 _4240_ _4241_ net358 VGND VGND VPWR VPWR _0000_ sky130_fd_sc_hd__a22o_1
XFILLER_7_372 VPWR VGND VPWR VGND sky130_ef_sc_hd__decap_12
X_6200_ _1728_ _1727_ _1729_ VGND VGND VPWR VPWR _1730_ sky130_fd_sc_hd__and3_1
X_7180_ _2630_ _2642_ _2643_ VGND VGND VPWR VPWR _2644_ sky130_fd_sc_hd__and3_1
X_6131_ _1660_ _1661_ _1648_ VGND VGND VPWR VPWR _1663_ sky130_fd_sc_hd__a21oi_1
XTAP_TAPCELL_ROW_5_309 VGND VPWR sky130_fd_sc_hd__tapvpwrvgnd_1
XFILLER_98_699 VGND VGND VPWR VPWR sky130_fd_sc_hd__fill_1
X_6062_ net431 _1595_ VGND VGND VPWR VPWR _0237_ sky130_fd_sc_hd__nor2_1
X_5013_ _0721_ _0722_ _0753_ _0754_ VGND VGND VPWR VPWR _0756_ sky130_fd_sc_hd__o211ai_1
XFILLER_93_371 VGND VGND VPWR VPWR sky130_fd_sc_hd__fill_1
XFILLER_26_29 VGND VGND VPWR VPWR sky130_fd_sc_hd__decap_8
XFILLER_38_287 VGND VGND VPWR VPWR sky130_fd_sc_hd__decap_8
Xclkbuf_leaf_18_clk clknet_3_6__leaf_clk VGND VGND VPWR VPWR clknet_leaf_18_clk sky130_fd_sc_hd__clkbuf_8
XPHY_EDGE_ROW_5_Right_5 VGND VGND VPWR VPWR sky130_fd_sc_hd__decap_3
X_6964_ _2431_ _2432_ VGND VGND VPWR VPWR _2433_ sky130_fd_sc_hd__or2_1
X_8703_ _4065_ _4075_ VGND VGND VPWR VPWR _4077_ sky130_fd_sc_hd__xnor2_1
X_5915_ _1432_ _1450_ _1451_ VGND VGND VPWR VPWR _1452_ sky130_fd_sc_hd__nand3_2
X_6895_ _2363_ _2364_ VGND VGND VPWR VPWR _2365_ sky130_fd_sc_hd__nor2_1
X_8634_ net401 pe_array\[2\].u_pe.accum_reg\[24\] net218 _4010_ VGND VGND VPWR VPWR
+ _4011_ sky130_fd_sc_hd__o2bb2a_4
X_5846_ _1382_ _1383_ VGND VGND VPWR VPWR _1384_ sky130_fd_sc_hd__nor2_1
X_8565_ _3915_ _3912_ _3943_ VGND VGND VPWR VPWR _3944_ sky130_fd_sc_hd__a21oi_2
XPHY_EDGE_ROW_86_Left_204 VGND VGND VPWR VPWR sky130_fd_sc_hd__decap_3
X_5777_ net497 net490 net352 net350 VGND VGND VPWR VPWR _1317_ sky130_fd_sc_hd__and4_1
XTAP_TAPCELL_ROW_60_970 VGND VPWR sky130_fd_sc_hd__tapvpwrvgnd_1
X_8496_ _3848_ _3876_ VGND VGND VPWR VPWR _3877_ sky130_fd_sc_hd__nand2_1
X_7516_ _2965_ _2966_ net271 VGND VGND VPWR VPWR _2969_ sky130_fd_sc_hd__o21ai_1
X_4728_ _0469_ _0477_ VGND VGND VPWR VPWR _0478_ sky130_fd_sc_hd__nand2b_1
X_7447_ net407 pe_array\[1\].u_pe.accum_reg\[21\] net230 _2902_ VGND VGND VPWR VPWR
+ _2903_ sky130_fd_sc_hd__o2bb2a_1
X_4659_ _4417_ _4419_ _4377_ _4379_ VGND VGND VPWR VPWR _4421_ sky130_fd_sc_hd__o211ai_2
X_7378_ _2833_ _2834_ net166 VGND VGND VPWR VPWR _2836_ sky130_fd_sc_hd__o21ai_1
X_6329_ _1853_ net174 _1854_ VGND VGND VPWR VPWR _1855_ sky130_fd_sc_hd__or3_4
X_9117_ clknet_leaf_20_clk _0229_ VGND VGND VPWR VPWR pe_array\[0\].u_pe.accum_reg\[3\]
+ sky130_fd_sc_hd__dfxtp_1
XFILLER_1_559 VGND VGND VPWR VPWR sky130_fd_sc_hd__fill_1
XPHY_EDGE_ROW_95_Left_213 VGND VGND VPWR VPWR sky130_fd_sc_hd__decap_3
X_9048_ clknet_leaf_5_clk _0160_ VGND VGND VPWR VPWR net121 sky130_fd_sc_hd__dfxtp_1
XFILLER_76_305 VGND VGND VPWR VPWR sky130_fd_sc_hd__decap_3
XFILLER_103_498 VGND VGND VPWR VPWR sky130_fd_sc_hd__decap_3
XFILLER_72_522 VGND VGND VPWR VPWR sky130_fd_sc_hd__decap_8
XFILLER_17_405 VPWR VGND VPWR VGND sky130_ef_sc_hd__decap_12
XFILLER_29_265 VGND VGND VPWR VPWR sky130_fd_sc_hd__decap_6
XFILLER_83_57 VGND VGND VPWR VPWR sky130_fd_sc_hd__decap_8
XFILLER_72_533 VPWR VGND VPWR VGND sky130_ef_sc_hd__decap_12
XTAP_TAPCELL_ROW_67_1058 VGND VPWR sky130_fd_sc_hd__tapvpwrvgnd_1
XFILLER_32_419 VGND VGND VPWR VPWR sky130_fd_sc_hd__fill_1
XTAP_TAPCELL_ROW_80_1214 VGND VPWR sky130_fd_sc_hd__tapvpwrvgnd_1
XFILLER_9_615 VGND VGND VPWR VPWR sky130_fd_sc_hd__fill_1
XFILLER_13_666 VGND VGND VPWR VPWR sky130_fd_sc_hd__decap_6
XTAP_TAPCELL_ROW_30_609 VGND VPWR sky130_fd_sc_hd__tapvpwrvgnd_1
XTAP_TAPCELL_ROW_10_377 VGND VPWR sky130_fd_sc_hd__tapvpwrvgnd_1
XTAP_TAPCELL_ROW_78_1187 VGND VPWR sky130_fd_sc_hd__tapvpwrvgnd_1
XTAP_TAPCELL_ROW_91_1343 VGND VPWR sky130_fd_sc_hd__tapvpwrvgnd_1
XFILLER_79_121 VGND VGND VPWR VPWR sky130_fd_sc_hd__decap_8
XFILLER_67_305 VPWR VGND VPWR VGND sky130_ef_sc_hd__decap_12
XFILLER_95_669 VGND VGND VPWR VPWR sky130_fd_sc_hd__decap_3
XTAP_TAPCELL_ROW_38_709 VGND VPWR sky130_fd_sc_hd__tapvpwrvgnd_1
XFILLER_90_363 VGND VGND VPWR VPWR sky130_fd_sc_hd__fill_1
XTAP_TAPCELL_ROW_18_466 VGND VPWR sky130_fd_sc_hd__tapvpwrvgnd_1
XFILLER_35_279 VGND VGND VPWR VPWR sky130_fd_sc_hd__fill_1
X_5700_ net428 _1244_ VGND VGND VPWR VPWR _0226_ sky130_fd_sc_hd__nor2_1
XFILLER_50_227 VPWR VGND VPWR VGND sky130_ef_sc_hd__decap_12
X_6680_ net157 _2193_ VGND VGND VPWR VPWR _2194_ sky130_fd_sc_hd__xnor2_1
XTAP_TAPCELL_ROW_100_1450 VGND VPWR sky130_fd_sc_hd__tapvpwrvgnd_1
X_5631_ net969 net383 VGND VGND VPWR VPWR _0172_ sky130_fd_sc_hd__and2_1
XFILLER_117_502 VGND VGND VPWR VPWR sky130_fd_sc_hd__fill_2
X_5562_ net924 net395 VGND VGND VPWR VPWR _0103_ sky130_fd_sc_hd__and2_1
X_8350_ net260 _3732_ _3733_ VGND VGND VPWR VPWR _3735_ sky130_fd_sc_hd__or3_1
X_8281_ _3625_ _3665_ VGND VGND VPWR VPWR _3668_ sky130_fd_sc_hd__xor2_2
XFILLER_8_681 VPWR VGND VPWR VGND sky130_ef_sc_hd__decap_12
X_7301_ _2759_ _2760_ VGND VGND VPWR VPWR _2762_ sky130_fd_sc_hd__nor2_1
X_4513_ _4277_ _4278_ net592 pe_array\[3\].u_pe.weight_in\[2\] VGND VGND VPWR VPWR
+ _4279_ sky130_fd_sc_hd__and4bb_1
X_7232_ _2694_ _2692_ VGND VGND VPWR VPWR _2695_ sky130_fd_sc_hd__xnor2_2
X_5493_ net249 _0679_ VGND VGND VPWR VPWR _1207_ sky130_fd_sc_hd__nand2_1
Xclkbuf_leaf_7_clk clknet_3_5__leaf_clk VGND VGND VPWR VPWR clknet_leaf_7_clk sky130_fd_sc_hd__clkbuf_8
X_4444_ net507 VGND VGND VPWR VPWR _4225_ sky130_fd_sc_hd__inv_2
X_7163_ _2624_ _2625_ VGND VGND VPWR VPWR _2627_ sky130_fd_sc_hd__xnor2_1
XFILLER_112_251 VGND VGND VPWR VPWR sky130_fd_sc_hd__fill_1
X_6114_ _1599_ _1645_ VGND VGND VPWR VPWR _1646_ sky130_fd_sc_hd__xnor2_1
X_7094_ _2558_ _2557_ _2514_ _2516_ VGND VGND VPWR VPWR _2560_ sky130_fd_sc_hd__a211oi_4
XTAP_TAPCELL_ROW_111_1590 VGND VPWR sky130_fd_sc_hd__tapvpwrvgnd_1
XFILLER_85_113 VPWR VGND VPWR VGND sky130_ef_sc_hd__decap_12
X_6045_ _1525_ _1532_ _1531_ VGND VGND VPWR VPWR _1579_ sky130_fd_sc_hd__a21bo_1
XFILLER_58_316 VGND VGND VPWR VPWR sky130_fd_sc_hd__fill_2
XFILLER_37_28 VGND VGND VPWR VPWR sky130_fd_sc_hd__fill_1
XFILLER_66_382 VPWR VGND VPWR VGND sky130_ef_sc_hd__decap_12
XFILLER_26_224 VGND VGND VPWR VPWR sky130_fd_sc_hd__decap_4
X_7996_ _3381_ _3389_ VGND VGND VPWR VPWR _3390_ sky130_fd_sc_hd__nor2_1
XFILLER_53_27 VPWR VGND VPWR VGND sky130_ef_sc_hd__decap_12
XFILLER_14_419 VGND VGND VPWR VPWR sky130_fd_sc_hd__fill_1
X_6947_ net272 _2414_ _2415_ VGND VGND VPWR VPWR _2416_ sky130_fd_sc_hd__nor3_1
X_6878_ _2309_ _2347_ VGND VGND VPWR VPWR _2349_ sky130_fd_sc_hd__nand2_1
X_8617_ _3992_ _3993_ VGND VGND VPWR VPWR _3994_ sky130_fd_sc_hd__and2_1
X_5829_ _1364_ _1365_ _1366_ VGND VGND VPWR VPWR _1368_ sky130_fd_sc_hd__a21o_1
X_8548_ _3924_ _3925_ net192 VGND VGND VPWR VPWR _3927_ sky130_fd_sc_hd__a21o_1
XFILLER_6_629 VPWR VGND VPWR VGND sky130_ef_sc_hd__decap_12
XFILLER_5_128 VPWR VGND VPWR VGND sky130_ef_sc_hd__decap_12
XTAP_TAPCELL_ROW_114_1619 VGND VPWR sky130_fd_sc_hd__tapvpwrvgnd_1
XFILLER_108_568 VGND VGND VPWR VPWR sky130_fd_sc_hd__fill_1
X_8479_ _3828_ _3829_ _3858_ _3859_ VGND VGND VPWR VPWR _3860_ sky130_fd_sc_hd__o211a_1
XFILLER_89_441 VGND VGND VPWR VPWR sky130_fd_sc_hd__fill_2
XFILLER_78_46 VGND VGND VPWR VPWR sky130_fd_sc_hd__decap_3
XFILLER_77_614 VGND VGND VPWR VPWR sky130_fd_sc_hd__fill_2
XFILLER_76_113 VGND VGND VPWR VPWR sky130_fd_sc_hd__decap_6
XFILLER_1_389 VGND VGND VPWR VPWR sky130_fd_sc_hd__decap_3
XFILLER_94_34 VGND VGND VPWR VPWR sky130_fd_sc_hd__decap_8
XFILLER_49_349 VGND VGND VPWR VPWR sky130_fd_sc_hd__decap_8
XFILLER_17_246 VGND VGND VPWR VPWR sky130_fd_sc_hd__decap_3
XFILLER_17_279 VGND VGND VPWR VPWR sky130_fd_sc_hd__fill_1
XFILLER_45_588 VPWR VGND VPWR VGND sky130_ef_sc_hd__decap_12
XFILLER_72_385 VGND VGND VPWR VPWR sky130_fd_sc_hd__decap_4
XFILLER_13_441 VGND VGND VPWR VPWR sky130_fd_sc_hd__decap_6
XTAP_TAPCELL_ROW_15_436 VGND VPWR sky130_fd_sc_hd__tapvpwrvgnd_1
XTAP_TAPCELL_ROW_43_767 VGND VPWR sky130_fd_sc_hd__tapvpwrvgnd_1
XFILLER_114_527 VGND VGND VPWR VPWR sky130_fd_sc_hd__decap_4
XFILLER_5_673 VPWR VGND VPWR VGND sky130_ef_sc_hd__decap_12
XFILLER_4_194 VGND VGND VPWR VPWR sky130_fd_sc_hd__fill_2
XFILLER_4_65 VPWR VGND VPWR VGND sky130_ef_sc_hd__decap_12
XFILLER_68_625 VPWR VGND VPWR VGND sky130_ef_sc_hd__decap_12
XFILLER_68_669 VPWR VGND VPWR VGND sky130_ef_sc_hd__decap_12
X_7850_ _3245_ _3246_ net504 net320 VGND VGND VPWR VPWR _3248_ sky130_fd_sc_hd__or4bb_1
XFILLER_82_138 VGND VGND VPWR VPWR sky130_fd_sc_hd__fill_2
XFILLER_63_341 VGND VGND VPWR VPWR sky130_fd_sc_hd__fill_2
X_6801_ _2270_ _2271_ _2272_ VGND VGND VPWR VPWR _2274_ sky130_fd_sc_hd__a21oi_1
XFILLER_63_374 VPWR VGND VPWR VGND sky130_ef_sc_hd__decap_12
X_4993_ _0733_ _0734_ _0735_ VGND VGND VPWR VPWR _0737_ sky130_fd_sc_hd__a21o_1
X_7781_ net225 _3041_ VGND VGND VPWR VPWR _3200_ sky130_fd_sc_hd__nand2_2
X_6732_ pe_array\[1\].u_pe.tap_count\[3\] _2207_ net226 net432 VGND VGND VPWR VPWR
+ _2210_ sky130_fd_sc_hd__a211o_1
X_6663_ _2145_ _2148_ _2177_ VGND VGND VPWR VPWR _2178_ sky130_fd_sc_hd__o21ai_1
X_5614_ net953 net386 VGND VGND VPWR VPWR _0155_ sky130_fd_sc_hd__and2_1
X_8402_ _3783_ _3784_ _3785_ VGND VGND VPWR VPWR _3786_ sky130_fd_sc_hd__nand3_1
X_6594_ _2109_ _2110_ VGND VGND VPWR VPWR _2111_ sky130_fd_sc_hd__or2_1
XFILLER_117_321 VGND VGND VPWR VPWR sky130_fd_sc_hd__decap_4
X_5545_ net945 net393 VGND VGND VPWR VPWR _0086_ sky130_fd_sc_hd__and2_1
X_8333_ _3718_ _3717_ _3716_ VGND VGND VPWR VPWR _3719_ sky130_fd_sc_hd__and3_1
XFILLER_117_365 VGND VGND VPWR VPWR sky130_fd_sc_hd__decap_8
XFILLER_105_505 VGND VGND VPWR VPWR sky130_fd_sc_hd__decap_8
X_8264_ _3649_ _3650_ _3587_ _3590_ VGND VGND VPWR VPWR _3652_ sky130_fd_sc_hd__o211a_1
X_5476_ net993 net251 _1198_ net371 VGND VGND VPWR VPWR _0048_ sky130_fd_sc_hd__o211a_1
X_8195_ net462 net679 net311 net308 VGND VGND VPWR VPWR _3584_ sky130_fd_sc_hd__and4_1
X_7215_ _2675_ _2676_ _2677_ VGND VGND VPWR VPWR _2678_ sky130_fd_sc_hd__nand3_1
Xfanout402 net405 VGND VGND VPWR VPWR net402 sky130_fd_sc_hd__clkbuf_2
Xfanout413 _4225_ VGND VGND VPWR VPWR net413 sky130_fd_sc_hd__buf_2
X_7146_ _2610_ VGND VGND VPWR VPWR _2611_ sky130_fd_sc_hd__inv_2
Xfanout457 net458 VGND VGND VPWR VPWR net457 sky130_fd_sc_hd__buf_6
Xfanout435 net436 VGND VGND VPWR VPWR net435 sky130_fd_sc_hd__buf_6
Xfanout446 net448 VGND VGND VPWR VPWR net446 sky130_fd_sc_hd__buf_2
Xfanout424 net426 VGND VGND VPWR VPWR net424 sky130_fd_sc_hd__clkbuf_4
XFILLER_48_27 VGND VGND VPWR VPWR sky130_fd_sc_hd__fill_1
Xfanout468 net7 VGND VGND VPWR VPWR net468 sky130_fd_sc_hd__clkbuf_4
XFILLER_58_146 VGND VGND VPWR VPWR sky130_fd_sc_hd__decap_8
Xfanout479 net482 VGND VGND VPWR VPWR net479 sky130_fd_sc_hd__buf_2
X_7077_ _2499_ _2501_ VGND VGND VPWR VPWR _2543_ sky130_fd_sc_hd__xor2_4
XFILLER_86_477 VGND VGND VPWR VPWR sky130_fd_sc_hd__fill_2
XFILLER_74_639 VGND VGND VPWR VPWR sky130_fd_sc_hd__decap_4
X_6028_ _1560_ _1561_ VGND VGND VPWR VPWR _1562_ sky130_fd_sc_hd__xor2_1
XFILLER_58_168 VGND VGND VPWR VPWR sky130_fd_sc_hd__fill_1
XFILLER_64_15 VPWR VGND VPWR VGND sky130_ef_sc_hd__decap_12
XFILLER_39_393 VGND VGND VPWR VPWR sky130_fd_sc_hd__decap_8
XFILLER_54_352 VGND VGND VPWR VPWR sky130_fd_sc_hd__decap_3
XFILLER_81_182 VGND VGND VPWR VPWR sky130_fd_sc_hd__decap_3
X_7979_ net478 net317 _3371_ VGND VGND VPWR VPWR _3373_ sky130_fd_sc_hd__and3_1
XTAP_TAPCELL_ROW_64_1017 VGND VPWR sky130_fd_sc_hd__tapvpwrvgnd_1
XFILLER_14_216 VPWR VGND VPWR VGND sky130_ef_sc_hd__decap_12
XFILLER_42_514 VGND VGND VPWR VPWR sky130_fd_sc_hd__fill_2
XFILLER_10_433 VPWR VGND VPWR VGND sky130_ef_sc_hd__decap_12
XFILLER_22_293 VPWR VGND VPWR VGND sky130_ef_sc_hd__decap_12
XTAP_TAPCELL_ROW_40_737 VGND VPWR sky130_fd_sc_hd__tapvpwrvgnd_1
XFILLER_108_321 VPWR VGND VPWR VGND sky130_ef_sc_hd__decap_12
XTAP_TAPCELL_ROW_20_494 VGND VPWR sky130_fd_sc_hd__tapvpwrvgnd_1
XTAP_TAPCELL_ROW_75_1157 VGND VPWR sky130_fd_sc_hd__tapvpwrvgnd_1
XFILLER_2_643 VGND VGND VPWR VPWR sky130_fd_sc_hd__fill_1
XFILLER_49_113 VGND VGND VPWR VPWR sky130_fd_sc_hd__decap_3
XFILLER_49_135 VPWR VGND VPWR VGND sky130_ef_sc_hd__decap_12
XFILLER_65_617 VPWR VGND VPWR VGND sky130_ef_sc_hd__decap_12
XTAP_TAPCELL_ROW_48_826 VGND VPWR sky130_fd_sc_hd__tapvpwrvgnd_1
XFILLER_92_458 VGND VGND VPWR VPWR sky130_fd_sc_hd__fill_2
XFILLER_92_447 VGND VGND VPWR VPWR sky130_fd_sc_hd__fill_1
XFILLER_18_533 VGND VGND VPWR VPWR sky130_fd_sc_hd__decap_4
XTAP_TAPCELL_ROW_86_1286 VGND VPWR sky130_fd_sc_hd__tapvpwrvgnd_1
XFILLER_60_344 VGND VGND VPWR VPWR sky130_fd_sc_hd__decap_4
XTAP_TAPCELL_ROW_28_594 VGND VPWR sky130_fd_sc_hd__tapvpwrvgnd_1
Xclkload34 clknet_leaf_3_clk VGND VGND VPWR VPWR clkload34/Y sky130_fd_sc_hd__inv_12
Xclkload23 clknet_leaf_46_clk VGND VGND VPWR VPWR clkload23/Y sky130_fd_sc_hd__inv_8
Xclkload12 clknet_leaf_61_clk VGND VGND VPWR VPWR clkload12/Y sky130_fd_sc_hd__inv_6
XPHY_EDGE_ROW_41_Left_159 VGND VGND VPWR VPWR sky130_fd_sc_hd__decap_3
Xclkload56 clknet_leaf_26_clk VGND VGND VPWR VPWR clkload56/Y sky130_fd_sc_hd__inv_8
Xclkload45 clknet_leaf_20_clk VGND VGND VPWR VPWR clkload45/Y sky130_fd_sc_hd__bufinv_16
X_5330_ _1061_ _1062_ VGND VGND VPWR VPWR _1063_ sky130_fd_sc_hd__or2_4
X_5261_ net745 _0961_ _0959_ VGND VGND VPWR VPWR _0996_ sky130_fd_sc_hd__a21oi_1
XFILLER_114_357 VGND VGND VPWR VPWR sky130_fd_sc_hd__decap_6
X_7000_ _2466_ _2465_ _2459_ VGND VGND VPWR VPWR _2468_ sky130_fd_sc_hd__a21o_1
X_5192_ _0925_ _0926_ net285 VGND VGND VPWR VPWR _0929_ sky130_fd_sc_hd__o21ai_1
XFILLER_68_433 VGND VGND VPWR VPWR sky130_fd_sc_hd__decap_6
XFILLER_83_414 VGND VGND VPWR VPWR sky130_fd_sc_hd__decap_4
XFILLER_68_477 VGND VGND VPWR VPWR sky130_fd_sc_hd__fill_2
XFILLER_55_105 VGND VGND VPWR VPWR sky130_fd_sc_hd__decap_6
X_8951_ clknet_leaf_64_clk _0063_ VGND VGND VPWR VPWR pe_accum\[3\]\[19\] sky130_fd_sc_hd__dfxtp_1
XPHY_EDGE_ROW_50_Left_168 VGND VGND VPWR VPWR sky130_fd_sc_hd__decap_3
X_7902_ net506 net312 VGND VGND VPWR VPWR _3298_ sky130_fd_sc_hd__nand2_1
XFILLER_55_138 VGND VGND VPWR VPWR sky130_fd_sc_hd__decap_3
X_8882_ net213 _4155_ VGND VGND VPWR VPWR _4222_ sky130_fd_sc_hd__nand2_2
XFILLER_71_609 VGND VGND VPWR VPWR sky130_fd_sc_hd__decap_6
XFILLER_36_363 VGND VGND VPWR VPWR sky130_fd_sc_hd__fill_1
X_7833_ _3230_ _3231_ VGND VGND VPWR VPWR _3232_ sky130_fd_sc_hd__or2_1
XFILLER_91_491 VGND VGND VPWR VPWR sky130_fd_sc_hd__fill_2
XFILLER_91_480 VGND VGND VPWR VPWR sky130_fd_sc_hd__fill_1
XFILLER_24_514 VGND VGND VPWR VPWR sky130_fd_sc_hd__fill_2
X_7764_ net979 net221 _3191_ net373 VGND VGND VPWR VPWR _0343_ sky130_fd_sc_hd__o211a_1
X_6715_ net912 net233 _2089_ net243 VGND VGND VPWR VPWR _0285_ sky130_fd_sc_hd__o2bb2ai_1
X_4976_ net298 net435 pe_array\[3\].u_pe.accum_reg\[15\] VGND VGND VPWR VPWR _0720_
+ sky130_fd_sc_hd__a21oi_1
X_7695_ net649 _3141_ VGND VGND VPWR VPWR _3142_ sky130_fd_sc_hd__xnor2_1
X_6646_ _2125_ _2122_ _2156_ _2155_ VGND VGND VPWR VPWR _2161_ sky130_fd_sc_hd__a31o_1
Xclkload6 clknet_3_7__leaf_clk VGND VGND VPWR VPWR clkload6/Y sky130_fd_sc_hd__inv_8
X_6577_ _2007_ _2035_ _2033_ VGND VGND VPWR VPWR _2094_ sky130_fd_sc_hd__a21oi_1
XFILLER_105_302 VGND VGND VPWR VPWR sky130_fd_sc_hd__decap_6
X_8316_ _3701_ VGND VGND VPWR VPWR _3702_ sky130_fd_sc_hd__inv_2
X_5528_ net952 net251 _1224_ net368 VGND VGND VPWR VPWR _0074_ sky130_fd_sc_hd__o211a_1
X_9296_ clknet_leaf_9_clk _0408_ VGND VGND VPWR VPWR pe_accum\[2\]\[6\] sky130_fd_sc_hd__dfxtp_1
XFILLER_105_335 VGND VGND VPWR VPWR sky130_fd_sc_hd__fill_1
XFILLER_3_429 VPWR VGND VPWR VGND sky130_ef_sc_hd__decap_12
X_8247_ pe_array\[2\].u_pe.accum_reg\[13\] net439 net313 VGND VGND VPWR VPWR _3635_
+ sky130_fd_sc_hd__and3_4
X_5459_ net181 _1186_ VGND VGND VPWR VPWR _1187_ sky130_fd_sc_hd__xnor2_1
Xfanout210 net211 VGND VGND VPWR VPWR net210 sky130_fd_sc_hd__buf_1
X_8178_ _3522_ _3519_ _3565_ _3567_ VGND VGND VPWR VPWR _3568_ sky130_fd_sc_hd__a211oi_4
Xfanout232 _2203_ VGND VGND VPWR VPWR net232 sky130_fd_sc_hd__clkbuf_2
Xfanout221 net223 VGND VGND VPWR VPWR net221 sky130_fd_sc_hd__buf_2
XFILLER_113_390 VGND VGND VPWR VPWR sky130_fd_sc_hd__fill_2
XFILLER_101_530 VGND VGND VPWR VPWR sky130_fd_sc_hd__fill_1
Xfanout243 net245 VGND VGND VPWR VPWR net243 sky130_fd_sc_hd__buf_2
Xfanout265 _3465_ VGND VGND VPWR VPWR net265 sky130_fd_sc_hd__buf_8
Xfanout254 _4249_ VGND VGND VPWR VPWR net254 sky130_fd_sc_hd__buf_2
X_7129_ net193 _2591_ _2593_ VGND VGND VPWR VPWR _2594_ sky130_fd_sc_hd__or3b_4
Xfanout276 net707 VGND VGND VPWR VPWR net276 sky130_fd_sc_hd__buf_2
XTAP_TAPCELL_ROW_70_1098 VGND VPWR sky130_fd_sc_hd__tapvpwrvgnd_1
Xfanout298 pe_array\[3\].u_pe.weight_in\[3\] VGND VGND VPWR VPWR net298 sky130_fd_sc_hd__dlymetal6s2s_1
Xfanout287 net288 VGND VGND VPWR VPWR net287 sky130_fd_sc_hd__buf_8
XFILLER_46_127 VPWR VGND VPWR VGND sky130_ef_sc_hd__decap_12
XFILLER_15_503 VGND VGND VPWR VPWR sky130_fd_sc_hd__fill_1
XFILLER_55_683 VGND VGND VPWR VPWR sky130_fd_sc_hd__fill_1
XFILLER_54_171 VGND VGND VPWR VPWR sky130_fd_sc_hd__decap_6
XFILLER_27_385 VGND VGND VPWR VPWR sky130_fd_sc_hd__fill_1
XFILLER_15_547 VGND VGND VPWR VPWR sky130_fd_sc_hd__decap_6
XTAP_TAPCELL_ROW_53_884 VGND VPWR sky130_fd_sc_hd__tapvpwrvgnd_1
XFILLER_24_40 VGND VGND VPWR VPWR sky130_fd_sc_hd__fill_1
XTAP_TAPCELL_ROW_25_553 VGND VPWR sky130_fd_sc_hd__tapvpwrvgnd_1
XTAP_TAPCELL_ROW_53_895 VGND VPWR sky130_fd_sc_hd__tapvpwrvgnd_1
XFILLER_24_62 VGND VGND VPWR VPWR sky130_fd_sc_hd__decap_8
XFILLER_10_241 VGND VGND VPWR VPWR sky130_fd_sc_hd__decap_8
XFILLER_109_641 VPWR VGND VPWR VGND sky130_ef_sc_hd__decap_12
XFILLER_40_61 VPWR VGND VPWR VGND sky130_ef_sc_hd__decap_12
XFILLER_108_173 VGND VGND VPWR VPWR sky130_fd_sc_hd__fill_2
XFILLER_97_517 VPWR VGND VPWR VGND sky130_ef_sc_hd__decap_12
XFILLER_111_349 VPWR VGND VPWR VGND sky130_ef_sc_hd__decap_12
XFILLER_77_241 VGND VGND VPWR VPWR sky130_fd_sc_hd__fill_2
XFILLER_49_81 VGND VGND VPWR VPWR sky130_fd_sc_hd__decap_6
XTAP_TAPCELL_ROW_88_1315 VGND VPWR sky130_fd_sc_hd__tapvpwrvgnd_1
XTAP_TAPCELL_ROW_88_1304 VGND VPWR sky130_fd_sc_hd__tapvpwrvgnd_1
XFILLER_65_403 VPWR VGND VPWR VGND sky130_ef_sc_hd__decap_12
XFILLER_1_55 VGND VGND VPWR VPWR sky130_fd_sc_hd__fill_1
XFILLER_92_266 VGND VGND VPWR VPWR sky130_fd_sc_hd__decap_4
XFILLER_18_341 VPWR VGND VPWR VGND sky130_ef_sc_hd__decap_12
XFILLER_92_288 VPWR VGND VPWR VGND sky130_ef_sc_hd__decap_12
XFILLER_73_491 VPWR VGND VPWR VGND sky130_ef_sc_hd__decap_12
X_4830_ _0575_ _0576_ net207 VGND VGND VPWR VPWR _0578_ sky130_fd_sc_hd__a21o_1
X_4761_ net469 net291 net289 net476 VGND VGND VPWR VPWR _0510_ sky130_fd_sc_hd__a22o_1
X_6500_ net202 _1992_ _1991_ VGND VGND VPWR VPWR _2020_ sky130_fd_sc_hd__a21o_1
XTAP_TAPCELL_ROW_99_1444 VGND VPWR sky130_fd_sc_hd__tapvpwrvgnd_1
X_7480_ net271 _2932_ _2933_ VGND VGND VPWR VPWR _2934_ sky130_fd_sc_hd__nor3_1
X_4692_ pe_array\[3\].u_pe.accum_reg\[8\] net300 net471 VGND VGND VPWR VPWR _0443_
+ sky130_fd_sc_hd__nand3_2
X_6431_ pe_array\[0\].u_pe.accum_reg\[23\] net456 net359 VGND VGND VPWR VPWR _1953_
+ sky130_fd_sc_hd__and3_1
X_9150_ clknet_leaf_21_clk _0262_ VGND VGND VPWR VPWR pe_accum\[0\]\[4\] sky130_fd_sc_hd__dfxtp_1
X_6362_ _1886_ net158 VGND VGND VPWR VPWR _1887_ sky130_fd_sc_hd__xnor2_2
X_8101_ net401 pe_array\[2\].u_pe.accum_reg\[9\] net219 _3492_ VGND VGND VPWR VPWR
+ _3493_ sky130_fd_sc_hd__o2bb2a_1
X_5313_ net208 _1045_ VGND VGND VPWR VPWR _1046_ sky130_fd_sc_hd__and2_1
X_6293_ _1817_ _1818_ net203 VGND VGND VPWR VPWR _1820_ sky130_fd_sc_hd__a21o_1
X_9081_ clknet_leaf_61_clk _0193_ VGND VGND VPWR VPWR net30 sky130_fd_sc_hd__dfxtp_1
X_8032_ pe_array\[2\].u_pe.accum_reg\[8\] net470 net317 VGND VGND VPWR VPWR _3425_
+ sky130_fd_sc_hd__and3_1
X_5244_ net415 _0979_ VGND VGND VPWR VPWR _0035_ sky130_fd_sc_hd__nor2_1
X_5175_ net183 _0912_ VGND VGND VPWR VPWR _0913_ sky130_fd_sc_hd__xnor2_1
XFILLER_29_606 VGND VGND VPWR VPWR sky130_fd_sc_hd__fill_1
XFILLER_56_436 VGND VGND VPWR VPWR sky130_fd_sc_hd__decap_6
XFILLER_29_639 VGND VGND VPWR VPWR sky130_fd_sc_hd__fill_2
X_8934_ clknet_leaf_52_clk _0046_ VGND VGND VPWR VPWR pe_accum\[3\]\[2\] sky130_fd_sc_hd__dfxtp_1
XFILLER_37_650 VGND VGND VPWR VPWR sky130_fd_sc_hd__fill_1
XTAP_TAPCELL_ROW_108_1551 VGND VPWR sky130_fd_sc_hd__tapvpwrvgnd_1
X_8865_ net925 net211 _4213_ net383 VGND VGND VPWR VPWR _0422_ sky130_fd_sc_hd__o211a_1
XFILLER_37_694 VGND VGND VPWR VPWR sky130_fd_sc_hd__fill_2
XFILLER_45_39 VPWR VGND VPWR VGND sky130_ef_sc_hd__decap_12
X_7816_ pe_array\[2\].u_pe.accum_reg\[0\] net513 pe_array\[2\].u_pe.weight_in\[0\]
+ VGND VGND VPWR VPWR _3217_ sky130_fd_sc_hd__and3_1
XFILLER_24_333 VGND VGND VPWR VPWR sky130_fd_sc_hd__decap_6
XFILLER_24_344 VGND VGND VPWR VPWR sky130_fd_sc_hd__fill_1
XFILLER_36_193 VGND VGND VPWR VPWR sky130_fd_sc_hd__decap_3
XFILLER_101_67 VGND VGND VPWR VPWR sky130_fd_sc_hd__fill_2
X_8796_ net163 _4166_ VGND VGND VPWR VPWR _4167_ sky130_fd_sc_hd__xnor2_1
XFILLER_12_517 VGND VGND VPWR VPWR sky130_fd_sc_hd__fill_1
XFILLER_24_355 VGND VGND VPWR VPWR sky130_fd_sc_hd__fill_1
XFILLER_51_196 VPWR VGND VPWR VGND sky130_ef_sc_hd__decap_12
XTAP_TAPCELL_ROW_22_512 VGND VPWR sky130_fd_sc_hd__tapvpwrvgnd_1
XTAP_TAPCELL_ROW_22_523 VGND VPWR sky130_fd_sc_hd__tapvpwrvgnd_1
X_7747_ net224 _2485_ VGND VGND VPWR VPWR _3183_ sky130_fd_sc_hd__nand2_1
X_4959_ _0652_ net687 _0664_ VGND VGND VPWR VPWR _0704_ sky130_fd_sc_hd__a21bo_1
XTAP_TAPCELL_ROW_50_854 VGND VPWR sky130_fd_sc_hd__tapvpwrvgnd_1
X_7678_ net170 _3093_ _3092_ VGND VGND VPWR VPWR _3126_ sky130_fd_sc_hd__a21oi_1
X_6629_ _2109_ _2112_ _2144_ VGND VGND VPWR VPWR _2145_ sky130_fd_sc_hd__o21a_1
XFILLER_106_611 VGND VGND VPWR VPWR sky130_fd_sc_hd__decap_4
XFILLER_105_143 VGND VGND VPWR VPWR sky130_fd_sc_hd__fill_1
X_9279_ clknet_3_5__leaf_clk _0391_ VGND VGND VPWR VPWR pe_array\[2\].u_pe.accum_reg\[21\]
+ sky130_fd_sc_hd__dfxtp_1
XTAP_TAPCELL_ROW_72_1116 VGND VPWR sky130_fd_sc_hd__tapvpwrvgnd_1
XFILLER_79_539 VGND VGND VPWR VPWR sky130_fd_sc_hd__fill_1
XFILLER_101_393 VGND VGND VPWR VPWR sky130_fd_sc_hd__decap_4
XFILLER_101_382 VGND VGND VPWR VPWR sky130_fd_sc_hd__decap_8
XFILLER_87_583 VPWR VGND VPWR VGND sky130_ef_sc_hd__decap_12
XFILLER_74_211 VGND VGND VPWR VPWR sky130_fd_sc_hd__decap_8
XFILLER_59_274 VGND VGND VPWR VPWR sky130_fd_sc_hd__fill_2
XFILLER_47_447 VGND VGND VPWR VPWR sky130_fd_sc_hd__fill_1
XTAP_TAPCELL_ROW_58_954 VGND VPWR sky130_fd_sc_hd__tapvpwrvgnd_1
XTAP_TAPCELL_ROW_2_281 VGND VPWR sky130_fd_sc_hd__tapvpwrvgnd_1
XFILLER_27_160 VGND VGND VPWR VPWR sky130_fd_sc_hd__fill_1
XFILLER_28_683 VGND VGND VPWR VPWR sky130_fd_sc_hd__fill_1
XPHY_EDGE_ROW_106_Left_224 VGND VGND VPWR VPWR sky130_fd_sc_hd__decap_3
XTAP_TAPCELL_ROW_83_1245 VGND VPWR sky130_fd_sc_hd__tapvpwrvgnd_1
XFILLER_30_303 VGND VGND VPWR VPWR sky130_fd_sc_hd__fill_2
XFILLER_35_83 VGND VGND VPWR VPWR sky130_fd_sc_hd__decap_3
XFILLER_35_94 VGND VGND VPWR VPWR sky130_fd_sc_hd__fill_2
XFILLER_42_141 VGND VGND VPWR VPWR sky130_fd_sc_hd__decap_4
XFILLER_11_561 VGND VGND VPWR VPWR sky130_fd_sc_hd__decap_6
XFILLER_7_532 VGND VGND VPWR VPWR sky130_fd_sc_hd__fill_1
XFILLER_51_93 VGND VGND VPWR VPWR sky130_fd_sc_hd__decap_8
XFILLER_7_576 VGND VGND VPWR VPWR sky130_fd_sc_hd__fill_2
XFILLER_7_598 VPWR VGND VPWR VGND sky130_ef_sc_hd__decap_12
XPHY_EDGE_ROW_115_Left_233 VGND VGND VPWR VPWR sky130_fd_sc_hd__decap_3
XFILLER_112_625 VPWR VGND VPWR VGND sky130_ef_sc_hd__decap_12
XFILLER_97_314 VPWR VGND VPWR VGND sky130_ef_sc_hd__decap_12
XTAP_TAPCELL_ROW_94_1385 VGND VPWR sky130_fd_sc_hd__tapvpwrvgnd_1
XFILLER_112_669 VPWR VGND VPWR VGND sky130_ef_sc_hd__decap_12
XFILLER_111_135 VGND VGND VPWR VPWR sky130_fd_sc_hd__decap_3
XFILLER_111_113 VGND VGND VPWR VPWR sky130_fd_sc_hd__fill_2
XFILLER_18_3 VPWR VGND VPWR VGND sky130_ef_sc_hd__decap_12
X_6980_ _2446_ _2447_ VGND VGND VPWR VPWR _2448_ sky130_fd_sc_hd__nor2_1
XFILLER_80_225 VGND VGND VPWR VPWR sky130_fd_sc_hd__decap_4
X_5931_ _1433_ _1436_ _1434_ VGND VGND VPWR VPWR _1467_ sky130_fd_sc_hd__o21ba_1
XFILLER_53_439 VGND VGND VPWR VPWR sky130_fd_sc_hd__decap_4
XFILLER_53_428 VGND VGND VPWR VPWR sky130_fd_sc_hd__fill_1
XFILLER_19_661 VGND VGND VPWR VPWR sky130_fd_sc_hd__fill_2
XFILLER_19_694 VGND VGND VPWR VPWR sky130_fd_sc_hd__fill_2
X_8650_ _3994_ _3996_ _4024_ VGND VGND VPWR VPWR _4026_ sky130_fd_sc_hd__nor3_1
X_5862_ _1397_ _1398_ VGND VGND VPWR VPWR _1400_ sky130_fd_sc_hd__xor2_1
X_8581_ _3955_ _3956_ _3957_ VGND VGND VPWR VPWR _3959_ sky130_fd_sc_hd__a21oi_1
X_5793_ _1328_ _1329_ _1330_ VGND VGND VPWR VPWR _1333_ sky130_fd_sc_hd__a21o_1
X_7601_ net649 _3050_ VGND VGND VPWR VPWR _3051_ sky130_fd_sc_hd__nor2_1
X_4813_ _0559_ _0560_ VGND VGND VPWR VPWR _0561_ sky130_fd_sc_hd__xor2_1
XTAP_TAPCELL_ROW_103_1492 VGND VPWR sky130_fd_sc_hd__tapvpwrvgnd_1
X_7532_ _2982_ _2983_ VGND VGND VPWR VPWR _2985_ sky130_fd_sc_hd__xnor2_1
X_4744_ _0479_ _0492_ _0493_ VGND VGND VPWR VPWR _0494_ sky130_fd_sc_hd__nand3_2
X_4675_ _4399_ _4400_ _4401_ VGND VGND VPWR VPWR _4436_ sky130_fd_sc_hd__o21ba_1
X_9202_ clknet_leaf_46_clk _0314_ VGND VGND VPWR VPWR pe_array\[1\].u_pe.accum_reg\[20\]
+ sky130_fd_sc_hd__dfxtp_1
X_7463_ _2700_ _2891_ _2890_ VGND VGND VPWR VPWR _2918_ sky130_fd_sc_hd__a21oi_1
X_6414_ _1936_ _1935_ VGND VGND VPWR VPWR _1937_ sky130_fd_sc_hd__and2b_1
X_7394_ net447 net338 pe_array\[1\].u_pe.accum_reg\[20\] VGND VGND VPWR VPWR _2851_
+ sky130_fd_sc_hd__a21oi_1
X_9133_ clknet_3_7__leaf_clk _0245_ VGND VGND VPWR VPWR pe_array\[0\].u_pe.accum_reg\[19\]
+ sky130_fd_sc_hd__dfxtp_1
X_6345_ net431 _1870_ VGND VGND VPWR VPWR _0245_ sky130_fd_sc_hd__nor2_1
XFILLER_115_485 VPWR VGND VPWR VGND sky130_ef_sc_hd__decap_12
X_9064_ clknet_leaf_7_clk _0176_ VGND VGND VPWR VPWR net139 sky130_fd_sc_hd__dfxtp_1
X_6276_ _1802_ _1803_ _1773_ VGND VGND VPWR VPWR _1804_ sky130_fd_sc_hd__or3b_4
XFILLER_103_669 VGND VGND VPWR VPWR sky130_fd_sc_hd__decap_3
X_8015_ net493 net485 net310 net309 VGND VGND VPWR VPWR _3408_ sky130_fd_sc_hd__and4_1
X_5227_ net745 _0931_ _0930_ VGND VGND VPWR VPWR _0963_ sky130_fd_sc_hd__a21bo_1
XFILLER_102_168 VGND VGND VPWR VPWR sky130_fd_sc_hd__decap_8
XFILLER_102_157 VGND VGND VPWR VPWR sky130_fd_sc_hd__decap_6
XFILLER_84_531 VGND VGND VPWR VPWR sky130_fd_sc_hd__fill_1
XFILLER_56_27 VGND VGND VPWR VPWR sky130_fd_sc_hd__fill_1
X_5158_ _0839_ _0840_ _0868_ _0896_ _0867_ VGND VGND VPWR VPWR _0897_ sky130_fd_sc_hd__a311o_1
X_5089_ net183 _0798_ _0797_ VGND VGND VPWR VPWR _0830_ sky130_fd_sc_hd__o21bai_1
XTAP_TAPCELL_ROW_55_913 VGND VPWR sky130_fd_sc_hd__tapvpwrvgnd_1
X_8917_ clknet_leaf_66_clk _0029_ VGND VGND VPWR VPWR pe_array\[3\].u_pe.accum_reg\[17\]
+ sky130_fd_sc_hd__dfxtp_1
XFILLER_112_77 VGND VGND VPWR VPWR sky130_fd_sc_hd__decap_6
XFILLER_71_236 VPWR VGND VPWR VGND sky130_ef_sc_hd__decap_12
XFILLER_71_225 VGND VGND VPWR VPWR sky130_fd_sc_hd__decap_4
X_8848_ net209 _3622_ VGND VGND VPWR VPWR _4205_ sky130_fd_sc_hd__nand2_1
XFILLER_24_141 VPWR VGND VPWR VGND sky130_ef_sc_hd__decap_12
X_8779_ _4117_ _4149_ VGND VGND VPWR VPWR _4151_ sky130_fd_sc_hd__nand2_1
XFILLER_52_494 VGND VGND VPWR VPWR sky130_fd_sc_hd__fill_1
XFILLER_12_325 VGND VGND VPWR VPWR sky130_fd_sc_hd__fill_1
XTAP_TAPCELL_ROW_35_670 VGND VPWR sky130_fd_sc_hd__tapvpwrvgnd_1
XFILLER_21_52 VGND VGND VPWR VPWR sky130_fd_sc_hd__decap_4
XFILLER_21_63 VPWR VGND VPWR VGND sky130_ef_sc_hd__decap_12
XFILLER_106_441 VPWR VGND VPWR VGND sky130_ef_sc_hd__decap_12
XFILLER_106_474 VGND VGND VPWR VPWR sky130_fd_sc_hd__fill_2
XTAP_TAPCELL_ROW_7_340 VGND VPWR sky130_fd_sc_hd__tapvpwrvgnd_1
XFILLER_87_380 VGND VGND VPWR VPWR sky130_fd_sc_hd__fill_1
XFILLER_75_542 VPWR VGND VPWR VGND sky130_ef_sc_hd__decap_12
XFILLER_47_255 VPWR VGND VPWR VGND sky130_ef_sc_hd__decap_12
XFILLER_90_545 VPWR VGND VPWR VGND sky130_ef_sc_hd__decap_12
XFILLER_28_491 VGND VGND VPWR VPWR sky130_fd_sc_hd__fill_1
XFILLER_62_269 VGND VGND VPWR VPWR sky130_fd_sc_hd__fill_1
XFILLER_31_612 VGND VGND VPWR VPWR sky130_fd_sc_hd__decap_4
XFILLER_30_177 VGND VGND VPWR VPWR sky130_fd_sc_hd__decap_4
XFILLER_30_188 VGND VGND VPWR VPWR sky130_fd_sc_hd__decap_8
XFILLER_31_689 VGND VGND VPWR VPWR sky130_fd_sc_hd__fill_2
XTAP_TAPCELL_ROW_96_1403 VGND VPWR sky130_fd_sc_hd__tapvpwrvgnd_1
XFILLER_11_391 VGND VGND VPWR VPWR sky130_fd_sc_hd__fill_1
X_4460_ net422 _4240_ VGND VGND VPWR VPWR _4241_ sky130_fd_sc_hd__nor2_2
XFILLER_7_384 VGND VGND VPWR VPWR sky130_fd_sc_hd__decap_8
XFILLER_116_249 VGND VGND VPWR VPWR sky130_fd_sc_hd__decap_3
XFILLER_112_400 VGND VGND VPWR VPWR sky130_fd_sc_hd__decap_3
XFILLER_98_623 VGND VGND VPWR VPWR sky130_fd_sc_hd__decap_6
X_6130_ _1648_ _1660_ _1661_ VGND VGND VPWR VPWR _1662_ sky130_fd_sc_hd__and3_1
XFILLER_98_645 VGND VGND VPWR VPWR sky130_fd_sc_hd__decap_4
XFILLER_97_111 VGND VGND VPWR VPWR sky130_fd_sc_hd__fill_1
XFILLER_112_477 VGND VGND VPWR VPWR sky130_fd_sc_hd__decap_4
XFILLER_100_606 VGND VGND VPWR VPWR sky130_fd_sc_hd__decap_8
X_6061_ net411 pe_array\[0\].u_pe.accum_reg\[11\] net240 _1594_ VGND VGND VPWR VPWR
+ _1595_ sky130_fd_sc_hd__o2bb2a_4
XFILLER_58_509 VGND VGND VPWR VPWR sky130_fd_sc_hd__decap_4
X_5012_ _0721_ _0722_ _0753_ _0754_ VGND VGND VPWR VPWR _0755_ sky130_fd_sc_hd__o211a_1
XFILLER_53_203 VGND VGND VPWR VPWR sky130_fd_sc_hd__decap_6
XTAP_TAPCELL_ROW_105_1510 VGND VPWR sky130_fd_sc_hd__tapvpwrvgnd_1
XFILLER_81_545 VGND VGND VPWR VPWR sky130_fd_sc_hd__decap_8
XFILLER_53_225 VGND VGND VPWR VPWR sky130_fd_sc_hd__decap_8
X_6963_ _2429_ _2430_ _2396_ VGND VGND VPWR VPWR _2432_ sky130_fd_sc_hd__a21oi_1
X_8702_ _4065_ _4075_ VGND VGND VPWR VPWR _4076_ sky130_fd_sc_hd__nor2_1
X_5914_ _1447_ _1448_ _1449_ VGND VGND VPWR VPWR _1451_ sky130_fd_sc_hd__a21o_1
XFILLER_53_258 VGND VGND VPWR VPWR sky130_fd_sc_hd__decap_8
XFILLER_41_409 VGND VGND VPWR VPWR sky130_fd_sc_hd__fill_2
X_6894_ net472 net464 net336 net334 VGND VGND VPWR VPWR _2364_ sky130_fd_sc_hd__and4_1
X_8633_ _4009_ _4008_ VGND VGND VPWR VPWR _4010_ sky130_fd_sc_hd__nand2_2
X_5845_ net493 net490 net348 net346 VGND VGND VPWR VPWR _1383_ sky130_fd_sc_hd__and4_1
XFILLER_22_634 VGND VGND VPWR VPWR sky130_fd_sc_hd__decap_8
XFILLER_22_645 VPWR VGND VPWR VGND sky130_ef_sc_hd__decap_12
XTAP_TAPCELL_ROW_32_640 VGND VPWR sky130_fd_sc_hd__tapvpwrvgnd_1
XFILLER_42_29 VPWR VGND VPWR VGND sky130_ef_sc_hd__decap_12
X_8564_ _3910_ _3941_ VGND VGND VPWR VPWR _3943_ sky130_fd_sc_hd__xnor2_1
X_5776_ net506 net348 VGND VGND VPWR VPWR _1316_ sky130_fd_sc_hd__nand2_1
XTAP_TAPCELL_ROW_60_971 VGND VPWR sky130_fd_sc_hd__tapvpwrvgnd_1
X_8495_ _3873_ _3874_ VGND VGND VPWR VPWR _3876_ sky130_fd_sc_hd__xnor2_1
X_7515_ net271 _2965_ _2966_ VGND VGND VPWR VPWR _2968_ sky130_fd_sc_hd__or3_1
X_4727_ _0470_ _0475_ VGND VGND VPWR VPWR _0477_ sky130_fd_sc_hd__xor2_1
X_7446_ _2900_ _2901_ VGND VGND VPWR VPWR _2902_ sky130_fd_sc_hd__xor2_1
X_4658_ _4379_ _4377_ _4417_ _4419_ VGND VGND VPWR VPWR _4420_ sky130_fd_sc_hd__a211o_1
XTAP_TAPCELL_ROW_116_1650 VGND VPWR sky130_fd_sc_hd__tapvpwrvgnd_1
X_9116_ clknet_leaf_20_clk _0228_ VGND VGND VPWR VPWR pe_array\[0\].u_pe.accum_reg\[2\]
+ sky130_fd_sc_hd__dfxtp_1
XFILLER_89_623 VGND VGND VPWR VPWR sky130_fd_sc_hd__decap_3
XFILLER_89_601 VGND VGND VPWR VPWR sky130_fd_sc_hd__fill_1
X_7377_ net166 _2833_ _2834_ VGND VGND VPWR VPWR _2835_ sky130_fd_sc_hd__or3_4
X_4589_ net405 pe_array\[3\].u_pe.accum_reg\[5\] net258 _4352_ VGND VGND VPWR VPWR
+ _4353_ sky130_fd_sc_hd__o2bb2a_1
XFILLER_115_293 VGND VGND VPWR VPWR sky130_fd_sc_hd__fill_1
XFILLER_107_55 VGND VGND VPWR VPWR sky130_fd_sc_hd__fill_1
X_6328_ _1850_ _1851_ net659 VGND VGND VPWR VPWR _1854_ sky130_fd_sc_hd__a21oi_1
XFILLER_107_99 VGND VGND VPWR VPWR sky130_fd_sc_hd__decap_3
X_6259_ _1752_ _1754_ _1784_ _1785_ VGND VGND VPWR VPWR _1787_ sky130_fd_sc_hd__o211ai_1
XFILLER_88_144 VPWR VGND VPWR VGND sky130_ef_sc_hd__decap_12
X_9047_ clknet_leaf_4_clk _0159_ VGND VGND VPWR VPWR net120 sky130_fd_sc_hd__dfxtp_1
XFILLER_67_15 VGND VGND VPWR VPWR sky130_fd_sc_hd__fill_2
XFILLER_17_417 VPWR VGND VPWR VGND sky130_ef_sc_hd__decap_12
XFILLER_29_255 VGND VGND VPWR VPWR sky130_fd_sc_hd__decap_6
XFILLER_44_203 VGND VGND VPWR VPWR sky130_fd_sc_hd__fill_1
XFILLER_72_545 VGND VGND VPWR VPWR sky130_fd_sc_hd__fill_1
XTAP_TAPCELL_ROW_67_1059 VGND VPWR sky130_fd_sc_hd__tapvpwrvgnd_1
XFILLER_25_461 VGND VGND VPWR VPWR sky130_fd_sc_hd__decap_8
XTAP_TAPCELL_ROW_80_1215 VGND VPWR sky130_fd_sc_hd__tapvpwrvgnd_1
XFILLER_12_111 VGND VGND VPWR VPWR sky130_fd_sc_hd__fill_2
XPHY_EDGE_ROW_11_Right_11 VGND VGND VPWR VPWR sky130_fd_sc_hd__decap_3
XFILLER_16_74 VGND VGND VPWR VPWR sky130_fd_sc_hd__fill_2
XFILLER_16_85 VPWR VGND VPWR VGND sky130_ef_sc_hd__decap_12
XFILLER_8_126 VGND VGND VPWR VPWR sky130_fd_sc_hd__fill_1
XFILLER_40_464 VGND VGND VPWR VPWR sky130_fd_sc_hd__fill_2
XTAP_TAPCELL_ROW_10_378 VGND VPWR sky130_fd_sc_hd__tapvpwrvgnd_1
XFILLER_4_321 VPWR VGND VPWR VGND sky130_ef_sc_hd__decap_12
XTAP_TAPCELL_ROW_78_1188 VGND VPWR sky130_fd_sc_hd__tapvpwrvgnd_1
XTAP_TAPCELL_ROW_91_1344 VGND VPWR sky130_fd_sc_hd__tapvpwrvgnd_1
XFILLER_79_111 VGND VGND VPWR VPWR sky130_fd_sc_hd__fill_1
XPHY_EDGE_ROW_20_Right_20 VGND VGND VPWR VPWR sky130_fd_sc_hd__decap_3
XFILLER_67_317 VPWR VGND VPWR VGND sky130_ef_sc_hd__decap_12
XFILLER_82_309 VGND VGND VPWR VPWR sky130_fd_sc_hd__decap_8
XFILLER_57_81 VPWR VGND VPWR VGND sky130_ef_sc_hd__decap_12
XFILLER_35_225 VGND VGND VPWR VPWR sky130_fd_sc_hd__decap_8
XFILLER_63_567 VGND VGND VPWR VPWR sky130_fd_sc_hd__decap_8
XTAP_TAPCELL_ROW_18_467 VGND VPWR sky130_fd_sc_hd__tapvpwrvgnd_1
XFILLER_16_472 VGND VGND VPWR VPWR sky130_fd_sc_hd__decap_4
XFILLER_31_420 VGND VGND VPWR VPWR sky130_fd_sc_hd__decap_8
XFILLER_50_239 VGND VGND VPWR VPWR sky130_fd_sc_hd__decap_4
X_5630_ net931 net383 VGND VGND VPWR VPWR _0171_ sky130_fd_sc_hd__and2_1
XTAP_TAPCELL_ROW_100_1451 VGND VPWR sky130_fd_sc_hd__tapvpwrvgnd_1
X_5561_ net902 net395 VGND VGND VPWR VPWR _0102_ sky130_fd_sc_hd__and2_1
X_8280_ _3625_ _3665_ VGND VGND VPWR VPWR _3667_ sky130_fd_sc_hd__or2_1
X_7300_ _2759_ _2616_ _2615_ VGND VGND VPWR VPWR _2761_ sky130_fd_sc_hd__and3b_1
X_5492_ net939 net249 _1206_ net370 VGND VGND VPWR VPWR _0056_ sky130_fd_sc_hd__o211a_1
X_4512_ pe_array\[3\].u_pe.accum_reg\[3\] net509 net299 VGND VGND VPWR VPWR _4278_
+ sky130_fd_sc_hd__and3_4
XFILLER_8_693 VGND VGND VPWR VPWR sky130_fd_sc_hd__decap_6
XFILLER_7_192 VGND VGND VPWR VPWR sky130_fd_sc_hd__fill_2
X_7231_ _2655_ _2617_ _2693_ VGND VGND VPWR VPWR _2694_ sky130_fd_sc_hd__a21oi_4
X_7162_ net465 _4234_ _2624_ VGND VGND VPWR VPWR _2626_ sky130_fd_sc_hd__or3_1
XFILLER_86_604 VGND VGND VPWR VPWR sky130_fd_sc_hd__fill_1
X_6113_ _1642_ _1643_ VGND VGND VPWR VPWR _1645_ sky130_fd_sc_hd__xnor2_1
X_7093_ _2516_ _2514_ _2557_ _2558_ VGND VGND VPWR VPWR _2559_ sky130_fd_sc_hd__o211a_4
XTAP_TAPCELL_ROW_111_1591 VGND VPWR sky130_fd_sc_hd__tapvpwrvgnd_1
XTAP_TAPCELL_ROW_111_1580 VGND VPWR sky130_fd_sc_hd__tapvpwrvgnd_1
XFILLER_86_637 VGND VGND VPWR VPWR sky130_fd_sc_hd__decap_6
XFILLER_85_125 VPWR VGND VPWR VGND sky130_ef_sc_hd__decap_12
X_6044_ _1575_ _1576_ net201 VGND VGND VPWR VPWR _1578_ sky130_fd_sc_hd__a21o_1
XFILLER_39_542 VGND VGND VPWR VPWR sky130_fd_sc_hd__decap_4
XFILLER_73_309 VGND VGND VPWR VPWR sky130_fd_sc_hd__fill_1
XFILLER_39_564 VPWR VGND VPWR VGND sky130_ef_sc_hd__decap_12
X_7995_ _3346_ _3388_ VGND VGND VPWR VPWR _3389_ sky130_fd_sc_hd__xnor2_1
XFILLER_66_394 VPWR VGND VPWR VGND sky130_ef_sc_hd__decap_12
XFILLER_26_236 VPWR VGND VPWR VGND sky130_ef_sc_hd__decap_12
XFILLER_54_589 VGND VGND VPWR VPWR sky130_fd_sc_hd__fill_1
X_6946_ net449 net341 pe_array\[1\].u_pe.accum_reg\[8\] VGND VGND VPWR VPWR _2415_
+ sky130_fd_sc_hd__a21oi_1
XFILLER_81_375 VGND VGND VPWR VPWR sky130_fd_sc_hd__fill_1
XFILLER_53_39 VPWR VGND VPWR VGND sky130_ef_sc_hd__decap_12
X_6877_ _2309_ _2347_ VGND VGND VPWR VPWR _2348_ sky130_fd_sc_hd__or2_1
X_8616_ _3953_ _3955_ VGND VGND VPWR VPWR _3993_ sky130_fd_sc_hd__nand2_1
X_5828_ _1364_ _1365_ _1366_ VGND VGND VPWR VPWR _1367_ sky130_fd_sc_hd__nand3_1
X_8547_ net188 _3923_ _3925_ VGND VGND VPWR VPWR _3926_ sky130_fd_sc_hd__or3b_4
X_5759_ _1298_ _1299_ VGND VGND VPWR VPWR _1300_ sky130_fd_sc_hd__nand2_1
X_8478_ _3855_ _3856_ net263 VGND VGND VPWR VPWR _3859_ sky130_fd_sc_hd__o21ai_1
X_7429_ _2852_ _2853_ _2883_ _2884_ VGND VGND VPWR VPWR _2885_ sky130_fd_sc_hd__o211ai_1
XFILLER_1_302 VGND VGND VPWR VPWR sky130_fd_sc_hd__fill_1
XFILLER_64_309 VPWR VGND VPWR VGND sky130_ef_sc_hd__decap_12
XFILLER_17_225 VGND VGND VPWR VPWR sky130_fd_sc_hd__decap_6
XFILLER_45_545 VGND VGND VPWR VPWR sky130_fd_sc_hd__fill_2
XTAP_TAPCELL_ROW_15_437 VGND VPWR sky130_fd_sc_hd__tapvpwrvgnd_1
XTAP_TAPCELL_ROW_43_768 VGND VPWR sky130_fd_sc_hd__tapvpwrvgnd_1
XFILLER_40_250 VGND VGND VPWR VPWR sky130_fd_sc_hd__fill_2
XFILLER_5_641 VPWR VGND VPWR VGND sky130_ef_sc_hd__decap_12
XFILLER_57_7 VPWR VGND VPWR VGND sky130_ef_sc_hd__decap_12
XFILLER_5_685 VPWR VGND VPWR VGND sky130_ef_sc_hd__decap_12
XFILLER_4_77 VGND VGND VPWR VPWR sky130_fd_sc_hd__decap_6
XFILLER_68_637 VGND VGND VPWR VPWR sky130_fd_sc_hd__decap_6
XFILLER_95_467 VGND VGND VPWR VPWR sky130_fd_sc_hd__fill_2
XFILLER_82_128 VGND VGND VPWR VPWR sky130_fd_sc_hd__decap_3
X_6800_ _2270_ _2271_ _2272_ VGND VGND VPWR VPWR _2273_ sky130_fd_sc_hd__and3_1
XFILLER_63_386 VGND VGND VPWR VPWR sky130_fd_sc_hd__decap_6
X_7780_ net974 net222 _3199_ net376 VGND VGND VPWR VPWR _0351_ sky130_fd_sc_hd__o211a_1
X_4992_ _0733_ _0734_ _0735_ VGND VGND VPWR VPWR _0736_ sky130_fd_sc_hd__nand3_1
X_6731_ net412 _2202_ VGND VGND VPWR VPWR _2209_ sky130_fd_sc_hd__nor2_1
XFILLER_16_291 VGND VGND VPWR VPWR sky130_fd_sc_hd__fill_1
X_6662_ net157 _2176_ VGND VGND VPWR VPWR _2177_ sky130_fd_sc_hd__xnor2_1
X_5613_ net997 net387 VGND VGND VPWR VPWR _0154_ sky130_fd_sc_hd__and2_1
X_8401_ net161 _3744_ _3743_ VGND VGND VPWR VPWR _3785_ sky130_fd_sc_hd__o21bai_1
Xclkbuf_3_2__f_clk clknet_0_clk VGND VGND VPWR VPWR clknet_3_2__leaf_clk sky130_fd_sc_hd__clkbuf_16
X_6593_ _2070_ _2072_ _2108_ VGND VGND VPWR VPWR _2110_ sky130_fd_sc_hd__nor3_1
X_8332_ _3670_ _3683_ _3682_ VGND VGND VPWR VPWR _3718_ sky130_fd_sc_hd__a21bo_1
X_5544_ net242 VGND VGND VPWR VPWR _0085_ sky130_fd_sc_hd__inv_2
X_8263_ _3587_ _3590_ _3649_ _3650_ VGND VGND VPWR VPWR _3651_ sky130_fd_sc_hd__a211oi_4
X_5475_ net252 _4321_ VGND VGND VPWR VPWR _1198_ sky130_fd_sc_hd__nand2_1
XFILLER_117_399 VGND VGND VPWR VPWR sky130_fd_sc_hd__fill_1
X_8194_ net679 net311 net308 net462 VGND VGND VPWR VPWR _3583_ sky130_fd_sc_hd__a22oi_1
X_7214_ net195 _2638_ _2636_ VGND VGND VPWR VPWR _2677_ sky130_fd_sc_hd__a21o_1
Xfanout403 net404 VGND VGND VPWR VPWR net403 sky130_fd_sc_hd__buf_2
Xfanout414 net415 VGND VGND VPWR VPWR net414 sky130_fd_sc_hd__clkbuf_4
X_7145_ _2564_ _2607_ _2608_ VGND VGND VPWR VPWR _2610_ sky130_fd_sc_hd__or3b_1
XFILLER_113_561 VPWR VGND VPWR VGND sky130_ef_sc_hd__decap_12
XFILLER_86_412 VGND VGND VPWR VPWR sky130_fd_sc_hd__decap_8
Xfanout436 net639 VGND VGND VPWR VPWR net436 sky130_fd_sc_hd__clkbuf_4
Xfanout425 net427 VGND VGND VPWR VPWR net425 sky130_fd_sc_hd__clkbuf_4
Xfanout447 net448 VGND VGND VPWR VPWR net447 sky130_fd_sc_hd__buf_6
Xfanout458 net459 VGND VGND VPWR VPWR net458 sky130_fd_sc_hd__buf_4
Xfanout469 net471 VGND VGND VPWR VPWR net469 sky130_fd_sc_hd__buf_2
X_7076_ _2499_ _2501_ VGND VGND VPWR VPWR _2542_ sky130_fd_sc_hd__xnor2_2
X_6027_ net481 _4232_ VGND VGND VPWR VPWR _1561_ sky130_fd_sc_hd__nor2_1
XFILLER_27_501 VGND VGND VPWR VPWR sky130_fd_sc_hd__decap_3
XFILLER_104_67 VGND VGND VPWR VPWR sky130_fd_sc_hd__fill_1
XFILLER_64_27 VGND VGND VPWR VPWR sky130_fd_sc_hd__fill_1
XFILLER_82_651 VPWR VGND VPWR VGND sky130_ef_sc_hd__decap_12
X_7978_ net478 net317 VGND VGND VPWR VPWR _3372_ sky130_fd_sc_hd__nand2_1
XTAP_TAPCELL_ROW_64_1018 VGND VPWR sky130_fd_sc_hd__tapvpwrvgnd_1
XFILLER_14_228 VGND VGND VPWR VPWR sky130_fd_sc_hd__decap_8
XFILLER_27_589 VGND VGND VPWR VPWR sky130_fd_sc_hd__decap_6
X_6929_ _2325_ _2363_ _2364_ VGND VGND VPWR VPWR _2398_ sky130_fd_sc_hd__o21ba_1
XFILLER_10_401 VPWR VGND VPWR VGND sky130_ef_sc_hd__decap_12
XTAP_TAPCELL_ROW_40_738 VGND VPWR sky130_fd_sc_hd__tapvpwrvgnd_1
XFILLER_13_64 VGND VGND VPWR VPWR sky130_fd_sc_hd__fill_1
XFILLER_10_445 VPWR VGND VPWR VGND sky130_ef_sc_hd__decap_12
XFILLER_108_333 VPWR VGND VPWR VGND sky130_ef_sc_hd__decap_12
XTAP_TAPCELL_ROW_20_495 VGND VPWR sky130_fd_sc_hd__tapvpwrvgnd_1
XTAP_TAPCELL_ROW_75_1158 VGND VPWR sky130_fd_sc_hd__tapvpwrvgnd_1
XFILLER_96_209 VPWR VGND VPWR VGND sky130_ef_sc_hd__decap_12
Xhold490 pe_accum\[2\]\[11\] VGND VGND VPWR VPWR net1005 sky130_fd_sc_hd__dlygate4sd3_1
XFILLER_77_423 VGND VGND VPWR VPWR sky130_fd_sc_hd__decap_8
XFILLER_2_699 VGND VGND VPWR VPWR sky130_fd_sc_hd__fill_1
XFILLER_49_147 VGND VGND VPWR VPWR sky130_fd_sc_hd__decap_4
XFILLER_65_629 VPWR VGND VPWR VGND sky130_ef_sc_hd__decap_12
XTAP_TAPCELL_ROW_48_827 VGND VPWR sky130_fd_sc_hd__tapvpwrvgnd_1
XFILLER_64_139 VGND VGND VPWR VPWR sky130_fd_sc_hd__fill_1
XFILLER_58_681 VPWR VGND VPWR VGND sky130_ef_sc_hd__decap_12
XFILLER_18_523 VGND VGND VPWR VPWR sky130_fd_sc_hd__fill_1
XFILLER_18_578 VGND VGND VPWR VPWR sky130_fd_sc_hd__fill_2
XTAP_TAPCELL_ROW_86_1287 VGND VPWR sky130_fd_sc_hd__tapvpwrvgnd_1
XFILLER_73_673 VGND VGND VPWR VPWR sky130_fd_sc_hd__decap_6
XFILLER_18_589 VGND VGND VPWR VPWR sky130_fd_sc_hd__decap_4
XTAP_TAPCELL_ROW_28_584 VGND VPWR sky130_fd_sc_hd__tapvpwrvgnd_1
XFILLER_33_515 VGND VGND VPWR VPWR sky130_fd_sc_hd__decap_4
XTAP_TAPCELL_ROW_28_595 VGND VPWR sky130_fd_sc_hd__tapvpwrvgnd_1
XFILLER_9_276 VGND VGND VPWR VPWR sky130_fd_sc_hd__decap_4
XFILLER_9_254 VGND VGND VPWR VPWR sky130_fd_sc_hd__decap_3
Xclkload35 clknet_leaf_5_clk VGND VGND VPWR VPWR clkload35/X sky130_fd_sc_hd__clkbuf_4
XFILLER_70_81 VGND VGND VPWR VPWR sky130_fd_sc_hd__decap_3
Xclkload13 clknet_leaf_63_clk VGND VGND VPWR VPWR clkload13/Y sky130_fd_sc_hd__inv_12
Xclkload24 clknet_leaf_47_clk VGND VGND VPWR VPWR clkload24/Y sky130_fd_sc_hd__inv_12
Xclkload57 clknet_leaf_27_clk VGND VGND VPWR VPWR clkload57/Y sky130_fd_sc_hd__clkinv_8
Xclkload46 clknet_leaf_18_clk VGND VGND VPWR VPWR clkload46/X sky130_fd_sc_hd__clkbuf_4
X_5260_ net688 _0994_ VGND VGND VPWR VPWR _0995_ sky130_fd_sc_hd__xnor2_1
XFILLER_79_90 VGND VGND VPWR VPWR sky130_fd_sc_hd__decap_3
XFILLER_48_3 VPWR VGND VPWR VGND sky130_ef_sc_hd__decap_12
X_5191_ net285 _0925_ _0926_ VGND VGND VPWR VPWR _0928_ sky130_fd_sc_hd__or3_1
XFILLER_95_220 VGND VGND VPWR VPWR sky130_fd_sc_hd__decap_4
X_8950_ clknet_leaf_64_clk _0062_ VGND VGND VPWR VPWR pe_accum\[3\]\[18\] sky130_fd_sc_hd__dfxtp_1
XFILLER_28_309 VPWR VGND VPWR VGND sky130_ef_sc_hd__decap_12
X_7901_ _3294_ _3295_ net828 _3267_ VGND VGND VPWR VPWR _3297_ sky130_fd_sc_hd__a211o_1
X_8881_ net928 net213 _4221_ net385 VGND VGND VPWR VPWR _0430_ sky130_fd_sc_hd__o211a_1
X_7832_ net504 net497 net323 net325 VGND VGND VPWR VPWR _3231_ sky130_fd_sc_hd__and4_1
XFILLER_64_695 VGND VGND VPWR VPWR sky130_fd_sc_hd__fill_1
XFILLER_63_183 VPWR VGND VPWR VGND sky130_ef_sc_hd__decap_12
X_7763_ net221 _2791_ VGND VGND VPWR VPWR _3191_ sky130_fd_sc_hd__nand2_1
XFILLER_24_548 VGND VGND VPWR VPWR sky130_fd_sc_hd__decap_8
X_4975_ _0598_ _0647_ net180 VGND VGND VPWR VPWR _0719_ sky130_fd_sc_hd__a21o_1
X_6714_ net899 net233 _2062_ net242 VGND VGND VPWR VPWR _0284_ sky130_fd_sc_hd__o2bb2ai_1
XFILLER_32_581 VGND VGND VPWR VPWR sky130_fd_sc_hd__decap_6
XFILLER_32_592 VGND VGND VPWR VPWR sky130_fd_sc_hd__decap_4
X_7694_ _3139_ _3140_ VGND VGND VPWR VPWR _3141_ sky130_fd_sc_hd__nand2_1
X_6645_ net429 _2160_ VGND VGND VPWR VPWR _0255_ sky130_fd_sc_hd__nor2_1
Xclkload7 clknet_leaf_52_clk VGND VGND VPWR VPWR clkload7/Y sky130_fd_sc_hd__inv_6
XFILLER_50_29 VPWR VGND VPWR VGND sky130_ef_sc_hd__decap_12
X_6576_ _2009_ _2035_ VGND VGND VPWR VPWR _2093_ sky130_fd_sc_hd__and2_1
XFILLER_117_141 VGND VGND VPWR VPWR sky130_fd_sc_hd__fill_2
X_9295_ clknet_leaf_10_clk _0407_ VGND VGND VPWR VPWR pe_accum\[2\]\[5\] sky130_fd_sc_hd__dfxtp_1
X_8315_ _3581_ _3628_ net160 VGND VGND VPWR VPWR _3701_ sky130_fd_sc_hd__o21bai_1
X_5527_ net251 _1178_ VGND VGND VPWR VPWR _1224_ sky130_fd_sc_hd__nand2_1
X_8246_ net439 net313 pe_array\[2\].u_pe.accum_reg\[13\] VGND VGND VPWR VPWR _3634_
+ sky130_fd_sc_hd__a21oi_1
X_5458_ _1184_ _1185_ VGND VGND VPWR VPWR _1186_ sky130_fd_sc_hd__xnor2_1
Xfanout211 _3215_ VGND VGND VPWR VPWR net211 sky130_fd_sc_hd__buf_2
Xfanout200 net201 VGND VGND VPWR VPWR net200 sky130_fd_sc_hd__buf_6
X_8177_ _3563_ _3564_ _3548_ VGND VGND VPWR VPWR _3567_ sky130_fd_sc_hd__a21oi_1
X_5389_ _1084_ _1119_ VGND VGND VPWR VPWR _1120_ sky130_fd_sc_hd__and2_1
Xfanout222 net223 VGND VGND VPWR VPWR net222 sky130_fd_sc_hd__buf_2
XFILLER_115_55 VGND VGND VPWR VPWR sky130_fd_sc_hd__fill_1
Xfanout233 net234 VGND VGND VPWR VPWR net233 sky130_fd_sc_hd__buf_2
Xfanout244 net245 VGND VGND VPWR VPWR net244 sky130_fd_sc_hd__buf_2
X_7128_ _2589_ _2590_ net542 _2546_ VGND VGND VPWR VPWR _2593_ sky130_fd_sc_hd__a211o_1
Xfanout255 _4243_ VGND VGND VPWR VPWR net255 sky130_fd_sc_hd__buf_2
Xfanout277 net278 VGND VGND VPWR VPWR net277 sky130_fd_sc_hd__buf_8
XTAP_TAPCELL_ROW_70_1099 VGND VPWR sky130_fd_sc_hd__tapvpwrvgnd_1
XTAP_TAPCELL_ROW_70_1088 VGND VPWR sky130_fd_sc_hd__tapvpwrvgnd_1
Xfanout299 net300 VGND VGND VPWR VPWR net299 sky130_fd_sc_hd__buf_6
Xfanout266 net267 VGND VGND VPWR VPWR net266 sky130_fd_sc_hd__buf_4
Xfanout288 _0482_ VGND VGND VPWR VPWR net288 sky130_fd_sc_hd__buf_8
X_7059_ _2524_ _2525_ VGND VGND VPWR VPWR _2526_ sky130_fd_sc_hd__or2_1
XFILLER_46_139 VGND VGND VPWR VPWR sky130_fd_sc_hd__fill_1
XFILLER_61_109 VGND VGND VPWR VPWR sky130_fd_sc_hd__decap_3
XFILLER_55_673 VGND VGND VPWR VPWR sky130_fd_sc_hd__decap_4
XFILLER_91_36 VGND VGND VPWR VPWR sky130_fd_sc_hd__fill_1
XFILLER_70_643 VGND VGND VPWR VPWR sky130_fd_sc_hd__fill_1
XFILLER_54_194 VGND VGND VPWR VPWR sky130_fd_sc_hd__fill_2
XTAP_TAPCELL_ROW_53_885 VGND VPWR sky130_fd_sc_hd__tapvpwrvgnd_1
XTAP_TAPCELL_ROW_25_554 VGND VPWR sky130_fd_sc_hd__tapvpwrvgnd_1
XFILLER_42_356 VGND VGND VPWR VPWR sky130_fd_sc_hd__decap_8
XFILLER_23_592 VGND VGND VPWR VPWR sky130_fd_sc_hd__fill_1
XFILLER_10_253 VPWR VGND VPWR VGND sky130_ef_sc_hd__decap_12
XFILLER_109_653 VPWR VGND VPWR VGND sky130_ef_sc_hd__decap_12
XFILLER_108_141 VGND VGND VPWR VPWR sky130_fd_sc_hd__decap_6
XFILLER_40_73 VGND VGND VPWR VPWR sky130_fd_sc_hd__fill_1
XFILLER_97_529 VGND VGND VPWR VPWR sky130_fd_sc_hd__decap_8
XFILLER_104_391 VGND VGND VPWR VPWR sky130_fd_sc_hd__fill_2
XTAP_TAPCELL_ROW_88_1305 VGND VPWR sky130_fd_sc_hd__tapvpwrvgnd_1
XFILLER_65_415 VPWR VGND VPWR VGND sky130_ef_sc_hd__decap_12
XFILLER_65_437 VGND VGND VPWR VPWR sky130_fd_sc_hd__decap_8
XFILLER_37_117 VGND VGND VPWR VPWR sky130_fd_sc_hd__fill_1
XFILLER_18_353 VGND VGND VPWR VPWR sky130_fd_sc_hd__decap_8
XFILLER_46_640 VGND VGND VPWR VPWR sky130_fd_sc_hd__decap_4
XFILLER_33_312 VGND VGND VPWR VPWR sky130_fd_sc_hd__decap_4
XFILLER_33_345 VGND VGND VPWR VPWR sky130_fd_sc_hd__fill_2
XFILLER_61_665 VGND VGND VPWR VPWR sky130_fd_sc_hd__decap_6
XFILLER_33_356 VGND VGND VPWR VPWR sky130_fd_sc_hd__decap_8
XFILLER_60_197 VGND VGND VPWR VPWR sky130_fd_sc_hd__decap_8
XFILLER_60_175 VGND VGND VPWR VPWR sky130_fd_sc_hd__decap_4
X_4760_ net476 net469 net291 net289 VGND VGND VPWR VPWR _0509_ sky130_fd_sc_hd__and4_1
XPHY_EDGE_ROW_112_Right_112 VGND VGND VPWR VPWR sky130_fd_sc_hd__decap_3
XTAP_TAPCELL_ROW_99_1445 VGND VPWR sky130_fd_sc_hd__tapvpwrvgnd_1
X_4691_ net300 net471 pe_array\[3\].u_pe.accum_reg\[8\] VGND VGND VPWR VPWR _0442_
+ sky130_fd_sc_hd__a21o_1
X_6430_ net456 net359 pe_array\[0\].u_pe.accum_reg\[23\] VGND VGND VPWR VPWR _1952_
+ sky130_fd_sc_hd__a21oi_1
X_6361_ _1884_ _1883_ VGND VGND VPWR VPWR _1886_ sky130_fd_sc_hd__xnor2_2
X_8100_ _3446_ _3491_ _3490_ _3487_ VGND VGND VPWR VPWR _3492_ sky130_fd_sc_hd__a211o_1
X_5312_ _1042_ _1043_ VGND VGND VPWR VPWR _1045_ sky130_fd_sc_hd__xor2_1
XPHY_EDGE_ROW_49_Right_49 VGND VGND VPWR VPWR sky130_fd_sc_hd__decap_3
X_6292_ _1568_ _1816_ net606 VGND VGND VPWR VPWR _1819_ sky130_fd_sc_hd__or3b_1
X_9080_ clknet_leaf_61_clk _0192_ VGND VGND VPWR VPWR net29 sky130_fd_sc_hd__dfxtp_1
X_8031_ net470 net317 pe_array\[2\].u_pe.accum_reg\[8\] VGND VGND VPWR VPWR _3424_
+ sky130_fd_sc_hd__a21oi_1
X_5243_ net397 pe_array\[3\].u_pe.accum_reg\[23\] net255 _0978_ VGND VGND VPWR VPWR
+ _0979_ sky130_fd_sc_hd__o2bb2a_4
XFILLER_68_231 VGND VGND VPWR VPWR sky130_fd_sc_hd__decap_8
X_5174_ _0909_ _0910_ VGND VGND VPWR VPWR _0912_ sky130_fd_sc_hd__xor2_1
XFILLER_29_19 VGND VGND VPWR VPWR sky130_fd_sc_hd__decap_8
XFILLER_68_253 VGND VGND VPWR VPWR sky130_fd_sc_hd__fill_1
XFILLER_96_595 VGND VGND VPWR VPWR sky130_fd_sc_hd__fill_1
XFILLER_83_256 VGND VGND VPWR VPWR sky130_fd_sc_hd__decap_3
XPHY_EDGE_ROW_58_Right_58 VGND VGND VPWR VPWR sky130_fd_sc_hd__decap_3
X_8933_ clknet_leaf_53_clk _0045_ VGND VGND VPWR VPWR pe_accum\[3\]\[1\] sky130_fd_sc_hd__dfxtp_1
XTAP_TAPCELL_ROW_108_1552 VGND VPWR sky130_fd_sc_hd__tapvpwrvgnd_1
X_8864_ _3887_ net211 VGND VGND VPWR VPWR _4213_ sky130_fd_sc_hd__nand2_2
XFILLER_71_429 VPWR VGND VPWR VGND sky130_ef_sc_hd__decap_12
XFILLER_37_673 VGND VGND VPWR VPWR sky130_fd_sc_hd__decap_3
XFILLER_37_684 VGND VGND VPWR VPWR sky130_fd_sc_hd__fill_1
X_7815_ net1022 _3213_ _3216_ VGND VGND VPWR VPWR _0369_ sky130_fd_sc_hd__o21ba_1
X_8795_ _4164_ _4165_ VGND VGND VPWR VPWR _4166_ sky130_fd_sc_hd__nor2_1
XFILLER_52_665 VGND VGND VPWR VPWR sky130_fd_sc_hd__fill_1
XFILLER_51_131 VGND VGND VPWR VPWR sky130_fd_sc_hd__decap_8
XFILLER_24_378 VGND VGND VPWR VPWR sky130_fd_sc_hd__decap_4
XFILLER_51_186 VGND VGND VPWR VPWR sky130_fd_sc_hd__decap_4
XTAP_TAPCELL_ROW_22_513 VGND VPWR sky130_fd_sc_hd__tapvpwrvgnd_1
X_4958_ _0700_ _0701_ _0688_ VGND VGND VPWR VPWR _0703_ sky130_fd_sc_hd__a21o_1
X_7746_ net972 net227 _3182_ net376 VGND VGND VPWR VPWR _0334_ sky130_fd_sc_hd__o211a_1
XTAP_TAPCELL_ROW_50_855 VGND VPWR sky130_fd_sc_hd__tapvpwrvgnd_1
X_4889_ _0591_ _0545_ VGND VGND VPWR VPWR _0636_ sky130_fd_sc_hd__and2b_1
X_7677_ _2698_ _3123_ VGND VGND VPWR VPWR _3125_ sky130_fd_sc_hd__xnor2_1
X_6628_ net177 _2142_ VGND VGND VPWR VPWR _2144_ sky130_fd_sc_hd__xnor2_1
XPHY_EDGE_ROW_67_Right_67 VGND VGND VPWR VPWR sky130_fd_sc_hd__decap_3
XFILLER_20_595 VPWR VGND VPWR VGND sky130_ef_sc_hd__decap_12
XFILLER_106_623 VGND VGND VPWR VPWR sky130_fd_sc_hd__fill_1
X_6559_ net654 _2075_ VGND VGND VPWR VPWR _2077_ sky130_fd_sc_hd__nand2_1
XFILLER_106_645 VPWR VGND VPWR VGND sky130_ef_sc_hd__decap_12
X_9278_ clknet_leaf_5_clk _0390_ VGND VGND VPWR VPWR pe_array\[2\].u_pe.accum_reg\[20\]
+ sky130_fd_sc_hd__dfxtp_1
XFILLER_3_238 VGND VGND VPWR VPWR sky130_fd_sc_hd__decap_6
XTAP_TAPCELL_ROW_72_1117 VGND VPWR sky130_fd_sc_hd__tapvpwrvgnd_1
X_8229_ _3574_ _3531_ VGND VGND VPWR VPWR _3618_ sky130_fd_sc_hd__and2b_1
XFILLER_87_595 VPWR VGND VPWR VGND sky130_ef_sc_hd__decap_12
XPHY_EDGE_ROW_76_Right_76 VGND VGND VPWR VPWR sky130_fd_sc_hd__decap_3
XTAP_TAPCELL_ROW_58_955 VGND VPWR sky130_fd_sc_hd__tapvpwrvgnd_1
XTAP_TAPCELL_ROW_58_944 VGND VPWR sky130_fd_sc_hd__tapvpwrvgnd_1
XFILLER_74_289 VGND VGND VPWR VPWR sky130_fd_sc_hd__fill_1
XFILLER_55_470 VGND VGND VPWR VPWR sky130_fd_sc_hd__fill_1
XTAP_TAPCELL_ROW_2_282 VGND VPWR sky130_fd_sc_hd__tapvpwrvgnd_1
XFILLER_55_492 VPWR VGND VPWR VGND sky130_ef_sc_hd__decap_12
XTAP_TAPCELL_ROW_83_1246 VGND VPWR sky130_fd_sc_hd__tapvpwrvgnd_1
XFILLER_70_473 VGND VGND VPWR VPWR sky130_fd_sc_hd__decap_3
XPHY_EDGE_ROW_85_Right_85 VGND VGND VPWR VPWR sky130_fd_sc_hd__decap_3
XFILLER_7_522 VGND VGND VPWR VPWR sky130_fd_sc_hd__fill_1
XFILLER_109_461 VGND VGND VPWR VPWR sky130_fd_sc_hd__fill_2
XTAP_TAPCELL_ROW_94_1386 VGND VPWR sky130_fd_sc_hd__tapvpwrvgnd_1
XFILLER_112_637 VGND VGND VPWR VPWR sky130_fd_sc_hd__decap_6
XFILLER_97_337 VPWR VGND VPWR VGND sky130_ef_sc_hd__decap_12
XFILLER_97_326 VGND VGND VPWR VPWR sky130_fd_sc_hd__decap_8
XPHY_EDGE_ROW_94_Right_94 VGND VGND VPWR VPWR sky130_fd_sc_hd__decap_3
XFILLER_78_573 VPWR VGND VPWR VGND sky130_ef_sc_hd__decap_12
XFILLER_65_234 VPWR VGND VPWR VGND sky130_ef_sc_hd__decap_12
XFILLER_80_215 VGND VGND VPWR VPWR sky130_fd_sc_hd__fill_2
XFILLER_65_278 VGND VGND VPWR VPWR sky130_fd_sc_hd__fill_2
X_5930_ _1426_ _1427_ _1425_ VGND VGND VPWR VPWR _1466_ sky130_fd_sc_hd__a21oi_1
XFILLER_53_407 VGND VGND VPWR VPWR sky130_fd_sc_hd__fill_1
XFILLER_34_610 VPWR VGND VPWR VGND sky130_ef_sc_hd__decap_12
XFILLER_18_172 VPWR VGND VPWR VGND sky130_ef_sc_hd__decap_12
XFILLER_18_194 VGND VGND VPWR VPWR sky130_fd_sc_hd__fill_2
XFILLER_34_643 VGND VGND VPWR VPWR sky130_fd_sc_hd__fill_1
XFILLER_92_90 VGND VGND VPWR VPWR sky130_fd_sc_hd__fill_1
X_5861_ _1397_ _1398_ VGND VGND VPWR VPWR _1399_ sky130_fd_sc_hd__nand2_1
XFILLER_33_142 VGND VGND VPWR VPWR sky130_fd_sc_hd__fill_1
XFILLER_34_665 VGND VGND VPWR VPWR sky130_fd_sc_hd__decap_3
X_7600_ _3047_ _3048_ VGND VGND VPWR VPWR _3050_ sky130_fd_sc_hd__xnor2_1
X_8580_ _3955_ _3956_ _3957_ VGND VGND VPWR VPWR _3958_ sky130_fd_sc_hd__and3_1
X_5792_ _1328_ _1329_ _1330_ VGND VGND VPWR VPWR _1332_ sky130_fd_sc_hd__nand3_1
XFILLER_61_495 VGND VGND VPWR VPWR sky130_fd_sc_hd__fill_1
XFILLER_61_473 VGND VGND VPWR VPWR sky130_fd_sc_hd__fill_2
X_4812_ net476 _4230_ VGND VGND VPWR VPWR _0560_ sky130_fd_sc_hd__nor2_1
XFILLER_21_304 VGND VGND VPWR VPWR sky130_fd_sc_hd__decap_4
XFILLER_21_315 VPWR VGND VPWR VGND sky130_ef_sc_hd__decap_12
XTAP_TAPCELL_ROW_103_1493 VGND VPWR sky130_fd_sc_hd__tapvpwrvgnd_1
X_7531_ _2983_ _2982_ VGND VGND VPWR VPWR _2984_ sky130_fd_sc_hd__and2b_1
X_4743_ _0489_ _0490_ _0491_ VGND VGND VPWR VPWR _0493_ sky130_fd_sc_hd__a21o_1
X_7462_ net166 _2916_ VGND VGND VPWR VPWR _2917_ sky130_fd_sc_hd__xnor2_1
X_6413_ net177 _1909_ _1908_ VGND VGND VPWR VPWR _1936_ sky130_fd_sc_hd__a21oi_1
X_9201_ clknet_leaf_48_clk _0313_ VGND VGND VPWR VPWR pe_array\[1\].u_pe.accum_reg\[19\]
+ sky130_fd_sc_hd__dfxtp_1
X_4674_ _4356_ _4392_ _4393_ VGND VGND VPWR VPWR _4435_ sky130_fd_sc_hd__o21ba_1
X_7393_ net425 _2850_ VGND VGND VPWR VPWR _0313_ sky130_fd_sc_hd__nor2_1
X_6344_ net411 pe_array\[0\].u_pe.accum_reg\[19\] net240 _1869_ VGND VGND VPWR VPWR
+ _1870_ sky130_fd_sc_hd__o2bb2a_2
X_9132_ clknet_leaf_27_clk _0244_ VGND VGND VPWR VPWR pe_array\[0\].u_pe.accum_reg\[18\]
+ sky130_fd_sc_hd__dfxtp_1
X_9063_ clknet_leaf_7_clk _0175_ VGND VGND VPWR VPWR net137 sky130_fd_sc_hd__dfxtp_1
XFILLER_103_615 VGND VGND VPWR VPWR sky130_fd_sc_hd__fill_1
X_6275_ _1799_ _1800_ _1801_ VGND VGND VPWR VPWR _1803_ sky130_fd_sc_hd__a21oi_1
XFILLER_115_497 VGND VGND VPWR VPWR sky130_fd_sc_hd__decap_6
XFILLER_102_125 VGND VGND VPWR VPWR sky130_fd_sc_hd__fill_1
X_8014_ net590 _4238_ VGND VGND VPWR VPWR _3407_ sky130_fd_sc_hd__or2_1
X_5226_ net688 _0961_ VGND VGND VPWR VPWR _0962_ sky130_fd_sc_hd__xnor2_1
XFILLER_69_551 VGND VGND VPWR VPWR sky130_fd_sc_hd__decap_3
XFILLER_96_370 VGND VGND VPWR VPWR sky130_fd_sc_hd__decap_4
X_5157_ _0807_ _0836_ _0837_ _0866_ VGND VGND VPWR VPWR _0896_ sky130_fd_sc_hd__and4bb_1
XFILLER_110_180 VPWR VGND VPWR VGND sky130_ef_sc_hd__decap_12
XFILLER_56_245 VGND VGND VPWR VPWR sky130_fd_sc_hd__decap_6
X_5088_ _0826_ _0827_ net183 VGND VGND VPWR VPWR _0829_ sky130_fd_sc_hd__o21ai_1
XFILLER_84_587 VGND VGND VPWR VPWR sky130_fd_sc_hd__fill_1
XTAP_TAPCELL_ROW_55_914 VGND VPWR sky130_fd_sc_hd__tapvpwrvgnd_1
X_8916_ clknet_leaf_68_clk _0028_ VGND VGND VPWR VPWR pe_array\[3\].u_pe.accum_reg\[16\]
+ sky130_fd_sc_hd__dfxtp_1
XFILLER_71_248 VGND VGND VPWR VPWR sky130_fd_sc_hd__decap_3
X_8847_ net1005 net209 _4204_ net382 VGND VGND VPWR VPWR _0413_ sky130_fd_sc_hd__o211a_1
XFILLER_24_153 VGND VGND VPWR VPWR sky130_fd_sc_hd__decap_4
XFILLER_25_654 VGND VGND VPWR VPWR sky130_fd_sc_hd__fill_2
X_8778_ _4117_ _4149_ VGND VGND VPWR VPWR _4150_ sky130_fd_sc_hd__or2_1
XTAP_TAPCELL_ROW_35_671 VGND VPWR sky130_fd_sc_hd__tapvpwrvgnd_1
XFILLER_40_624 VGND VGND VPWR VPWR sky130_fd_sc_hd__decap_4
X_7729_ net226 _2213_ VGND VGND VPWR VPWR _3174_ sky130_fd_sc_hd__nand2_1
XFILLER_24_197 VGND VGND VPWR VPWR sky130_fd_sc_hd__fill_2
XFILLER_115_3 VPWR VGND VPWR VGND sky130_ef_sc_hd__decap_12
XFILLER_4_525 VGND VGND VPWR VPWR sky130_fd_sc_hd__decap_6
XFILLER_21_75 VGND VGND VPWR VPWR sky130_fd_sc_hd__decap_8
XFILLER_106_453 VGND VGND VPWR VPWR sky130_fd_sc_hd__decap_8
XFILLER_4_569 VPWR VGND VPWR VGND sky130_ef_sc_hd__decap_12
XFILLER_97_68 VGND VGND VPWR VPWR sky130_fd_sc_hd__fill_1
XFILLER_97_57 VGND VGND VPWR VPWR sky130_fd_sc_hd__fill_2
XFILLER_79_337 VGND VGND VPWR VPWR sky130_fd_sc_hd__decap_3
XFILLER_79_326 VGND VGND VPWR VPWR sky130_fd_sc_hd__fill_1
XTAP_TAPCELL_ROW_7_341 VGND VPWR sky130_fd_sc_hd__tapvpwrvgnd_1
XFILLER_79_359 VPWR VGND VPWR VGND sky130_ef_sc_hd__decap_12
XFILLER_75_554 VGND VGND VPWR VPWR sky130_fd_sc_hd__decap_6
XFILLER_47_223 VGND VGND VPWR VPWR sky130_fd_sc_hd__fill_1
XFILLER_75_576 VPWR VGND VPWR VGND sky130_ef_sc_hd__decap_12
XFILLER_47_267 VPWR VGND VPWR VGND sky130_ef_sc_hd__decap_12
XFILLER_62_248 VGND VGND VPWR VPWR sky130_fd_sc_hd__decap_4
XFILLER_46_83 VGND VGND VPWR VPWR sky130_fd_sc_hd__fill_1
XFILLER_15_164 VGND VGND VPWR VPWR sky130_fd_sc_hd__decap_4
XFILLER_43_484 VPWR VGND VPWR VGND sky130_ef_sc_hd__decap_12
XFILLER_87_7 VGND VGND VPWR VPWR sky130_fd_sc_hd__decap_3
XFILLER_62_82 VGND VGND VPWR VPWR sky130_fd_sc_hd__fill_2
XFILLER_30_145 VGND VGND VPWR VPWR sky130_fd_sc_hd__fill_1
XTAP_TAPCELL_ROW_96_1404 VGND VPWR sky130_fd_sc_hd__tapvpwrvgnd_1
XFILLER_7_55 VGND VGND VPWR VPWR sky130_fd_sc_hd__fill_1
XFILLER_116_228 VGND VGND VPWR VPWR sky130_fd_sc_hd__decap_4
XFILLER_7_77 VGND VGND VPWR VPWR sky130_fd_sc_hd__fill_2
XFILLER_97_123 VGND VGND VPWR VPWR sky130_fd_sc_hd__fill_2
XFILLER_97_167 VGND VGND VPWR VPWR sky130_fd_sc_hd__fill_1
XFILLER_85_307 VPWR VGND VPWR VGND sky130_ef_sc_hd__decap_12
X_6060_ _1555_ _1593_ VGND VGND VPWR VPWR _1594_ sky130_fd_sc_hd__xnor2_2
XFILLER_97_189 VGND VGND VPWR VPWR sky130_fd_sc_hd__fill_1
X_5011_ _0750_ _0751_ net283 VGND VGND VPWR VPWR _0754_ sky130_fd_sc_hd__o21ai_1
XFILLER_38_234 VGND VGND VPWR VPWR sky130_fd_sc_hd__decap_8
XFILLER_66_587 VGND VGND VPWR VPWR sky130_fd_sc_hd__fill_1
Xclone173 _0568_ VGND VGND VPWR VPWR net688 sky130_fd_sc_hd__clkbuf_1
XTAP_TAPCELL_ROW_105_1511 VGND VPWR sky130_fd_sc_hd__tapvpwrvgnd_1
XFILLER_81_557 VGND VGND VPWR VPWR sky130_fd_sc_hd__decap_3
X_6962_ _2396_ _2429_ _2430_ VGND VGND VPWR VPWR _2431_ sky130_fd_sc_hd__and3_1
X_8701_ _4073_ _4074_ VGND VGND VPWR VPWR _4075_ sky130_fd_sc_hd__or2_1
X_5913_ _1447_ _1448_ _1449_ VGND VGND VPWR VPWR _1450_ sky130_fd_sc_hd__nand3_2
X_6893_ net464 net336 net334 net472 VGND VGND VPWR VPWR _2363_ sky130_fd_sc_hd__a22oi_1
X_8632_ _3978_ _3983_ _4007_ VGND VGND VPWR VPWR _4009_ sky130_fd_sc_hd__nand3_1
X_5844_ net490 net348 net346 net493 VGND VGND VPWR VPWR _1382_ sky130_fd_sc_hd__a22oi_1
XFILLER_34_473 VGND VGND VPWR VPWR sky130_fd_sc_hd__decap_3
XFILLER_34_484 VGND VGND VPWR VPWR sky130_fd_sc_hd__decap_8
X_8563_ _3910_ _3941_ VGND VGND VPWR VPWR _3942_ sky130_fd_sc_hd__and2_1
XFILLER_61_281 VGND VGND VPWR VPWR sky130_fd_sc_hd__fill_2
XFILLER_22_657 VGND VGND VPWR VPWR sky130_fd_sc_hd__fill_1
XTAP_TAPCELL_ROW_32_641 VGND VPWR sky130_fd_sc_hd__tapvpwrvgnd_1
X_5775_ _1313_ _1314_ VGND VGND VPWR VPWR _1315_ sky130_fd_sc_hd__nor2_1
XTAP_TAPCELL_ROW_60_972 VGND VPWR sky130_fd_sc_hd__tapvpwrvgnd_1
X_7514_ net271 _2965_ _2966_ VGND VGND VPWR VPWR _2967_ sky130_fd_sc_hd__nor3_1
X_8494_ _3874_ _3873_ VGND VGND VPWR VPWR _3875_ sky130_fd_sc_hd__and2b_1
X_4726_ _0470_ _0475_ VGND VGND VPWR VPWR _0476_ sky130_fd_sc_hd__nand2_1
X_7445_ _2872_ _2877_ _2871_ VGND VGND VPWR VPWR _2901_ sky130_fd_sc_hd__o21bai_1
X_4657_ _4414_ _4416_ _4398_ VGND VGND VPWR VPWR _4419_ sky130_fd_sc_hd__o21a_1
XTAP_TAPCELL_ROW_116_1651 VGND VPWR sky130_fd_sc_hd__tapvpwrvgnd_1
XTAP_TAPCELL_ROW_116_1640 VGND VPWR sky130_fd_sc_hd__tapvpwrvgnd_1
X_7376_ _2830_ _2831_ _2832_ VGND VGND VPWR VPWR _2834_ sky130_fd_sc_hd__a21oi_1
X_9115_ clknet_leaf_13_clk _0227_ VGND VGND VPWR VPWR pe_array\[0\].u_pe.accum_reg\[1\]
+ sky130_fd_sc_hd__dfxtp_1
X_6327_ _1850_ _1852_ _1851_ VGND VGND VPWR VPWR _1853_ sky130_fd_sc_hd__and3_1
XFILLER_89_613 VGND VGND VPWR VPWR sky130_fd_sc_hd__decap_3
X_4588_ _4350_ _4351_ VGND VGND VPWR VPWR _4352_ sky130_fd_sc_hd__xnor2_1
XFILLER_115_261 VGND VGND VPWR VPWR sky130_fd_sc_hd__decap_3
X_9046_ clknet_leaf_10_clk _0158_ VGND VGND VPWR VPWR net119 sky130_fd_sc_hd__dfxtp_1
XFILLER_107_89 VGND VGND VPWR VPWR sky130_fd_sc_hd__decap_3
X_6258_ _1752_ _1754_ _1784_ _1785_ VGND VGND VPWR VPWR _1786_ sky130_fd_sc_hd__o211a_1
XFILLER_88_156 VPWR VGND VPWR VGND sky130_ef_sc_hd__decap_12
XTAP_TAPCELL_ROW_4_300 VGND VPWR sky130_fd_sc_hd__tapvpwrvgnd_1
XFILLER_88_178 VGND VGND VPWR VPWR sky130_fd_sc_hd__decap_6
X_6189_ net457 net360 pe_array\[0\].u_pe.accum_reg\[15\] VGND VGND VPWR VPWR _1719_
+ sky130_fd_sc_hd__a21oi_1
X_5209_ _0919_ _0945_ VGND VGND VPWR VPWR _0946_ sky130_fd_sc_hd__and2_1
XFILLER_29_201 VGND VGND VPWR VPWR sky130_fd_sc_hd__decap_8
XFILLER_29_223 VGND VGND VPWR VPWR sky130_fd_sc_hd__fill_1
XFILLER_84_351 VGND VGND VPWR VPWR sky130_fd_sc_hd__fill_1
XFILLER_17_429 VPWR VGND VPWR VGND sky130_ef_sc_hd__decap_12
XFILLER_29_289 VGND VGND VPWR VPWR sky130_fd_sc_hd__fill_1
XFILLER_44_215 VGND VGND VPWR VPWR sky130_fd_sc_hd__fill_1
XTAP_TAPCELL_ROW_80_1216 VGND VPWR sky130_fd_sc_hd__tapvpwrvgnd_1
XFILLER_13_602 VGND VGND VPWR VPWR sky130_fd_sc_hd__decap_6
XFILLER_16_64 VGND VGND VPWR VPWR sky130_fd_sc_hd__fill_1
XFILLER_25_495 VGND VGND VPWR VPWR sky130_fd_sc_hd__fill_2
XFILLER_9_617 VPWR VGND VPWR VGND sky130_ef_sc_hd__decap_12
XFILLER_16_97 VGND VGND VPWR VPWR sky130_fd_sc_hd__fill_1
XFILLER_40_421 VGND VGND VPWR VPWR sky130_fd_sc_hd__decap_8
XFILLER_40_487 VPWR VGND VPWR VGND sky130_ef_sc_hd__decap_12
XFILLER_32_41 VGND VGND VPWR VPWR sky130_fd_sc_hd__fill_1
XFILLER_32_63 VGND VGND VPWR VPWR sky130_fd_sc_hd__fill_2
XTAP_TAPCELL_ROW_10_368 VGND VPWR sky130_fd_sc_hd__tapvpwrvgnd_1
XTAP_TAPCELL_ROW_10_379 VGND VPWR sky130_fd_sc_hd__tapvpwrvgnd_1
XFILLER_4_333 VPWR VGND VPWR VGND sky130_ef_sc_hd__decap_12
XTAP_TAPCELL_ROW_78_1189 VGND VPWR sky130_fd_sc_hd__tapvpwrvgnd_1
XFILLER_106_272 VPWR VGND VPWR VGND sky130_ef_sc_hd__decap_12
XTAP_TAPCELL_ROW_91_1345 VGND VPWR sky130_fd_sc_hd__tapvpwrvgnd_1
XFILLER_94_126 VPWR VGND VPWR VGND sky130_ef_sc_hd__decap_12
XFILLER_67_329 VGND VGND VPWR VPWR sky130_fd_sc_hd__decap_6
XFILLER_0_561 VPWR VGND VPWR VGND sky130_ef_sc_hd__decap_12
XFILLER_57_93 VPWR VGND VPWR VGND sky130_ef_sc_hd__decap_12
XFILLER_48_565 VPWR VGND VPWR VGND sky130_ef_sc_hd__decap_12
XFILLER_48_587 VGND VGND VPWR VPWR sky130_fd_sc_hd__fill_1
XFILLER_90_332 VGND VGND VPWR VPWR sky130_fd_sc_hd__decap_4
XFILLER_90_365 VGND VGND VPWR VPWR sky130_fd_sc_hd__decap_6
XFILLER_63_557 VGND VGND VPWR VPWR sky130_fd_sc_hd__decap_3
XTAP_TAPCELL_ROW_18_468 VGND VPWR sky130_fd_sc_hd__tapvpwrvgnd_1
XFILLER_90_376 VPWR VGND VPWR VGND sky130_ef_sc_hd__decap_12
XFILLER_43_281 VGND VGND VPWR VPWR sky130_fd_sc_hd__fill_2
XTAP_TAPCELL_ROW_100_1452 VGND VPWR sky130_fd_sc_hd__tapvpwrvgnd_1
XFILLER_31_487 VGND VGND VPWR VPWR sky130_fd_sc_hd__decap_4
X_5560_ net893 net391 VGND VGND VPWR VPWR _0101_ sky130_fd_sc_hd__and2_1
X_5491_ net249 _0642_ VGND VGND VPWR VPWR _1206_ sky130_fd_sc_hd__nand2_1
X_4511_ net509 net299 pe_array\[3\].u_pe.accum_reg\[3\] VGND VGND VPWR VPWR _4277_
+ sky130_fd_sc_hd__a21oi_1
X_7230_ _2610_ _2653_ _2652_ VGND VGND VPWR VPWR _2693_ sky130_fd_sc_hd__a21oi_1
XFILLER_104_209 VPWR VGND VPWR VGND sky130_ef_sc_hd__decap_12
XFILLER_98_421 VGND VGND VPWR VPWR sky130_fd_sc_hd__fill_2
X_7161_ net464 _4234_ VGND VGND VPWR VPWR _2625_ sky130_fd_sc_hd__nor2_1
X_6112_ net467 _4232_ _1642_ VGND VGND VPWR VPWR _1644_ sky130_fd_sc_hd__or3_1
X_7092_ _2556_ _2555_ _2541_ VGND VGND VPWR VPWR _2558_ sky130_fd_sc_hd__a21o_1
XFILLER_112_253 VGND VGND VPWR VPWR sky130_fd_sc_hd__decap_3
XTAP_TAPCELL_ROW_111_1581 VGND VPWR sky130_fd_sc_hd__tapvpwrvgnd_1
XFILLER_85_104 VGND VGND VPWR VPWR sky130_fd_sc_hd__decap_8
X_6043_ net199 _1574_ _1576_ VGND VGND VPWR VPWR _1577_ sky130_fd_sc_hd__or3b_1
XFILLER_58_329 VGND VGND VPWR VPWR sky130_fd_sc_hd__decap_3
XFILLER_100_459 VPWR VGND VPWR VGND sky130_ef_sc_hd__decap_12
XFILLER_85_137 VGND VGND VPWR VPWR sky130_fd_sc_hd__decap_3
XTAP_TAPCELL_ROW_37_700 VGND VPWR sky130_fd_sc_hd__tapvpwrvgnd_1
XFILLER_39_576 VPWR VGND VPWR VGND sky130_ef_sc_hd__decap_12
XFILLER_93_181 VGND VGND VPWR VPWR sky130_fd_sc_hd__decap_8
X_7994_ _3382_ _3386_ VGND VGND VPWR VPWR _3388_ sky130_fd_sc_hd__xor2_1
XFILLER_66_373 VGND VGND VPWR VPWR sky130_fd_sc_hd__fill_2
X_6945_ pe_array\[1\].u_pe.accum_reg\[8\] net449 net341 VGND VGND VPWR VPWR _2414_
+ sky130_fd_sc_hd__and3_1
X_6876_ _2284_ _2346_ VGND VGND VPWR VPWR _2347_ sky130_fd_sc_hd__xnor2_1
X_8615_ net187 _3991_ VGND VGND VPWR VPWR _3992_ sky130_fd_sc_hd__xnor2_1
X_5827_ _1320_ _1327_ _1326_ VGND VGND VPWR VPWR _1366_ sky130_fd_sc_hd__a21bo_1
XFILLER_22_465 VGND VGND VPWR VPWR sky130_fd_sc_hd__fill_1
X_8546_ _3921_ _3922_ net601 _3891_ VGND VGND VPWR VPWR _3925_ sky130_fd_sc_hd__a211o_1
X_5758_ _1296_ _1297_ _1269_ _1270_ VGND VGND VPWR VPWR _1299_ sky130_fd_sc_hd__a211o_1
XFILLER_22_498 VGND VGND VPWR VPWR sky130_fd_sc_hd__decap_3
X_8477_ net263 _3855_ _3856_ VGND VGND VPWR VPWR _3858_ sky130_fd_sc_hd__or3_4
XFILLER_5_119 VGND VGND VPWR VPWR sky130_fd_sc_hd__fill_1
X_4709_ _0458_ _0459_ VGND VGND VPWR VPWR _0460_ sky130_fd_sc_hd__nand2_4
X_5689_ net428 _1235_ _1236_ VGND VGND VPWR VPWR _0223_ sky130_fd_sc_hd__nor3_1
X_7428_ _2880_ _2881_ net269 VGND VGND VPWR VPWR _2884_ sky130_fd_sc_hd__o21ai_1
XFILLER_78_37 VGND VGND VPWR VPWR sky130_fd_sc_hd__fill_1
X_7359_ _2757_ _2790_ VGND VGND VPWR VPWR _2818_ sky130_fd_sc_hd__or2_4
X_9029_ clknet_leaf_45_clk _0141_ VGND VGND VPWR VPWR net100 sky130_fd_sc_hd__dfxtp_1
XFILLER_45_502 VGND VGND VPWR VPWR sky130_fd_sc_hd__fill_2
XFILLER_17_215 VGND VGND VPWR VPWR sky130_fd_sc_hd__decap_8
XFILLER_17_259 VPWR VGND VPWR VGND sky130_ef_sc_hd__decap_12
XFILLER_27_74 VGND VGND VPWR VPWR sky130_fd_sc_hd__fill_1
XFILLER_60_538 VGND VGND VPWR VPWR sky130_fd_sc_hd__decap_3
XFILLER_32_218 VGND VGND VPWR VPWR sky130_fd_sc_hd__fill_2
XTAP_TAPCELL_ROW_15_438 VGND VPWR sky130_fd_sc_hd__tapvpwrvgnd_1
XFILLER_25_281 VPWR VGND VPWR VGND sky130_ef_sc_hd__decap_12
XTAP_TAPCELL_ROW_43_769 VGND VPWR sky130_fd_sc_hd__tapvpwrvgnd_1
XFILLER_43_51 VGND VGND VPWR VPWR sky130_fd_sc_hd__decap_4
XFILLER_9_447 VGND VGND VPWR VPWR sky130_fd_sc_hd__fill_1
XFILLER_5_653 VPWR VGND VPWR VGND sky130_ef_sc_hd__decap_12
XFILLER_4_141 VGND VGND VPWR VPWR sky130_fd_sc_hd__fill_1
XFILLER_5_697 VGND VGND VPWR VPWR sky130_fd_sc_hd__decap_3
XFILLER_91_652 VPWR VGND VPWR VGND sky130_ef_sc_hd__decap_12
XFILLER_51_505 VGND VGND VPWR VPWR sky130_fd_sc_hd__fill_2
XFILLER_36_546 VPWR VGND VPWR VGND sky130_ef_sc_hd__decap_12
XFILLER_36_568 VPWR VGND VPWR VGND sky130_ef_sc_hd__decap_12
X_6730_ _2207_ _2208_ VGND VGND VPWR VPWR _0292_ sky130_fd_sc_hd__nor2_1
X_4991_ _0688_ _0701_ _0700_ VGND VGND VPWR VPWR _0735_ sky130_fd_sc_hd__a21bo_1
XFILLER_90_195 VGND VGND VPWR VPWR sky130_fd_sc_hd__fill_1
X_6661_ _2174_ _2175_ VGND VGND VPWR VPWR _2176_ sky130_fd_sc_hd__nor2_1
X_5612_ net968 net386 VGND VGND VPWR VPWR _0153_ sky130_fd_sc_hd__and2_1
X_6592_ _2070_ _2072_ _2108_ VGND VGND VPWR VPWR _2109_ sky130_fd_sc_hd__o21a_1
X_8400_ _3781_ _3782_ net161 VGND VGND VPWR VPWR _3784_ sky130_fd_sc_hd__o21ai_1
XFILLER_31_284 VPWR VGND VPWR VGND sky130_ef_sc_hd__decap_12
XFILLER_117_301 VGND VGND VPWR VPWR sky130_fd_sc_hd__decap_6
X_5543_ net409 net428 _1228_ VGND VGND VPWR VPWR _1229_ sky130_fd_sc_hd__or3_1
X_8331_ _3714_ _3715_ net161 VGND VGND VPWR VPWR _3717_ sky130_fd_sc_hd__o21ai_1
XFILLER_117_378 VGND VGND VPWR VPWR sky130_fd_sc_hd__decap_3
X_8262_ _3648_ _3647_ net676 _3606_ VGND VGND VPWR VPWR _3650_ sky130_fd_sc_hd__o211a_1
X_5474_ net923 net251 _1197_ net371 VGND VGND VPWR VPWR _0047_ sky130_fd_sc_hd__o211a_1
XTAP_TAPCELL_ROW_113_1610 VGND VPWR sky130_fd_sc_hd__tapvpwrvgnd_1
XFILLER_105_529 VGND VGND VPWR VPWR sky130_fd_sc_hd__decap_4
X_8193_ net470 _4238_ VGND VGND VPWR VPWR _3582_ sky130_fd_sc_hd__nor2_1
X_7213_ _2673_ _2674_ net195 VGND VGND VPWR VPWR _2676_ sky130_fd_sc_hd__a21o_1
XFILLER_113_540 VGND VGND VPWR VPWR sky130_fd_sc_hd__decap_8
Xfanout404 net405 VGND VGND VPWR VPWR net404 sky130_fd_sc_hd__dlymetal6s2s_1
X_7144_ _2607_ _2608_ VGND VGND VPWR VPWR _2609_ sky130_fd_sc_hd__and2b_1
XFILLER_113_573 VPWR VGND VPWR VGND sky130_ef_sc_hd__decap_12
XFILLER_98_251 VGND VGND VPWR VPWR sky130_fd_sc_hd__fill_1
Xfanout415 net423 VGND VGND VPWR VPWR net415 sky130_fd_sc_hd__clkbuf_2
Xfanout437 net438 VGND VGND VPWR VPWR net437 sky130_fd_sc_hd__buf_8
Xfanout448 net451 VGND VGND VPWR VPWR net448 sky130_fd_sc_hd__clkbuf_2
Xfanout426 net427 VGND VGND VPWR VPWR net426 sky130_fd_sc_hd__clkbuf_2
XFILLER_48_29 VPWR VGND VPWR VGND sky130_ef_sc_hd__decap_12
Xfanout459 net8 VGND VGND VPWR VPWR net459 sky130_fd_sc_hd__buf_12
XFILLER_59_649 VGND VGND VPWR VPWR sky130_fd_sc_hd__decap_3
XFILLER_58_126 VGND VGND VPWR VPWR sky130_fd_sc_hd__fill_1
X_7075_ _2531_ _2539_ VGND VGND VPWR VPWR _2541_ sky130_fd_sc_hd__xnor2_1
X_6026_ _1558_ _1559_ VGND VGND VPWR VPWR _1560_ sky130_fd_sc_hd__nor2_1
XFILLER_67_671 VGND VGND VPWR VPWR sky130_fd_sc_hd__fill_1
XFILLER_39_373 VGND VGND VPWR VPWR sky130_fd_sc_hd__decap_8
XFILLER_82_663 VPWR VGND VPWR VGND sky130_ef_sc_hd__decap_12
XFILLER_81_162 VGND VGND VPWR VPWR sky130_fd_sc_hd__decap_6
X_7977_ pe_array\[2\].u_pe.accum_reg\[7\] pe_array\[2\].u_pe.weight_in\[7\] VGND VGND
+ VPWR VPWR _3371_ sky130_fd_sc_hd__xor2_1
XTAP_TAPCELL_ROW_64_1019 VGND VPWR sky130_fd_sc_hd__tapvpwrvgnd_1
X_6928_ _2319_ _2356_ _2357_ VGND VGND VPWR VPWR _2397_ sky130_fd_sc_hd__o21ba_1
XFILLER_80_38 VGND VGND VPWR VPWR sky130_fd_sc_hd__decap_8
X_6859_ net472 net336 VGND VGND VPWR VPWR _2330_ sky130_fd_sc_hd__nand2_1
XFILLER_10_413 VGND VGND VPWR VPWR sky130_fd_sc_hd__decap_6
XTAP_TAPCELL_ROW_40_728 VGND VPWR sky130_fd_sc_hd__tapvpwrvgnd_1
XTAP_TAPCELL_ROW_40_739 VGND VPWR sky130_fd_sc_hd__tapvpwrvgnd_1
XFILLER_10_457 VGND VGND VPWR VPWR sky130_fd_sc_hd__decap_3
X_8529_ net160 _3872_ _3871_ VGND VGND VPWR VPWR _3909_ sky130_fd_sc_hd__a21oi_2
XFILLER_108_345 VGND VGND VPWR VPWR sky130_fd_sc_hd__decap_8
XFILLER_89_36 VPWR VGND VPWR VGND sky130_ef_sc_hd__decap_12
XTAP_TAPCELL_ROW_20_496 VGND VPWR sky130_fd_sc_hd__tapvpwrvgnd_1
XTAP_TAPCELL_ROW_75_1159 VGND VPWR sky130_fd_sc_hd__tapvpwrvgnd_1
XTAP_TAPCELL_ROW_75_1148 VGND VPWR sky130_fd_sc_hd__tapvpwrvgnd_1
XFILLER_2_601 VPWR VGND VPWR VGND sky130_ef_sc_hd__decap_12
XFILLER_8_3 VPWR VGND VPWR VGND sky130_ef_sc_hd__decap_12
XFILLER_2_645 VPWR VGND VPWR VGND sky130_ef_sc_hd__decap_12
Xhold480 pe_accum\[1\]\[19\] VGND VGND VPWR VPWR net995 sky130_fd_sc_hd__dlygate4sd3_1
Xhold491 pe_accum\[0\]\[8\] VGND VGND VPWR VPWR net1006 sky130_fd_sc_hd__dlygate4sd3_1
XFILLER_104_595 VGND VGND VPWR VPWR sky130_fd_sc_hd__decap_8
XFILLER_77_435 VGND VGND VPWR VPWR sky130_fd_sc_hd__fill_2
XFILLER_58_693 VGND VGND VPWR VPWR sky130_fd_sc_hd__decap_6
XTAP_TAPCELL_ROW_48_828 VGND VPWR sky130_fd_sc_hd__tapvpwrvgnd_1
XTAP_TAPCELL_ROW_86_1288 VGND VPWR sky130_fd_sc_hd__tapvpwrvgnd_1
XFILLER_33_527 VPWR VGND VPWR VGND sky130_ef_sc_hd__decap_12
XFILLER_54_83 VGND VGND VPWR VPWR sky130_fd_sc_hd__fill_1
XTAP_TAPCELL_ROW_28_585 VGND VPWR sky130_fd_sc_hd__tapvpwrvgnd_1
XFILLER_60_357 VGND VGND VPWR VPWR sky130_fd_sc_hd__decap_3
XFILLER_9_200 VGND VGND VPWR VPWR sky130_fd_sc_hd__decap_3
XFILLER_9_233 VGND VGND VPWR VPWR sky130_fd_sc_hd__fill_2
XFILLER_41_593 VGND VGND VPWR VPWR sky130_fd_sc_hd__fill_1
XFILLER_70_93 VGND VGND VPWR VPWR sky130_fd_sc_hd__decap_3
Xclkload14 clknet_leaf_65_clk VGND VGND VPWR VPWR clkload14/Y sky130_fd_sc_hd__inv_12
Xclkload25 clknet_leaf_48_clk VGND VGND VPWR VPWR clkload25/Y sky130_fd_sc_hd__inv_12
Xclkload36 clknet_leaf_14_clk VGND VGND VPWR VPWR clkload36/Y sky130_fd_sc_hd__inv_12
Xclkload47 clknet_leaf_28_clk VGND VGND VPWR VPWR clkload47/Y sky130_fd_sc_hd__clkinvlp_4
XFILLER_114_304 VGND VGND VPWR VPWR sky130_fd_sc_hd__decap_4
XFILLER_5_483 VGND VGND VPWR VPWR sky130_fd_sc_hd__decap_6
XFILLER_5_461 VPWR VGND VPWR VGND sky130_ef_sc_hd__decap_12
X_5190_ net285 _0925_ _0926_ VGND VGND VPWR VPWR _0927_ sky130_fd_sc_hd__nor3_1
XFILLER_110_521 VGND VGND VPWR VPWR sky130_fd_sc_hd__fill_1
XFILLER_68_468 VGND VGND VPWR VPWR sky130_fd_sc_hd__decap_8
XFILLER_49_660 VGND VGND VPWR VPWR sky130_fd_sc_hd__fill_1
XFILLER_83_449 VGND VGND VPWR VPWR sky130_fd_sc_hd__decap_4
X_7900_ net828 _3267_ _3294_ _3295_ VGND VGND VPWR VPWR _3296_ sky130_fd_sc_hd__o211ai_2
X_8880_ net213 _4124_ VGND VGND VPWR VPWR _4221_ sky130_fd_sc_hd__nand2_2
X_7831_ net504 net323 net325 net496 VGND VGND VPWR VPWR _3230_ sky130_fd_sc_hd__a22oi_1
XFILLER_36_365 VGND VGND VPWR VPWR sky130_fd_sc_hd__decap_6
XFILLER_63_195 VPWR VGND VPWR VGND sky130_ef_sc_hd__decap_12
X_7762_ net948 net221 _3190_ net374 VGND VGND VPWR VPWR _0342_ sky130_fd_sc_hd__o211a_1
X_4974_ _0601_ _0685_ _0684_ VGND VGND VPWR VPWR _0718_ sky130_fd_sc_hd__a21o_1
X_6713_ net910 net235 _2038_ net243 VGND VGND VPWR VPWR _0283_ sky130_fd_sc_hd__o2bb2ai_1
X_7693_ _3107_ _3108_ _3138_ VGND VGND VPWR VPWR _3140_ sky130_fd_sc_hd__o21ai_1
X_6644_ net410 pe_array\[0\].u_pe.accum_reg\[29\] net238 _2159_ VGND VGND VPWR VPWR
+ _2160_ sky130_fd_sc_hd__o2bb2a_2
Xclkload8 clknet_leaf_53_clk VGND VGND VPWR VPWR clkload8/Y sky130_fd_sc_hd__clkinv_8
X_6575_ _2091_ VGND VGND VPWR VPWR _2092_ sky130_fd_sc_hd__inv_2
X_9294_ clknet_leaf_11_clk _0406_ VGND VGND VPWR VPWR pe_accum\[2\]\[4\] sky130_fd_sc_hd__dfxtp_1
X_8314_ net160 VGND VGND VPWR VPWR _3700_ sky130_fd_sc_hd__inv_2
X_5526_ net986 net251 _1223_ net367 VGND VGND VPWR VPWR _0073_ sky130_fd_sc_hd__o211a_1
X_8245_ _3630_ _3631_ VGND VGND VPWR VPWR _3633_ sky130_fd_sc_hd__xnor2_1
X_5457_ _1160_ _1161_ net743 VGND VGND VPWR VPWR _1185_ sky130_fd_sc_hd__mux2_1
XFILLER_117_197 VGND VGND VPWR VPWR sky130_fd_sc_hd__decap_8
XFILLER_105_337 VPWR VGND VPWR VGND sky130_ef_sc_hd__decap_12
Xfanout212 _3215_ VGND VGND VPWR VPWR net212 sky130_fd_sc_hd__buf_2
Xfanout201 net203 VGND VGND VPWR VPWR net201 sky130_fd_sc_hd__buf_6
X_8176_ _3548_ _3563_ net868 VGND VGND VPWR VPWR _3566_ sky130_fd_sc_hd__nand3_1
X_5388_ _1116_ _1117_ VGND VGND VPWR VPWR _1119_ sky130_fd_sc_hd__xnor2_1
Xfanout223 net228 VGND VGND VPWR VPWR net223 sky130_fd_sc_hd__clkbuf_4
Xfanout234 net235 VGND VGND VPWR VPWR net234 sky130_fd_sc_hd__dlymetal6s2s_1
Xfanout245 _1229_ VGND VGND VPWR VPWR net245 sky130_fd_sc_hd__buf_2
XFILLER_59_446 VGND VGND VPWR VPWR sky130_fd_sc_hd__fill_2
Xfanout256 _4243_ VGND VGND VPWR VPWR net256 sky130_fd_sc_hd__dlymetal6s2s_1
X_7127_ net543 _2546_ _2589_ _2590_ VGND VGND VPWR VPWR _2592_ sky130_fd_sc_hd__o211ai_1
Xfanout278 net281 VGND VGND VPWR VPWR net278 sky130_fd_sc_hd__buf_8
XTAP_TAPCELL_ROW_70_1089 VGND VPWR sky130_fd_sc_hd__tapvpwrvgnd_1
Xfanout289 pe_array\[3\].u_pe.weight_in\[6\] VGND VGND VPWR VPWR net289 sky130_fd_sc_hd__buf_2
Xfanout267 net269 VGND VGND VPWR VPWR net267 sky130_fd_sc_hd__buf_6
X_7058_ _2522_ _2523_ _2482_ VGND VGND VPWR VPWR _2525_ sky130_fd_sc_hd__o21a_1
XFILLER_86_276 VGND VGND VPWR VPWR sky130_fd_sc_hd__decap_3
X_6009_ _1541_ _1542_ _1473_ _1475_ VGND VGND VPWR VPWR _1544_ sky130_fd_sc_hd__o211a_1
XFILLER_55_641 VPWR VGND VPWR VGND sky130_ef_sc_hd__decap_12
Xclkbuf_leaf_66_clk clknet_3_1__leaf_clk VGND VGND VPWR VPWR clknet_leaf_66_clk sky130_fd_sc_hd__clkbuf_8
XFILLER_54_184 VGND VGND VPWR VPWR sky130_fd_sc_hd__decap_6
XTAP_TAPCELL_ROW_25_555 VGND VPWR sky130_fd_sc_hd__tapvpwrvgnd_1
XTAP_TAPCELL_ROW_53_886 VGND VPWR sky130_fd_sc_hd__tapvpwrvgnd_1
XFILLER_23_582 VGND VGND VPWR VPWR sky130_fd_sc_hd__decap_3
XFILLER_10_265 VPWR VGND VPWR VGND sky130_ef_sc_hd__decap_12
XFILLER_109_665 VGND VGND VPWR VPWR sky130_fd_sc_hd__decap_6
XFILLER_2_475 VGND VGND VPWR VPWR sky130_fd_sc_hd__fill_1
XFILLER_77_221 VGND VGND VPWR VPWR sky130_fd_sc_hd__decap_3
XTAP_TAPCELL_ROW_88_1306 VGND VPWR sky130_fd_sc_hd__tapvpwrvgnd_1
XFILLER_77_276 VGND VGND VPWR VPWR sky130_fd_sc_hd__decap_4
XFILLER_65_427 VGND VGND VPWR VPWR sky130_fd_sc_hd__fill_2
XFILLER_1_57 VPWR VGND VPWR VGND sky130_ef_sc_hd__decap_12
Xclkbuf_leaf_57_clk clknet_3_1__leaf_clk VGND VGND VPWR VPWR clknet_leaf_57_clk sky130_fd_sc_hd__clkbuf_8
XFILLER_80_419 VGND VGND VPWR VPWR sky130_fd_sc_hd__fill_1
XFILLER_80_408 VGND VGND VPWR VPWR sky130_fd_sc_hd__decap_4
XFILLER_61_600 VPWR VGND VPWR VGND sky130_ef_sc_hd__decap_12
XFILLER_18_365 VPWR VGND VPWR VGND sky130_ef_sc_hd__decap_12
XFILLER_60_110 VGND VGND VPWR VPWR sky130_fd_sc_hd__decap_3
XFILLER_14_582 VGND VGND VPWR VPWR sky130_fd_sc_hd__fill_1
X_4690_ net533 _0439_ VGND VGND VPWR VPWR _0441_ sky130_fd_sc_hd__xnor2_2
XTAP_TAPCELL_ROW_99_1446 VGND VPWR sky130_fd_sc_hd__tapvpwrvgnd_1
X_6360_ _1884_ _1883_ VGND VGND VPWR VPWR _1885_ sky130_fd_sc_hd__and2b_1
X_5311_ _1042_ _1043_ VGND VGND VPWR VPWR _1044_ sky130_fd_sc_hd__and2_1
XFILLER_114_145 VGND VGND VPWR VPWR sky130_fd_sc_hd__fill_1
XFILLER_114_123 VGND VGND VPWR VPWR sky130_fd_sc_hd__decap_8
X_6291_ _1815_ _1814_ _1781_ _1783_ VGND VGND VPWR VPWR _1818_ sky130_fd_sc_hd__a211o_1
X_8030_ net478 _3422_ _3421_ VGND VGND VPWR VPWR _3423_ sky130_fd_sc_hd__a21boi_1
X_5242_ _0976_ _0977_ VGND VGND VPWR VPWR _0978_ sky130_fd_sc_hd__xnor2_2
X_5173_ _0909_ _0910_ VGND VGND VPWR VPWR _0911_ sky130_fd_sc_hd__nor2_1
XFILLER_96_563 VGND VGND VPWR VPWR sky130_fd_sc_hd__fill_1
Xinput1 pixel_in[0] VGND VGND VPWR VPWR net1 sky130_fd_sc_hd__clkbuf_4
X_8932_ clknet_leaf_52_clk _0044_ VGND VGND VPWR VPWR pe_accum\[3\]\[0\] sky130_fd_sc_hd__dfxtp_1
Xclkbuf_leaf_48_clk clknet_3_2__leaf_clk VGND VGND VPWR VPWR clknet_leaf_48_clk sky130_fd_sc_hd__clkbuf_8
XFILLER_37_630 VGND VGND VPWR VPWR sky130_fd_sc_hd__decap_6
XTAP_TAPCELL_ROW_108_1553 VGND VPWR sky130_fd_sc_hd__tapvpwrvgnd_1
X_8863_ net975 net211 _4212_ net383 VGND VGND VPWR VPWR _0421_ sky130_fd_sc_hd__o211a_1
XFILLER_24_302 VGND VGND VPWR VPWR sky130_fd_sc_hd__fill_2
X_7814_ pe_array\[2\].u_pe.tap_count\[3\] _3213_ net215 net421 VGND VGND VPWR VPWR
+ _3216_ sky130_fd_sc_hd__a211o_1
XFILLER_36_184 VGND VGND VPWR VPWR sky130_fd_sc_hd__fill_1
X_8794_ _4132_ _4134_ _4163_ VGND VGND VPWR VPWR _4165_ sky130_fd_sc_hd__and3_1
XTAP_TAPCELL_ROW_22_514 VGND VPWR sky130_fd_sc_hd__tapvpwrvgnd_1
X_4957_ _0688_ _0700_ _0701_ VGND VGND VPWR VPWR _0702_ sky130_fd_sc_hd__nand3_1
X_7745_ net224 _2440_ VGND VGND VPWR VPWR _3182_ sky130_fd_sc_hd__nand2_1
XTAP_TAPCELL_ROW_50_856 VGND VPWR sky130_fd_sc_hd__tapvpwrvgnd_1
X_4888_ _0589_ _0633_ VGND VGND VPWR VPWR _0635_ sky130_fd_sc_hd__xor2_2
X_7676_ net170 _3123_ VGND VGND VPWR VPWR _3124_ sky130_fd_sc_hd__and2_1
X_6627_ net657 _2142_ VGND VGND VPWR VPWR _2143_ sky130_fd_sc_hd__nor2_1
X_6558_ net654 _2075_ VGND VGND VPWR VPWR _2076_ sky130_fd_sc_hd__nor2_1
X_6489_ _1985_ _2009_ VGND VGND VPWR VPWR _2010_ sky130_fd_sc_hd__xnor2_1
XFILLER_106_657 VGND VGND VPWR VPWR sky130_fd_sc_hd__decap_8
X_9277_ clknet_leaf_5_clk _0389_ VGND VGND VPWR VPWR pe_array\[2\].u_pe.accum_reg\[19\]
+ sky130_fd_sc_hd__dfxtp_1
X_5509_ _0923_ net246 VGND VGND VPWR VPWR _1215_ sky130_fd_sc_hd__nand2_1
XTAP_TAPCELL_ROW_72_1118 VGND VPWR sky130_fd_sc_hd__tapvpwrvgnd_1
X_8228_ _3615_ _3616_ VGND VGND VPWR VPWR _3617_ sky130_fd_sc_hd__and2_1
XFILLER_105_189 VGND VGND VPWR VPWR sky130_fd_sc_hd__decap_6
XFILLER_86_37 VPWR VGND VPWR VGND sky130_ef_sc_hd__decap_12
X_8159_ _3507_ _3516_ _3515_ VGND VGND VPWR VPWR _3549_ sky130_fd_sc_hd__a21bo_1
XFILLER_74_235 VGND VGND VPWR VPWR sky130_fd_sc_hd__decap_3
XTAP_TAPCELL_ROW_58_945 VGND VPWR sky130_fd_sc_hd__tapvpwrvgnd_1
Xclkbuf_leaf_39_clk clknet_3_3__leaf_clk VGND VGND VPWR VPWR clknet_leaf_39_clk sky130_fd_sc_hd__clkbuf_8
XTAP_TAPCELL_ROW_2_272 VGND VPWR sky130_fd_sc_hd__tapvpwrvgnd_1
XTAP_TAPCELL_ROW_2_283 VGND VPWR sky130_fd_sc_hd__tapvpwrvgnd_1
XFILLER_15_335 VGND VGND VPWR VPWR sky130_fd_sc_hd__fill_1
XTAP_TAPCELL_ROW_83_1247 VGND VPWR sky130_fd_sc_hd__tapvpwrvgnd_1
XFILLER_43_699 VGND VGND VPWR VPWR sky130_fd_sc_hd__fill_1
XFILLER_51_51 VGND VGND VPWR VPWR sky130_fd_sc_hd__decap_4
XTAP_TAPCELL_ROW_94_1387 VGND VPWR sky130_fd_sc_hd__tapvpwrvgnd_1
XTAP_TAPCELL_ROW_94_1376 VGND VPWR sky130_fd_sc_hd__tapvpwrvgnd_1
XFILLER_97_349 VGND VGND VPWR VPWR sky130_fd_sc_hd__decap_3
XFILLER_78_530 VGND VGND VPWR VPWR sky130_fd_sc_hd__fill_2
XPHY_EDGE_ROW_29_Left_147 VGND VGND VPWR VPWR sky130_fd_sc_hd__decap_3
XFILLER_78_585 VGND VGND VPWR VPWR sky130_fd_sc_hd__decap_3
XFILLER_65_202 VGND VGND VPWR VPWR sky130_fd_sc_hd__fill_1
XFILLER_65_246 VPWR VGND VPWR VGND sky130_ef_sc_hd__decap_12
XFILLER_80_205 VGND VGND VPWR VPWR sky130_fd_sc_hd__decap_6
X_5860_ _1357_ _1358_ _1359_ VGND VGND VPWR VPWR _1398_ sky130_fd_sc_hd__o21bai_1
XFILLER_18_184 VGND VGND VPWR VPWR sky130_fd_sc_hd__decap_6
XFILLER_34_622 VPWR VGND VPWR VGND sky130_ef_sc_hd__decap_12
X_4811_ _0557_ _0558_ VGND VGND VPWR VPWR _0559_ sky130_fd_sc_hd__nor2_1
X_5791_ _1328_ _1329_ _1330_ VGND VGND VPWR VPWR _1331_ sky130_fd_sc_hd__and3_1
XFILLER_21_327 VGND VGND VPWR VPWR sky130_fd_sc_hd__fill_1
XPHY_EDGE_ROW_38_Left_156 VGND VGND VPWR VPWR sky130_fd_sc_hd__decap_3
XTAP_TAPCELL_ROW_103_1494 VGND VPWR sky130_fd_sc_hd__tapvpwrvgnd_1
X_7530_ _2944_ _2945_ _2947_ _2949_ VGND VGND VPWR VPWR _2983_ sky130_fd_sc_hd__o31a_1
X_4742_ _0489_ _0490_ _0491_ VGND VGND VPWR VPWR _0492_ sky130_fd_sc_hd__nand3_2
X_7461_ _2913_ _2914_ VGND VGND VPWR VPWR _2916_ sky130_fd_sc_hd__xnor2_1
X_4673_ _4357_ _4397_ _4396_ VGND VGND VPWR VPWR _4434_ sky130_fd_sc_hd__a21oi_1
X_6412_ net175 _1934_ VGND VGND VPWR VPWR _1935_ sky130_fd_sc_hd__xnor2_1
X_9200_ clknet_leaf_47_clk _0312_ VGND VGND VPWR VPWR pe_array\[1\].u_pe.accum_reg\[18\]
+ sky130_fd_sc_hd__dfxtp_1
X_7392_ net407 pe_array\[1\].u_pe.accum_reg\[19\] net229 _2849_ VGND VGND VPWR VPWR
+ _2850_ sky130_fd_sc_hd__o2bb2a_4
XFILLER_115_421 VGND VGND VPWR VPWR sky130_fd_sc_hd__decap_3
X_6343_ _1867_ _1868_ VGND VGND VPWR VPWR _1869_ sky130_fd_sc_hd__xor2_2
X_9131_ clknet_leaf_27_clk _0243_ VGND VGND VPWR VPWR pe_array\[0\].u_pe.accum_reg\[17\]
+ sky130_fd_sc_hd__dfxtp_1
X_9062_ clknet_leaf_7_clk _0174_ VGND VGND VPWR VPWR net136 sky130_fd_sc_hd__dfxtp_1
X_6274_ _1799_ _1800_ _1801_ VGND VGND VPWR VPWR _1802_ sky130_fd_sc_hd__and3_1
XPHY_EDGE_ROW_47_Left_165 VGND VGND VPWR VPWR sky130_fd_sc_hd__decap_3
XFILLER_69_530 VPWR VGND VPWR VGND sky130_ef_sc_hd__decap_12
X_8013_ net321 _3334_ _3366_ _3368_ VGND VGND VPWR VPWR _3406_ sky130_fd_sc_hd__o2bb2ai_1
X_5225_ _0959_ _0960_ VGND VGND VPWR VPWR _0961_ sky130_fd_sc_hd__nor2_1
XFILLER_111_671 VGND VGND VPWR VPWR sky130_fd_sc_hd__fill_1
XFILLER_56_213 VGND VGND VPWR VPWR sky130_fd_sc_hd__decap_4
XFILLER_56_29 VPWR VGND VPWR VGND sky130_ef_sc_hd__decap_12
X_5156_ _0839_ _0868_ VGND VGND VPWR VPWR _0895_ sky130_fd_sc_hd__and2_1
XFILLER_29_405 VGND VGND VPWR VPWR sky130_fd_sc_hd__decap_8
XFILLER_110_192 VGND VGND VPWR VPWR sky130_fd_sc_hd__decap_4
XFILLER_84_533 VGND VGND VPWR VPWR sky130_fd_sc_hd__decap_8
X_5087_ net183 _0826_ _0827_ VGND VGND VPWR VPWR _0828_ sky130_fd_sc_hd__or3_1
XTAP_TAPCELL_ROW_55_915 VGND VPWR sky130_fd_sc_hd__tapvpwrvgnd_1
X_8915_ clknet_leaf_68_clk _0027_ VGND VGND VPWR VPWR pe_array\[3\].u_pe.accum_reg\[15\]
+ sky130_fd_sc_hd__dfxtp_1
XFILLER_37_460 VGND VGND VPWR VPWR sky130_fd_sc_hd__decap_4
XTAP_TAPCELL_ROW_69_1080 VGND VPWR sky130_fd_sc_hd__tapvpwrvgnd_1
XFILLER_25_611 VGND VGND VPWR VPWR sky130_fd_sc_hd__decap_4
X_8846_ net209 _3578_ VGND VGND VPWR VPWR _4204_ sky130_fd_sc_hd__nand2_1
XPHY_EDGE_ROW_56_Left_174 VGND VGND VPWR VPWR sky130_fd_sc_hd__decap_3
X_8777_ _4146_ _4147_ VGND VGND VPWR VPWR _4149_ sky130_fd_sc_hd__xnor2_1
X_5989_ net644 net349 VGND VGND VPWR VPWR _1524_ sky130_fd_sc_hd__nand2_1
XFILLER_52_485 VGND VGND VPWR VPWR sky130_fd_sc_hd__fill_2
XFILLER_25_699 VGND VGND VPWR VPWR sky130_fd_sc_hd__fill_1
XTAP_TAPCELL_ROW_35_672 VGND VPWR sky130_fd_sc_hd__tapvpwrvgnd_1
X_7728_ net426 _3173_ VGND VGND VPWR VPWR _0325_ sky130_fd_sc_hd__nor2_1
XFILLER_8_309 VGND VGND VPWR VPWR sky130_fd_sc_hd__decap_8
XFILLER_20_382 VPWR VGND VPWR VGND sky130_ef_sc_hd__decap_12
X_7659_ pe_array\[1\].u_pe.accum_reg\[29\] net550 net341 VGND VGND VPWR VPWR _3107_
+ sky130_fd_sc_hd__and3_1
XFILLER_108_3 VPWR VGND VPWR VGND sky130_ef_sc_hd__decap_12
XPHY_EDGE_ROW_65_Left_183 VGND VGND VPWR VPWR sky130_fd_sc_hd__decap_3
XFILLER_97_25 VPWR VGND VPWR VGND sky130_ef_sc_hd__decap_12
XFILLER_106_487 VGND VGND VPWR VPWR sky130_fd_sc_hd__decap_8
XTAP_TAPCELL_ROW_7_342 VGND VPWR sky130_fd_sc_hd__tapvpwrvgnd_1
XFILLER_87_393 VPWR VGND VPWR VGND sky130_ef_sc_hd__decap_12
XFILLER_90_514 VGND VGND VPWR VPWR sky130_fd_sc_hd__fill_1
XFILLER_75_588 VGND VGND VPWR VPWR sky130_fd_sc_hd__decap_3
XFILLER_47_279 VGND VGND VPWR VPWR sky130_fd_sc_hd__fill_1
XPHY_EDGE_ROW_74_Left_192 VGND VGND VPWR VPWR sky130_fd_sc_hd__decap_3
XFILLER_28_471 VGND VGND VPWR VPWR sky130_fd_sc_hd__decap_4
XFILLER_15_176 VPWR VGND VPWR VGND sky130_ef_sc_hd__decap_12
XFILLER_43_496 VGND VGND VPWR VPWR sky130_fd_sc_hd__decap_8
XFILLER_30_135 VGND VGND VPWR VPWR sky130_fd_sc_hd__decap_4
XTAP_TAPCELL_ROW_96_1405 VGND VPWR sky130_fd_sc_hd__tapvpwrvgnd_1
XFILLER_11_393 VPWR VGND VPWR VGND sky130_ef_sc_hd__decap_12
XFILLER_109_281 VPWR VGND VPWR VGND sky130_ef_sc_hd__decap_12
XFILLER_112_457 VGND VGND VPWR VPWR sky130_fd_sc_hd__decap_6
XFILLER_98_669 VPWR VGND VPWR VGND sky130_ef_sc_hd__decap_12
XFILLER_97_157 VGND VGND VPWR VPWR sky130_fd_sc_hd__fill_1
X_5010_ net283 _0750_ _0751_ VGND VGND VPWR VPWR _0753_ sky130_fd_sc_hd__or3_4
XFILLER_85_319 VPWR VGND VPWR VGND sky130_ef_sc_hd__decap_12
XFILLER_66_500 VGND VGND VPWR VPWR sky130_fd_sc_hd__decap_8
XFILLER_23_3 VPWR VGND VPWR VGND sky130_ef_sc_hd__decap_12
Xclone141 net281 VGND VGND VPWR VPWR net656 sky130_fd_sc_hd__clkbuf_2
XFILLER_66_533 VPWR VGND VPWR VGND sky130_ef_sc_hd__decap_12
XFILLER_93_363 VGND VGND VPWR VPWR sky130_fd_sc_hd__decap_8
XFILLER_81_503 VGND VGND VPWR VPWR sky130_fd_sc_hd__fill_1
XTAP_TAPCELL_ROW_105_1512 VGND VPWR sky130_fd_sc_hd__tapvpwrvgnd_1
X_8700_ net188 _4072_ VGND VGND VPWR VPWR _4074_ sky130_fd_sc_hd__and2_1
X_6961_ _2427_ _2428_ _2377_ _2379_ VGND VGND VPWR VPWR _2430_ sky130_fd_sc_hd__a211o_1
X_5912_ _1392_ _1400_ _1399_ VGND VGND VPWR VPWR _1449_ sky130_fd_sc_hd__a21bo_1
X_6892_ _2320_ _2360_ VGND VGND VPWR VPWR _2362_ sky130_fd_sc_hd__xor2_1
X_8631_ _3983_ _3978_ _4007_ VGND VGND VPWR VPWR _4008_ sky130_fd_sc_hd__a21o_1
X_5843_ net497 net348 _1354_ _1353_ VGND VGND VPWR VPWR _1381_ sky130_fd_sc_hd__a31o_1
XFILLER_61_271 VGND VGND VPWR VPWR sky130_fd_sc_hd__fill_2
X_8562_ _3939_ _3940_ VGND VGND VPWR VPWR _3941_ sky130_fd_sc_hd__nor2_1
XFILLER_21_135 VGND VGND VPWR VPWR sky130_fd_sc_hd__decap_3
XTAP_TAPCELL_ROW_32_642 VGND VPWR sky130_fd_sc_hd__tapvpwrvgnd_1
X_5774_ net512 net346 _1288_ _1290_ VGND VGND VPWR VPWR _1314_ sky130_fd_sc_hd__a211oi_1
XTAP_TAPCELL_ROW_60_973 VGND VPWR sky130_fd_sc_hd__tapvpwrvgnd_1
X_7513_ pe_array\[1\].u_pe.accum_reg\[24\] _2367_ VGND VGND VPWR VPWR _2966_ sky130_fd_sc_hd__nor2_1
X_8493_ net160 _3844_ _3843_ VGND VGND VPWR VPWR _3874_ sky130_fd_sc_hd__a21oi_1
X_4725_ _0473_ _0474_ VGND VGND VPWR VPWR _0475_ sky130_fd_sc_hd__xor2_1
X_7444_ _2869_ _2899_ VGND VGND VPWR VPWR _2900_ sky130_fd_sc_hd__xnor2_2
X_4656_ _4398_ _4416_ _4414_ VGND VGND VPWR VPWR _4418_ sky130_fd_sc_hd__or3_4
XTAP_TAPCELL_ROW_116_1641 VGND VPWR sky130_fd_sc_hd__tapvpwrvgnd_1
X_7375_ _2830_ _2831_ _2832_ VGND VGND VPWR VPWR _2833_ sky130_fd_sc_hd__and3_1
X_4587_ _4319_ _4320_ _4318_ VGND VGND VPWR VPWR _4351_ sky130_fd_sc_hd__o21ba_4
X_9114_ clknet_leaf_21_clk _0226_ VGND VGND VPWR VPWR pe_array\[0\].u_pe.accum_reg\[0\]
+ sky130_fd_sc_hd__dfxtp_1
X_6326_ _1818_ net203 _1816_ VGND VGND VPWR VPWR _1852_ sky130_fd_sc_hd__a21o_1
XFILLER_107_57 VPWR VGND VPWR VGND sky130_ef_sc_hd__decap_12
X_9045_ clknet_leaf_10_clk _0157_ VGND VGND VPWR VPWR net118 sky130_fd_sc_hd__dfxtp_1
XFILLER_89_669 VGND VGND VPWR VPWR sky130_fd_sc_hd__decap_3
X_6257_ _1781_ _1782_ net706 VGND VGND VPWR VPWR _1785_ sky130_fd_sc_hd__o21ai_1
XFILLER_67_28 VGND VGND VPWR VPWR sky130_fd_sc_hd__decap_4
XFILLER_88_168 VGND VGND VPWR VPWR sky130_fd_sc_hd__decap_4
X_6188_ _1600_ _1644_ net157 VGND VGND VPWR VPWR _1718_ sky130_fd_sc_hd__o21ai_2
X_5208_ _0942_ _0943_ VGND VGND VPWR VPWR _0945_ sky130_fd_sc_hd__xnor2_1
XTAP_TAPCELL_ROW_4_301 VGND VPWR sky130_fd_sc_hd__tapvpwrvgnd_1
XFILLER_111_490 VGND VGND VPWR VPWR sky130_fd_sc_hd__decap_8
X_5139_ _0875_ _0876_ _0846_ _0847_ VGND VGND VPWR VPWR _0878_ sky130_fd_sc_hd__a211o_1
XFILLER_84_363 VGND VGND VPWR VPWR sky130_fd_sc_hd__fill_1
XFILLER_84_341 VGND VGND VPWR VPWR sky130_fd_sc_hd__fill_1
XFILLER_57_577 VGND VGND VPWR VPWR sky130_fd_sc_hd__fill_1
XFILLER_29_279 VGND VGND VPWR VPWR sky130_fd_sc_hd__fill_1
XFILLER_44_249 VGND VGND VPWR VPWR sky130_fd_sc_hd__decap_3
X_8829_ net946 net215 _4195_ net388 VGND VGND VPWR VPWR _0404_ sky130_fd_sc_hd__o211a_1
XTAP_TAPCELL_ROW_80_1217 VGND VPWR sky130_fd_sc_hd__tapvpwrvgnd_1
XFILLER_40_499 VGND VGND VPWR VPWR sky130_fd_sc_hd__fill_1
XTAP_TAPCELL_ROW_10_369 VGND VPWR sky130_fd_sc_hd__tapvpwrvgnd_1
XFILLER_106_251 VGND VGND VPWR VPWR sky130_fd_sc_hd__fill_1
XFILLER_4_345 VGND VGND VPWR VPWR sky130_fd_sc_hd__decap_8
XFILLER_106_284 VPWR VGND VPWR VGND sky130_ef_sc_hd__decap_12
XTAP_TAPCELL_ROW_91_1346 VGND VPWR sky130_fd_sc_hd__tapvpwrvgnd_1
XFILLER_95_617 VGND VGND VPWR VPWR sky130_fd_sc_hd__fill_2
XFILLER_94_105 VPWR VGND VPWR VGND sky130_ef_sc_hd__decap_12
XFILLER_0_573 VPWR VGND VPWR VGND sky130_ef_sc_hd__decap_12
XFILLER_48_511 VGND VGND VPWR VPWR sky130_fd_sc_hd__fill_2
XFILLER_94_138 VGND VGND VPWR VPWR sky130_fd_sc_hd__fill_2
XPHY_EDGE_ROW_82_Left_200 VGND VGND VPWR VPWR sky130_fd_sc_hd__decap_3
XFILLER_48_533 VGND VGND VPWR VPWR sky130_fd_sc_hd__decap_6
XFILLER_75_363 VGND VGND VPWR VPWR sky130_fd_sc_hd__fill_2
XFILLER_48_555 VGND VGND VPWR VPWR sky130_fd_sc_hd__fill_1
XFILLER_48_577 VGND VGND VPWR VPWR sky130_fd_sc_hd__decap_3
XFILLER_75_385 VGND VGND VPWR VPWR sky130_fd_sc_hd__decap_3
XFILLER_35_249 VPWR VGND VPWR VGND sky130_ef_sc_hd__decap_12
XFILLER_90_388 VPWR VGND VPWR VGND sky130_ef_sc_hd__decap_12
XTAP_TAPCELL_ROW_18_469 VGND VPWR sky130_fd_sc_hd__tapvpwrvgnd_1
XTAP_TAPCELL_ROW_100_1453 VGND VPWR sky130_fd_sc_hd__tapvpwrvgnd_1
XFILLER_117_505 VGND VGND VPWR VPWR sky130_fd_sc_hd__decap_6
X_5490_ net933 net247 _1205_ net365 VGND VGND VPWR VPWR _0055_ sky130_fd_sc_hd__o211a_1
X_4510_ net427 _4276_ VGND VGND VPWR VPWR _0014_ sky130_fd_sc_hd__nor2_1
XFILLER_7_183 VGND VGND VPWR VPWR sky130_fd_sc_hd__fill_1
XPHY_EDGE_ROW_9_Right_9 VGND VGND VPWR VPWR sky130_fd_sc_hd__decap_3
X_7160_ _2622_ _2623_ VGND VGND VPWR VPWR _2624_ sky130_fd_sc_hd__or2_1
X_6111_ net466 _4232_ VGND VGND VPWR VPWR _1643_ sky130_fd_sc_hd__nor2_1
X_7091_ _2541_ _2555_ _2556_ VGND VGND VPWR VPWR _2557_ sky130_fd_sc_hd__nand3_2
XTAP_TAPCELL_ROW_111_1582 VGND VPWR sky130_fd_sc_hd__tapvpwrvgnd_1
XPHY_EDGE_ROW_107_Right_107 VGND VGND VPWR VPWR sky130_fd_sc_hd__decap_3
XFILLER_98_477 VGND VGND VPWR VPWR sky130_fd_sc_hd__decap_8
X_6042_ _1572_ _1573_ _1526_ _1528_ VGND VGND VPWR VPWR _1576_ sky130_fd_sc_hd__a211o_1
XFILLER_66_363 VGND VGND VPWR VPWR sky130_fd_sc_hd__fill_1
X_7993_ _3382_ _3386_ VGND VGND VPWR VPWR _3387_ sky130_fd_sc_hd__and2_1
XTAP_TAPCELL_ROW_37_701 VGND VPWR sky130_fd_sc_hd__tapvpwrvgnd_1
XFILLER_39_588 VGND VGND VPWR VPWR sky130_fd_sc_hd__decap_6
X_6944_ net449 net337 VGND VGND VPWR VPWR _2413_ sky130_fd_sc_hd__nand2_8
XTAP_TAPCELL_ROW_66_1050 VGND VPWR sky130_fd_sc_hd__tapvpwrvgnd_1
X_8614_ _3989_ _3990_ VGND VGND VPWR VPWR _3991_ sky130_fd_sc_hd__nor2_1
X_6875_ _2344_ _2345_ VGND VGND VPWR VPWR _2346_ sky130_fd_sc_hd__and2b_1
X_5826_ _1362_ _1363_ _1356_ VGND VGND VPWR VPWR _1365_ sky130_fd_sc_hd__a21o_1
X_8545_ net600 _3891_ _3921_ _3922_ VGND VGND VPWR VPWR _3924_ sky130_fd_sc_hd__o211ai_1
X_5757_ _1269_ _1270_ _1296_ _1297_ VGND VGND VPWR VPWR _1298_ sky130_fd_sc_hd__o211ai_1
X_8476_ net262 _3855_ _3856_ VGND VGND VPWR VPWR _3857_ sky130_fd_sc_hd__nor3_1
XFILLER_5_109 VGND VGND VPWR VPWR sky130_fd_sc_hd__decap_3
X_4708_ _0456_ _0457_ _4434_ VGND VGND VPWR VPWR _0459_ sky130_fd_sc_hd__o21ai_1
Xrebuffer225 net746 VGND VGND VPWR VPWR net740 sky130_fd_sc_hd__buf_1
X_5688_ net508 pe_array\[0\].u_pe.tap_count\[1\] pe_array\[0\].u_pe.tap_count\[0\]
+ VGND VGND VPWR VPWR _1236_ sky130_fd_sc_hd__and3_1
X_7427_ net269 _2880_ _2881_ VGND VGND VPWR VPWR _2883_ sky130_fd_sc_hd__or3_1
X_4639_ net304 pe_array\[3\].u_pe.weight_in\[2\] net471 net461 VGND VGND VPWR VPWR
+ _4401_ sky130_fd_sc_hd__and4_1
XFILLER_116_560 VPWR VGND VPWR VGND sky130_ef_sc_hd__decap_12
XFILLER_78_27 VGND VGND VPWR VPWR sky130_fd_sc_hd__fill_1
X_7358_ _2788_ _2816_ VGND VGND VPWR VPWR _2817_ sky130_fd_sc_hd__xor2_1
XFILLER_103_210 VPWR VGND VPWR VGND sky130_ef_sc_hd__decap_12
X_6309_ _1802_ _1834_ VGND VGND VPWR VPWR _1836_ sky130_fd_sc_hd__xnor2_2
XFILLER_77_606 VGND VGND VPWR VPWR sky130_fd_sc_hd__decap_8
XFILLER_1_337 VGND VGND VPWR VPWR sky130_fd_sc_hd__decap_4
X_7289_ _2747_ _2748_ net169 VGND VGND VPWR VPWR _2750_ sky130_fd_sc_hd__a21o_1
XFILLER_77_617 VPWR VGND VPWR VGND sky130_ef_sc_hd__decap_12
X_9028_ clknet_leaf_45_clk _0140_ VGND VGND VPWR VPWR net99 sky130_fd_sc_hd__dfxtp_1
XFILLER_72_322 VGND VGND VPWR VPWR sky130_fd_sc_hd__fill_1
XFILLER_84_193 VGND VGND VPWR VPWR sky130_fd_sc_hd__decap_3
XFILLER_72_355 VGND VGND VPWR VPWR sky130_fd_sc_hd__decap_3
XFILLER_17_238 VGND VGND VPWR VPWR sky130_fd_sc_hd__decap_8
XFILLER_27_64 VGND VGND VPWR VPWR sky130_fd_sc_hd__decap_4
XFILLER_60_517 VGND VGND VPWR VPWR sky130_fd_sc_hd__fill_1
XTAP_TAPCELL_ROW_15_428 VGND VPWR sky130_fd_sc_hd__tapvpwrvgnd_1
XTAP_TAPCELL_ROW_15_439 VGND VPWR sky130_fd_sc_hd__tapvpwrvgnd_1
XFILLER_25_293 VGND VGND VPWR VPWR sky130_fd_sc_hd__decap_8
XFILLER_40_241 VGND VGND VPWR VPWR sky130_fd_sc_hd__fill_1
XFILLER_43_85 VGND VGND VPWR VPWR sky130_fd_sc_hd__fill_1
XFILLER_5_610 VGND VGND VPWR VPWR sky130_fd_sc_hd__decap_6
XFILLER_5_665 VGND VGND VPWR VPWR sky130_fd_sc_hd__decap_6
XFILLER_4_197 VGND VGND VPWR VPWR sky130_fd_sc_hd__decap_3
XFILLER_68_82 VGND VGND VPWR VPWR sky130_fd_sc_hd__fill_2
XFILLER_67_116 VGND VGND VPWR VPWR sky130_fd_sc_hd__decap_4
XFILLER_82_108 VPWR VGND VPWR VGND sky130_ef_sc_hd__decap_12
XFILLER_76_683 VPWR VGND VPWR VGND sky130_ef_sc_hd__decap_12
XFILLER_36_536 VGND VGND VPWR VPWR sky130_fd_sc_hd__decap_4
XFILLER_36_558 VGND VGND VPWR VPWR sky130_fd_sc_hd__decap_3
XFILLER_91_697 VGND VGND VPWR VPWR sky130_fd_sc_hd__decap_3
X_4990_ _0731_ _0732_ net184 VGND VGND VPWR VPWR _0734_ sky130_fd_sc_hd__o21ai_1
X_6660_ _2140_ _2143_ _2173_ VGND VGND VPWR VPWR _2175_ sky130_fd_sc_hd__nor3_1
XFILLER_90_3 VGND VGND VPWR VPWR sky130_fd_sc_hd__fill_1
X_5611_ net946 net387 VGND VGND VPWR VPWR _0152_ sky130_fd_sc_hd__and2_1
X_6591_ _2106_ _2107_ VGND VGND VPWR VPWR _2108_ sky130_fd_sc_hd__nor2_1
X_5542_ pe_array\[0\].u_pe.tap_count\[2\] pe_array\[0\].u_pe.tap_count\[1\] pe_array\[0\].u_pe.tap_count\[0\]
+ pe_array\[0\].u_pe.tap_count\[3\] VGND VGND VPWR VPWR _1228_ sky130_fd_sc_hd__or4b_1
X_8330_ net161 _3714_ _3715_ VGND VGND VPWR VPWR _3716_ sky130_fd_sc_hd__or3_4
XFILLER_31_296 VGND VGND VPWR VPWR sky130_fd_sc_hd__decap_6
X_8261_ net676 _3606_ _3647_ _3648_ VGND VGND VPWR VPWR _3649_ sky130_fd_sc_hd__a211oi_4
X_5473_ net252 _4296_ VGND VGND VPWR VPWR _1197_ sky130_fd_sc_hd__nand2_1
XTAP_TAPCELL_ROW_113_1611 VGND VPWR sky130_fd_sc_hd__tapvpwrvgnd_1
X_8192_ net443 net312 _3419_ _3417_ VGND VGND VPWR VPWR _3581_ sky130_fd_sc_hd__a31o_4
X_7212_ net193 _2672_ _2674_ VGND VGND VPWR VPWR _2675_ sky130_fd_sc_hd__or3b_1
Xfanout405 _4225_ VGND VGND VPWR VPWR net405 sky130_fd_sc_hd__clkbuf_4
X_7143_ _2605_ _2606_ _2559_ _2561_ VGND VGND VPWR VPWR _2608_ sky130_fd_sc_hd__a211o_1
XFILLER_59_617 VPWR VGND VPWR VGND sky130_ef_sc_hd__decap_12
Xfanout427 net9 VGND VGND VPWR VPWR net427 sky130_fd_sc_hd__buf_4
Xfanout416 net418 VGND VGND VPWR VPWR net416 sky130_fd_sc_hd__clkbuf_4
X_7074_ _2531_ _2539_ VGND VGND VPWR VPWR _2540_ sky130_fd_sc_hd__nand2b_1
Xfanout438 net602 VGND VGND VPWR VPWR net438 sky130_fd_sc_hd__buf_8
XFILLER_113_585 VPWR VGND VPWR VGND sky130_ef_sc_hd__decap_12
XFILLER_58_138 VGND VGND VPWR VPWR sky130_fd_sc_hd__fill_2
Xfanout449 net450 VGND VGND VPWR VPWR net449 sky130_fd_sc_hd__buf_8
X_6025_ net871 net466 net347 net345 VGND VGND VPWR VPWR _1559_ sky130_fd_sc_hd__and4_1
XFILLER_104_47 VGND VGND VPWR VPWR sky130_fd_sc_hd__fill_1
XFILLER_73_119 VGND VGND VPWR VPWR sky130_fd_sc_hd__decap_3
XFILLER_66_193 VGND VGND VPWR VPWR sky130_fd_sc_hd__decap_3
XFILLER_64_29 VPWR VGND VPWR VGND sky130_ef_sc_hd__decap_12
XFILLER_27_558 VGND VGND VPWR VPWR sky130_fd_sc_hd__fill_2
XFILLER_82_675 VPWR VGND VPWR VGND sky130_ef_sc_hd__decap_12
X_7976_ pe_array\[2\].u_pe.accum_reg\[7\] pe_array\[2\].u_pe.weight_in\[7\] VGND VGND
+ VPWR VPWR _3370_ sky130_fd_sc_hd__and2_1
XFILLER_42_539 VGND VGND VPWR VPWR sky130_fd_sc_hd__decap_8
X_6927_ _2355_ _2359_ _2361_ VGND VGND VPWR VPWR _2396_ sky130_fd_sc_hd__a21o_1
X_6858_ _2324_ _2328_ VGND VGND VPWR VPWR _2329_ sky130_fd_sc_hd__xnor2_1
XFILLER_22_241 VGND VGND VPWR VPWR sky130_fd_sc_hd__decap_8
X_5809_ _1345_ _1347_ VGND VGND VPWR VPWR _1348_ sky130_fd_sc_hd__nand2_1
XFILLER_13_33 VGND VGND VPWR VPWR sky130_fd_sc_hd__fill_1
XTAP_TAPCELL_ROW_40_729 VGND VPWR sky130_fd_sc_hd__tapvpwrvgnd_1
X_8528_ net159 _3907_ VGND VGND VPWR VPWR _3908_ sky130_fd_sc_hd__xnor2_2
X_6789_ _2260_ _2261_ VGND VGND VPWR VPWR _2262_ sky130_fd_sc_hd__nor2_1
XFILLER_6_407 VPWR VGND VPWR VGND sky130_ef_sc_hd__decap_12
XFILLER_89_48 VGND VGND VPWR VPWR sky130_fd_sc_hd__decap_8
X_8459_ _3838_ _3839_ net176 VGND VGND VPWR VPWR _3841_ sky130_fd_sc_hd__a21o_1
XTAP_TAPCELL_ROW_20_497 VGND VPWR sky130_fd_sc_hd__tapvpwrvgnd_1
XTAP_TAPCELL_ROW_75_1149 VGND VPWR sky130_fd_sc_hd__tapvpwrvgnd_1
XFILLER_2_613 VPWR VGND VPWR VGND sky130_ef_sc_hd__decap_12
Xhold481 pe_accum\[2\]\[16\] VGND VGND VPWR VPWR net996 sky130_fd_sc_hd__dlygate4sd3_1
Xhold470 pe_accum\[1\]\[15\] VGND VGND VPWR VPWR net985 sky130_fd_sc_hd__dlygate4sd3_1
XFILLER_2_657 VPWR VGND VPWR VGND sky130_ef_sc_hd__decap_12
Xhold492 pe_accum\[3\]\[20\] VGND VGND VPWR VPWR net1007 sky130_fd_sc_hd__dlygate4sd3_1
XFILLER_104_585 VGND VGND VPWR VPWR sky130_fd_sc_hd__decap_3
XFILLER_38_41 VPWR VGND VPWR VGND sky130_ef_sc_hd__decap_12
XFILLER_92_439 VGND VGND VPWR VPWR sky130_fd_sc_hd__decap_8
XFILLER_73_620 VPWR VGND VPWR VGND sky130_ef_sc_hd__decap_12
XFILLER_38_85 VPWR VGND VPWR VGND sky130_ef_sc_hd__decap_12
XTAP_TAPCELL_ROW_48_829 VGND VPWR sky130_fd_sc_hd__tapvpwrvgnd_1
XTAP_TAPCELL_ROW_86_1289 VGND VPWR sky130_fd_sc_hd__tapvpwrvgnd_1
XFILLER_72_141 VGND VGND VPWR VPWR sky130_fd_sc_hd__fill_1
XFILLER_45_377 VGND VGND VPWR VPWR sky130_fd_sc_hd__fill_2
XFILLER_60_336 VGND VGND VPWR VPWR sky130_fd_sc_hd__fill_1
XTAP_TAPCELL_ROW_28_586 VGND VPWR sky130_fd_sc_hd__tapvpwrvgnd_1
XFILLER_33_539 VGND VGND VPWR VPWR sky130_fd_sc_hd__decap_8
XFILLER_9_223 VGND VGND VPWR VPWR sky130_fd_sc_hd__fill_1
XFILLER_70_61 VGND VGND VPWR VPWR sky130_fd_sc_hd__decap_3
Xclkload15 clknet_leaf_54_clk VGND VGND VPWR VPWR clkload15/Y sky130_fd_sc_hd__clkinv_2
Xclkload26 clknet_leaf_50_clk VGND VGND VPWR VPWR clkload26/Y sky130_fd_sc_hd__inv_8
Xclkload48 clknet_leaf_29_clk VGND VGND VPWR VPWR clkload48/Y sky130_fd_sc_hd__clkinv_4
Xclkload37 clknet_leaf_17_clk VGND VGND VPWR VPWR clkload37/Y sky130_fd_sc_hd__inv_12
XFILLER_62_7 VPWR VGND VPWR VGND sky130_ef_sc_hd__decap_12
XFILLER_5_473 VGND VGND VPWR VPWR sky130_fd_sc_hd__decap_6
XFILLER_79_70 VGND VGND VPWR VPWR sky130_fd_sc_hd__decap_4
XPHY_EDGE_ROW_10_Left_128 VGND VGND VPWR VPWR sky130_fd_sc_hd__decap_3
XFILLER_110_533 VGND VGND VPWR VPWR sky130_fd_sc_hd__fill_2
X_7830_ net423 _3229_ VGND VGND VPWR VPWR _0371_ sky130_fd_sc_hd__nor2_1
XFILLER_36_344 VGND VGND VPWR VPWR sky130_fd_sc_hd__decap_3
X_7761_ net221 _2764_ VGND VGND VPWR VPWR _3190_ sky130_fd_sc_hd__nand2_1
X_4973_ net415 _0717_ VGND VGND VPWR VPWR _0026_ sky130_fd_sc_hd__nor2_1
X_6712_ net908 net235 _2010_ net243 VGND VGND VPWR VPWR _0282_ sky130_fd_sc_hd__o2bb2ai_1
X_7692_ _3107_ _3108_ _3138_ VGND VGND VPWR VPWR _3139_ sky130_fd_sc_hd__or3_1
X_6643_ _2157_ _2158_ VGND VGND VPWR VPWR _2159_ sky130_fd_sc_hd__xor2_2
XFILLER_32_561 VGND VGND VPWR VPWR sky130_fd_sc_hd__fill_2
Xclkload9 clknet_leaf_58_clk VGND VGND VPWR VPWR clkload9/Y sky130_fd_sc_hd__inv_8
X_6574_ _2060_ _2087_ VGND VGND VPWR VPWR _2091_ sky130_fd_sc_hd__nand2_1
X_9293_ clknet_leaf_10_clk _0405_ VGND VGND VPWR VPWR pe_accum\[2\]\[3\] sky130_fd_sc_hd__dfxtp_1
X_8313_ _3580_ _3664_ _3666_ VGND VGND VPWR VPWR _3699_ sky130_fd_sc_hd__o21ai_2
X_5525_ _1155_ net251 VGND VGND VPWR VPWR _1223_ sky130_fd_sc_hd__nand2_1
X_8244_ _3631_ _3630_ VGND VGND VPWR VPWR _3632_ sky130_fd_sc_hd__and2b_1
X_5456_ pe_array\[3\].u_pe.accum_reg\[31\] _1183_ VGND VGND VPWR VPWR _1184_ sky130_fd_sc_hd__xnor2_1
XFILLER_105_349 VPWR VGND VPWR VGND sky130_ef_sc_hd__decap_12
Xfanout213 net216 VGND VGND VPWR VPWR net213 sky130_fd_sc_hd__buf_2
XFILLER_99_561 VPWR VGND VPWR VGND sky130_ef_sc_hd__decap_12
Xfanout202 net203 VGND VGND VPWR VPWR net202 sky130_fd_sc_hd__buf_4
X_8175_ _3548_ _3564_ _3563_ VGND VGND VPWR VPWR _3565_ sky130_fd_sc_hd__and3_4
X_5387_ _1117_ _1116_ VGND VGND VPWR VPWR _1118_ sky130_fd_sc_hd__and2b_1
XFILLER_113_382 VGND VGND VPWR VPWR sky130_fd_sc_hd__decap_8
Xfanout235 net237 VGND VGND VPWR VPWR net235 sky130_fd_sc_hd__clkbuf_2
Xfanout224 net228 VGND VGND VPWR VPWR net224 sky130_fd_sc_hd__buf_2
Xfanout246 net247 VGND VGND VPWR VPWR net246 sky130_fd_sc_hd__buf_2
X_7126_ net541 _2546_ _2589_ _2590_ VGND VGND VPWR VPWR _2591_ sky130_fd_sc_hd__o211a_1
XFILLER_115_57 VPWR VGND VPWR VGND sky130_ef_sc_hd__decap_12
Xfanout279 net280 VGND VGND VPWR VPWR net279 sky130_fd_sc_hd__clkbuf_2
Xfanout257 net258 VGND VGND VPWR VPWR net257 sky130_fd_sc_hd__clkbuf_2
Xfanout268 net269 VGND VGND VPWR VPWR net268 sky130_fd_sc_hd__clkbuf_2
X_7057_ _2482_ _2522_ _2523_ VGND VGND VPWR VPWR _2524_ sky130_fd_sc_hd__nor3_1
X_6008_ _1473_ _1475_ _1541_ _1542_ VGND VGND VPWR VPWR _1543_ sky130_fd_sc_hd__a211oi_1
XFILLER_46_108 VGND VGND VPWR VPWR sky130_fd_sc_hd__fill_2
XFILLER_55_653 VPWR VGND VPWR VGND sky130_ef_sc_hd__decap_12
XFILLER_54_130 VGND VGND VPWR VPWR sky130_fd_sc_hd__decap_8
XFILLER_70_601 VPWR VGND VPWR VGND sky130_ef_sc_hd__decap_12
X_7959_ _3351_ _3352_ _3306_ _3311_ VGND VGND VPWR VPWR _3354_ sky130_fd_sc_hd__a211o_1
XFILLER_70_645 VPWR VGND VPWR VGND sky130_ef_sc_hd__decap_12
XFILLER_70_667 VGND VGND VPWR VPWR sky130_fd_sc_hd__decap_6
XTAP_TAPCELL_ROW_25_556 VGND VPWR sky130_fd_sc_hd__tapvpwrvgnd_1
XTAP_TAPCELL_ROW_53_887 VGND VPWR sky130_fd_sc_hd__tapvpwrvgnd_1
XFILLER_23_561 VGND VGND VPWR VPWR sky130_fd_sc_hd__fill_2
XFILLER_24_76 VGND VGND VPWR VPWR sky130_fd_sc_hd__fill_2
XFILLER_50_391 VPWR VGND VPWR VGND sky130_ef_sc_hd__decap_12
XFILLER_10_277 VPWR VGND VPWR VGND sky130_ef_sc_hd__decap_12
XFILLER_40_20 VGND VGND VPWR VPWR sky130_fd_sc_hd__decap_8
XFILLER_2_421 VPWR VGND VPWR VGND sky130_ef_sc_hd__decap_12
XFILLER_111_308 VPWR VGND VPWR VGND sky130_ef_sc_hd__decap_12
XFILLER_49_51 VGND VGND VPWR VPWR sky130_fd_sc_hd__decap_4
XTAP_TAPCELL_ROW_88_1307 VGND VPWR sky130_fd_sc_hd__tapvpwrvgnd_1
XFILLER_1_69 VPWR VGND VPWR VGND sky130_ef_sc_hd__decap_12
XFILLER_61_612 VGND VGND VPWR VPWR sky130_fd_sc_hd__decap_4
XFILLER_18_377 VPWR VGND VPWR VGND sky130_ef_sc_hd__decap_12
XFILLER_46_675 VGND VGND VPWR VPWR sky130_fd_sc_hd__decap_4
XTAP_TAPCELL_ROW_99_1436 VGND VPWR sky130_fd_sc_hd__tapvpwrvgnd_1
XFILLER_41_391 VGND VGND VPWR VPWR sky130_fd_sc_hd__fill_1
XTAP_TAPCELL_ROW_99_1447 VGND VPWR sky130_fd_sc_hd__tapvpwrvgnd_1
X_6290_ _1781_ _1783_ net704 _1815_ VGND VGND VPWR VPWR _1817_ sky130_fd_sc_hd__o211ai_1
XFILLER_53_3 VPWR VGND VPWR VGND sky130_ef_sc_hd__decap_12
X_5310_ _1013_ _1015_ VGND VGND VPWR VPWR _1043_ sky130_fd_sc_hd__nand2b_1
X_5241_ _0947_ _0951_ _0946_ VGND VGND VPWR VPWR _0977_ sky130_fd_sc_hd__o21ba_4
XFILLER_102_319 VGND VGND VPWR VPWR sky130_fd_sc_hd__decap_8
XFILLER_96_531 VGND VGND VPWR VPWR sky130_fd_sc_hd__fill_1
X_5172_ net205 _0878_ _0877_ VGND VGND VPWR VPWR _0910_ sky130_fd_sc_hd__a21oi_1
XFILLER_110_363 VGND VGND VPWR VPWR sky130_fd_sc_hd__fill_1
XFILLER_83_203 VGND VGND VPWR VPWR sky130_fd_sc_hd__fill_1
X_8931_ clknet_leaf_58_clk _0043_ VGND VGND VPWR VPWR pe_array\[3\].u_pe.accum_reg\[31\]
+ sky130_fd_sc_hd__dfxtp_1
XFILLER_28_119 VPWR VGND VPWR VGND sky130_ef_sc_hd__decap_12
Xinput2 pixel_in[1] VGND VGND VPWR VPWR net2 sky130_fd_sc_hd__buf_8
XFILLER_83_225 VGND VGND VPWR VPWR sky130_fd_sc_hd__fill_1
XTAP_TAPCELL_ROW_108_1554 VGND VPWR sky130_fd_sc_hd__tapvpwrvgnd_1
X_8862_ _3853_ net211 VGND VGND VPWR VPWR _4212_ sky130_fd_sc_hd__nand2_1
XFILLER_36_141 VGND VGND VPWR VPWR sky130_fd_sc_hd__decap_4
XFILLER_101_15 VPWR VGND VPWR VGND sky130_ef_sc_hd__decap_12
X_7813_ net403 _3208_ VGND VGND VPWR VPWR _3215_ sky130_fd_sc_hd__nor2_2
X_8793_ _4132_ _4134_ _4163_ VGND VGND VPWR VPWR _4164_ sky130_fd_sc_hd__a21oi_1
XFILLER_52_645 VPWR VGND VPWR VGND sky130_ef_sc_hd__decap_12
XFILLER_51_155 VGND VGND VPWR VPWR sky130_fd_sc_hd__decap_3
X_7744_ net964 net227 _3181_ net379 VGND VGND VPWR VPWR _0333_ sky130_fd_sc_hd__o211a_1
XFILLER_61_19 VPWR VGND VPWR VGND sky130_ef_sc_hd__decap_12
XTAP_TAPCELL_ROW_22_515 VGND VPWR sky130_fd_sc_hd__tapvpwrvgnd_1
X_4956_ _0698_ _0697_ _0699_ VGND VGND VPWR VPWR _0701_ sky130_fd_sc_hd__a21o_1
XTAP_TAPCELL_ROW_50_857 VGND VPWR sky130_fd_sc_hd__tapvpwrvgnd_1
XFILLER_20_542 VGND VGND VPWR VPWR sky130_fd_sc_hd__decap_3
X_4887_ _0631_ _0589_ _0632_ VGND VGND VPWR VPWR _0634_ sky130_fd_sc_hd__or3b_4
X_7675_ _3121_ _3122_ VGND VGND VPWR VPWR _3123_ sky130_fd_sc_hd__nor2_1
X_6626_ _2140_ _2141_ VGND VGND VPWR VPWR _2142_ sky130_fd_sc_hd__or2_1
X_6557_ _2073_ _2074_ VGND VGND VPWR VPWR _2075_ sky130_fd_sc_hd__xnor2_1
XFILLER_20_586 VGND VGND VPWR VPWR sky130_fd_sc_hd__fill_2
X_5508_ net1007 net248 _1214_ net363 VGND VGND VPWR VPWR _0064_ sky130_fd_sc_hd__o211a_1
X_6488_ _2007_ _2008_ VGND VGND VPWR VPWR _2009_ sky130_fd_sc_hd__nor2_1
XFILLER_105_113 VPWR VGND VPWR VGND sky130_ef_sc_hd__decap_12
X_9276_ clknet_leaf_5_clk _0388_ VGND VGND VPWR VPWR pe_array\[2\].u_pe.accum_reg\[18\]
+ sky130_fd_sc_hd__dfxtp_1
XTAP_TAPCELL_ROW_72_1119 VGND VPWR sky130_fd_sc_hd__tapvpwrvgnd_1
X_8227_ _3613_ _3614_ _3572_ VGND VGND VPWR VPWR _3616_ sky130_fd_sc_hd__o21ai_1
X_5439_ _1157_ _1167_ VGND VGND VPWR VPWR _1168_ sky130_fd_sc_hd__and2b_1
X_8158_ _3545_ _3546_ VGND VGND VPWR VPWR _3548_ sky130_fd_sc_hd__xnor2_1
XFILLER_86_49 VPWR VGND VPWR VGND sky130_ef_sc_hd__decap_12
X_7109_ _2535_ _2536_ _2534_ VGND VGND VPWR VPWR _2574_ sky130_fd_sc_hd__a21oi_1
X_8089_ _3477_ _3478_ _3479_ VGND VGND VPWR VPWR _3481_ sky130_fd_sc_hd__a21oi_1
XFILLER_59_288 VGND VGND VPWR VPWR sky130_fd_sc_hd__fill_1
XFILLER_19_119 VGND VGND VPWR VPWR sky130_fd_sc_hd__decap_3
XTAP_TAPCELL_ROW_58_946 VGND VPWR sky130_fd_sc_hd__tapvpwrvgnd_1
XFILLER_19_87 VPWR VGND VPWR VGND sky130_ef_sc_hd__decap_12
XFILLER_74_269 VPWR VGND VPWR VGND sky130_ef_sc_hd__decap_12
XTAP_TAPCELL_ROW_2_273 VGND VPWR sky130_fd_sc_hd__tapvpwrvgnd_1
XFILLER_28_664 VGND VGND VPWR VPWR sky130_fd_sc_hd__fill_1
XFILLER_55_483 VGND VGND VPWR VPWR sky130_fd_sc_hd__fill_2
XFILLER_42_100 VGND VGND VPWR VPWR sky130_fd_sc_hd__decap_3
XTAP_TAPCELL_ROW_83_1248 VGND VPWR sky130_fd_sc_hd__tapvpwrvgnd_1
XFILLER_70_453 VPWR VGND VPWR VGND sky130_ef_sc_hd__decap_12
XFILLER_35_53 VGND VGND VPWR VPWR sky130_fd_sc_hd__decap_3
XFILLER_30_317 VGND VGND VPWR VPWR sky130_fd_sc_hd__fill_2
XFILLER_43_689 VGND VGND VPWR VPWR sky130_fd_sc_hd__fill_2
XFILLER_7_513 VGND VGND VPWR VPWR sky130_fd_sc_hd__decap_3
XFILLER_7_557 VGND VGND VPWR VPWR sky130_fd_sc_hd__decap_3
XFILLER_109_485 VPWR VGND VPWR VGND sky130_ef_sc_hd__decap_12
XTAP_TAPCELL_ROW_94_1377 VGND VPWR sky130_fd_sc_hd__tapvpwrvgnd_1
XFILLER_38_417 VGND VGND VPWR VPWR sky130_fd_sc_hd__decap_3
XFILLER_76_93 VGND VGND VPWR VPWR sky130_fd_sc_hd__fill_2
XFILLER_65_225 VGND VGND VPWR VPWR sky130_fd_sc_hd__decap_3
XFILLER_65_258 VPWR VGND VPWR VGND sky130_ef_sc_hd__decap_12
XFILLER_18_141 VGND VGND VPWR VPWR sky130_fd_sc_hd__decap_8
XFILLER_46_461 VGND VGND VPWR VPWR sky130_fd_sc_hd__decap_4
XFILLER_80_239 VGND VGND VPWR VPWR sky130_fd_sc_hd__decap_4
XFILLER_61_442 VGND VGND VPWR VPWR sky130_fd_sc_hd__fill_1
X_4810_ net469 net291 net460 net289 VGND VGND VPWR VPWR _0558_ sky130_fd_sc_hd__and4_1
XFILLER_34_678 VGND VGND VPWR VPWR sky130_fd_sc_hd__fill_2
X_5790_ _1292_ _1299_ _1298_ VGND VGND VPWR VPWR _1330_ sky130_fd_sc_hd__a21bo_1
XFILLER_33_166 VGND VGND VPWR VPWR sky130_fd_sc_hd__fill_2
XTAP_TAPCELL_ROW_103_1495 VGND VPWR sky130_fd_sc_hd__tapvpwrvgnd_1
XTAP_TAPCELL_ROW_103_1484 VGND VPWR sky130_fd_sc_hd__tapvpwrvgnd_1
X_4741_ _0441_ _0447_ _0446_ VGND VGND VPWR VPWR _0491_ sky130_fd_sc_hd__a21bo_1
X_7460_ _2914_ _2913_ VGND VGND VPWR VPWR _2915_ sky130_fd_sc_hd__and2b_1
X_4672_ _4360_ _4421_ _4420_ VGND VGND VPWR VPWR _4433_ sky130_fd_sc_hd__a21bo_1
X_6411_ _1931_ _1932_ VGND VGND VPWR VPWR _1934_ sky130_fd_sc_hd__xnor2_1
X_9130_ clknet_leaf_28_clk _0242_ VGND VGND VPWR VPWR pe_array\[0\].u_pe.accum_reg\[16\]
+ sky130_fd_sc_hd__dfxtp_1
X_7391_ _2847_ _2848_ VGND VGND VPWR VPWR _2849_ sky130_fd_sc_hd__xor2_2
X_6342_ _1837_ _1840_ _1835_ VGND VGND VPWR VPWR _1868_ sky130_fd_sc_hd__o21a_1
XFILLER_103_617 VPWR VGND VPWR VGND sky130_ef_sc_hd__decap_12
X_9061_ clknet_leaf_5_clk _0173_ VGND VGND VPWR VPWR net135 sky130_fd_sc_hd__dfxtp_1
X_6273_ net157 _1769_ _1768_ VGND VGND VPWR VPWR _1801_ sky130_fd_sc_hd__o21bai_1
XFILLER_102_105 VGND VGND VPWR VPWR sky130_fd_sc_hd__fill_1
XPHY_EDGE_ROW_102_Left_220 VGND VGND VPWR VPWR sky130_fd_sc_hd__decap_3
X_8012_ _3346_ _3388_ _3387_ VGND VGND VPWR VPWR _3405_ sky130_fd_sc_hd__a21oi_1
X_5224_ _0957_ _0958_ _0926_ _0927_ VGND VGND VPWR VPWR _0960_ sky130_fd_sc_hd__a211oi_1
XFILLER_102_149 VGND VGND VPWR VPWR sky130_fd_sc_hd__fill_1
XFILLER_69_542 VGND VGND VPWR VPWR sky130_fd_sc_hd__fill_1
XFILLER_84_512 VGND VGND VPWR VPWR sky130_fd_sc_hd__decap_6
XFILLER_56_19 VGND VGND VPWR VPWR sky130_fd_sc_hd__decap_8
X_5155_ _0893_ VGND VGND VPWR VPWR _0894_ sky130_fd_sc_hd__inv_2
X_5086_ _0823_ _0824_ _0825_ VGND VGND VPWR VPWR _0827_ sky130_fd_sc_hd__a21oi_1
XFILLER_84_589 VGND VGND VPWR VPWR sky130_fd_sc_hd__decap_4
XTAP_TAPCELL_ROW_55_916 VGND VPWR sky130_fd_sc_hd__tapvpwrvgnd_1
X_8914_ clknet_leaf_68_clk _0026_ VGND VGND VPWR VPWR pe_array\[3\].u_pe.accum_reg\[14\]
+ sky130_fd_sc_hd__dfxtp_1
X_8845_ net1001 net210 _4203_ net380 VGND VGND VPWR VPWR _0412_ sky130_fd_sc_hd__o211a_1
XTAP_TAPCELL_ROW_69_1081 VGND VPWR sky130_fd_sc_hd__tapvpwrvgnd_1
XFILLER_64_280 VGND VGND VPWR VPWR sky130_fd_sc_hd__fill_1
XFILLER_72_29 VGND VGND VPWR VPWR sky130_fd_sc_hd__fill_2
XFILLER_64_291 VPWR VGND VPWR VGND sky130_ef_sc_hd__decap_12
X_8776_ _4147_ _4146_ VGND VGND VPWR VPWR _4148_ sky130_fd_sc_hd__and2b_1
X_5988_ net466 net349 VGND VGND VPWR VPWR _1523_ sky130_fd_sc_hd__nand2_1
XFILLER_52_475 VGND VGND VPWR VPWR sky130_fd_sc_hd__fill_1
XFILLER_12_306 VGND VGND VPWR VPWR sky130_fd_sc_hd__fill_2
XTAP_TAPCELL_ROW_35_673 VGND VPWR sky130_fd_sc_hd__tapvpwrvgnd_1
XFILLER_40_615 VGND VGND VPWR VPWR sky130_fd_sc_hd__decap_3
X_7727_ net406 pe_array\[1\].u_pe.accum_reg\[31\] net232 _3172_ VGND VGND VPWR VPWR
+ _3173_ sky130_fd_sc_hd__o2bb2a_4
X_4939_ _0598_ _0683_ VGND VGND VPWR VPWR _0684_ sky130_fd_sc_hd__nor2_1
X_7658_ pe_array\[1\].u_pe.accum_reg\[29\] _2367_ VGND VGND VPWR VPWR _3106_ sky130_fd_sc_hd__nor2_1
X_6609_ _2097_ _2124_ VGND VGND VPWR VPWR _2126_ sky130_fd_sc_hd__nand2_1
XFILLER_20_394 VPWR VGND VPWR VGND sky130_ef_sc_hd__decap_12
X_7589_ _3014_ _3012_ _3038_ VGND VGND VPWR VPWR _3040_ sky130_fd_sc_hd__and3_1
XFILLER_4_549 VGND VGND VPWR VPWR sky130_fd_sc_hd__decap_4
X_9259_ clknet_leaf_13_clk _0371_ VGND VGND VPWR VPWR pe_array\[2\].u_pe.accum_reg\[1\]
+ sky130_fd_sc_hd__dfxtp_1
XFILLER_97_37 VGND VGND VPWR VPWR sky130_fd_sc_hd__fill_1
XFILLER_106_477 VGND VGND VPWR VPWR sky130_fd_sc_hd__decap_3
XTAP_TAPCELL_ROW_7_332 VGND VPWR sky130_fd_sc_hd__tapvpwrvgnd_1
XTAP_TAPCELL_ROW_7_343 VGND VPWR sky130_fd_sc_hd__tapvpwrvgnd_1
XFILLER_87_372 VGND VGND VPWR VPWR sky130_fd_sc_hd__fill_1
XFILLER_47_225 VGND VGND VPWR VPWR sky130_fd_sc_hd__decap_4
XFILLER_101_193 VGND VGND VPWR VPWR sky130_fd_sc_hd__decap_6
XFILLER_46_41 VPWR VGND VPWR VGND sky130_ef_sc_hd__decap_12
XFILLER_28_461 VGND VGND VPWR VPWR sky130_fd_sc_hd__decap_6
XFILLER_46_85 VGND VGND VPWR VPWR sky130_fd_sc_hd__decap_4
XFILLER_102_80 VGND VGND VPWR VPWR sky130_fd_sc_hd__decap_4
XFILLER_43_475 VGND VGND VPWR VPWR sky130_fd_sc_hd__fill_1
XFILLER_31_648 VGND VGND VPWR VPWR sky130_fd_sc_hd__decap_3
XFILLER_62_95 VGND VGND VPWR VPWR sky130_fd_sc_hd__fill_1
XTAP_TAPCELL_ROW_96_1406 VGND VPWR sky130_fd_sc_hd__tapvpwrvgnd_1
XFILLER_11_361 VPWR VGND VPWR VGND sky130_ef_sc_hd__decap_12
XFILLER_7_57 VPWR VGND VPWR VGND sky130_ef_sc_hd__decap_12
XFILLER_109_293 VPWR VGND VPWR VGND sky130_ef_sc_hd__decap_12
XFILLER_98_604 VPWR VGND VPWR VGND sky130_ef_sc_hd__decap_12
XFILLER_97_169 VPWR VGND VPWR VGND sky130_ef_sc_hd__decap_12
XFILLER_66_545 VPWR VGND VPWR VGND sky130_ef_sc_hd__decap_12
XFILLER_16_3 VPWR VGND VPWR VGND sky130_ef_sc_hd__decap_12
Xclone142 net175 VGND VGND VPWR VPWR net657 sky130_fd_sc_hd__clkbuf_1
XFILLER_66_589 VPWR VGND VPWR VGND sky130_ef_sc_hd__decap_12
Xclone164 net575 VGND VGND VPWR VPWR net679 sky130_fd_sc_hd__clkbuf_1
X_6960_ _2377_ _2379_ _2427_ _2428_ VGND VGND VPWR VPWR _2429_ sky130_fd_sc_hd__o211ai_1
XTAP_TAPCELL_ROW_105_1513 VGND VPWR sky130_fd_sc_hd__tapvpwrvgnd_1
X_5911_ _1445_ _1446_ _1437_ VGND VGND VPWR VPWR _1448_ sky130_fd_sc_hd__a21o_1
X_6891_ _2320_ _2360_ VGND VGND VPWR VPWR _2361_ sky130_fd_sc_hd__and2b_1
X_8630_ _4005_ _4006_ VGND VGND VPWR VPWR _4007_ sky130_fd_sc_hd__nand2_1
X_5842_ net515 _4232_ VGND VGND VPWR VPWR _1380_ sky130_fd_sc_hd__nor2_1
X_8561_ _3936_ _3937_ _3938_ VGND VGND VPWR VPWR _3940_ sky130_fd_sc_hd__a21oi_1
X_5773_ _1288_ _1290_ net512 net346 VGND VGND VPWR VPWR _1313_ sky130_fd_sc_hd__o211a_1
XTAP_TAPCELL_ROW_32_632 VGND VPWR sky130_fd_sc_hd__tapvpwrvgnd_1
XTAP_TAPCELL_ROW_60_974 VGND VPWR sky130_fd_sc_hd__tapvpwrvgnd_1
X_4724_ net493 _4230_ VGND VGND VPWR VPWR _0474_ sky130_fd_sc_hd__nor2_1
XFILLER_21_169 VGND VGND VPWR VPWR sky130_fd_sc_hd__decap_4
X_7512_ pe_array\[1\].u_pe.accum_reg\[24\] net451 net339 VGND VGND VPWR VPWR _2965_
+ sky130_fd_sc_hd__and3_1
XTAP_TAPCELL_ROW_32_643 VGND VPWR sky130_fd_sc_hd__tapvpwrvgnd_1
X_8492_ _3700_ _3872_ VGND VGND VPWR VPWR _3873_ sky130_fd_sc_hd__xnor2_1
X_7443_ _2896_ _2897_ VGND VGND VPWR VPWR _2899_ sky130_fd_sc_hd__xnor2_2
X_4655_ _4398_ _4414_ _4416_ VGND VGND VPWR VPWR _4417_ sky130_fd_sc_hd__nor3_1
XTAP_TAPCELL_ROW_116_1642 VGND VPWR sky130_fd_sc_hd__tapvpwrvgnd_1
X_7374_ net196 _2800_ _2798_ VGND VGND VPWR VPWR _2832_ sky130_fd_sc_hd__a21o_1
X_4586_ _4347_ _4348_ VGND VGND VPWR VPWR _4350_ sky130_fd_sc_hd__xnor2_1
X_9113_ clknet_leaf_21_clk _0225_ VGND VGND VPWR VPWR pe_array\[0\].u_pe.tap_count\[3\]
+ sky130_fd_sc_hd__dfxtp_1
X_6325_ _1849_ _1848_ net203 VGND VGND VPWR VPWR _1851_ sky130_fd_sc_hd__a21o_1
X_9044_ clknet_leaf_10_clk _0156_ VGND VGND VPWR VPWR net117 sky130_fd_sc_hd__dfxtp_1
XFILLER_107_69 VPWR VGND VPWR VGND sky130_ef_sc_hd__decap_12
X_6256_ net280 _1781_ _1782_ VGND VGND VPWR VPWR _1784_ sky130_fd_sc_hd__or3_4
X_6187_ net172 VGND VGND VPWR VPWR _1717_ sky130_fd_sc_hd__inv_2
XFILLER_76_309 VGND VGND VPWR VPWR sky130_fd_sc_hd__fill_1
XFILLER_69_350 VGND VGND VPWR VPWR sky130_fd_sc_hd__decap_4
X_5207_ _0943_ _0942_ VGND VGND VPWR VPWR _0944_ sky130_fd_sc_hd__and2b_1
XTAP_TAPCELL_ROW_4_302 VGND VPWR sky130_fd_sc_hd__tapvpwrvgnd_1
X_5138_ _0846_ _0847_ _0875_ _0876_ VGND VGND VPWR VPWR _0877_ sky130_fd_sc_hd__o211a_1
XFILLER_29_225 VGND VGND VPWR VPWR sky130_fd_sc_hd__decap_3
XFILLER_96_191 VGND VGND VPWR VPWR sky130_fd_sc_hd__decap_4
X_5069_ _0809_ _0810_ VGND VGND VPWR VPWR _0811_ sky130_fd_sc_hd__and2b_1
XFILLER_16_44 VGND VGND VPWR VPWR sky130_fd_sc_hd__fill_1
X_8828_ net214 _3243_ VGND VGND VPWR VPWR _4195_ sky130_fd_sc_hd__nand2_1
XTAP_TAPCELL_ROW_80_1218 VGND VPWR sky130_fd_sc_hd__tapvpwrvgnd_1
X_8759_ _4096_ _4098_ VGND VGND VPWR VPWR _4131_ sky130_fd_sc_hd__or2_1
XFILLER_12_103 VGND VGND VPWR VPWR sky130_fd_sc_hd__decap_8
XFILLER_21_681 VGND VGND VPWR VPWR sky130_fd_sc_hd__decap_3
XTAP_TAPCELL_ROW_91_1347 VGND VPWR sky130_fd_sc_hd__tapvpwrvgnd_1
XFILLER_106_296 VPWR VGND VPWR VGND sky130_ef_sc_hd__decap_12
XFILLER_94_117 VGND VGND VPWR VPWR sky130_fd_sc_hd__fill_2
XFILLER_79_169 VGND VGND VPWR VPWR sky130_fd_sc_hd__decap_6
XFILLER_0_585 VGND VGND VPWR VPWR sky130_fd_sc_hd__decap_3
XFILLER_48_523 VGND VGND VPWR VPWR sky130_fd_sc_hd__fill_2
XFILLER_63_537 VPWR VGND VPWR VGND sky130_ef_sc_hd__decap_12
XFILLER_48_589 VPWR VGND VPWR VGND sky130_ef_sc_hd__decap_12
XFILLER_43_261 VGND VGND VPWR VPWR sky130_fd_sc_hd__decap_8
XFILLER_50_209 VGND VGND VPWR VPWR sky130_fd_sc_hd__decap_6
XTAP_TAPCELL_ROW_100_1454 VGND VPWR sky130_fd_sc_hd__tapvpwrvgnd_1
XFILLER_8_641 VGND VGND VPWR VPWR sky130_fd_sc_hd__decap_3
X_6110_ _1640_ _1641_ VGND VGND VPWR VPWR _1642_ sky130_fd_sc_hd__or2_1
X_7090_ _2552_ _2553_ _2554_ VGND VGND VPWR VPWR _2556_ sky130_fd_sc_hd__a21o_1
XFILLER_98_467 VGND VGND VPWR VPWR sky130_fd_sc_hd__decap_4
X_6041_ _1526_ _1528_ _1572_ _1573_ VGND VGND VPWR VPWR _1575_ sky130_fd_sc_hd__o211ai_1
XFILLER_112_288 VPWR VGND VPWR VGND sky130_ef_sc_hd__decap_12
XTAP_TAPCELL_ROW_111_1583 VGND VPWR sky130_fd_sc_hd__tapvpwrvgnd_1
XFILLER_94_640 VGND VGND VPWR VPWR sky130_fd_sc_hd__decap_4
XFILLER_81_323 VGND VGND VPWR VPWR sky130_fd_sc_hd__decap_3
X_7992_ _3345_ _3385_ VGND VGND VPWR VPWR _3386_ sky130_fd_sc_hd__xnor2_1
XFILLER_54_526 VGND VGND VPWR VPWR sky130_fd_sc_hd__fill_1
XFILLER_54_515 VGND VGND VPWR VPWR sky130_fd_sc_hd__fill_1
XTAP_TAPCELL_ROW_37_702 VGND VPWR sky130_fd_sc_hd__tapvpwrvgnd_1
XFILLER_81_334 VGND VGND VPWR VPWR sky130_fd_sc_hd__fill_2
X_6943_ _2410_ _2411_ VGND VGND VPWR VPWR _2412_ sky130_fd_sc_hd__xnor2_1
XTAP_TAPCELL_ROW_66_1051 VGND VPWR sky130_fd_sc_hd__tapvpwrvgnd_1
XTAP_TAPCELL_ROW_66_1040 VGND VPWR sky130_fd_sc_hd__tapvpwrvgnd_1
X_6874_ _2343_ _2342_ _2303_ _2305_ VGND VGND VPWR VPWR _2345_ sky130_fd_sc_hd__a211o_1
XFILLER_22_401 VGND VGND VPWR VPWR sky130_fd_sc_hd__decap_4
XFILLER_34_261 VGND VGND VPWR VPWR sky130_fd_sc_hd__decap_8
X_8613_ _3987_ _3988_ _3949_ _3950_ VGND VGND VPWR VPWR _3990_ sky130_fd_sc_hd__a211oi_1
X_5825_ _1356_ _1362_ _1363_ VGND VGND VPWR VPWR _1364_ sky130_fd_sc_hd__nand3_1
XTAP_TAPCELL_ROW_45_790 VGND VPWR sky130_fd_sc_hd__tapvpwrvgnd_1
X_8544_ _3890_ _3891_ _3921_ _3922_ VGND VGND VPWR VPWR _3923_ sky130_fd_sc_hd__o211a_1
X_5756_ _1293_ _1294_ net491 net354 VGND VGND VPWR VPWR _1297_ sky130_fd_sc_hd__a2bb2o_1
X_5687_ net508 pe_array\[0\].u_pe.tap_count\[0\] net1030 VGND VGND VPWR VPWR _1235_
+ sky130_fd_sc_hd__a21oi_1
X_8475_ net441 net315 pe_array\[2\].u_pe.accum_reg\[20\] VGND VGND VPWR VPWR _3856_
+ sky130_fd_sc_hd__a21oi_1
Xrebuffer215 _1521_ VGND VGND VPWR VPWR net730 sky130_fd_sc_hd__dlygate4sd1_1
X_4707_ _4434_ _0457_ _0456_ VGND VGND VPWR VPWR _0458_ sky130_fd_sc_hd__or3_4
Xrebuffer226 _0436_ VGND VGND VPWR VPWR net741 sky130_fd_sc_hd__buf_2
X_4638_ net303 net469 net460 net304 VGND VGND VPWR VPWR _4400_ sky130_fd_sc_hd__a22oi_1
X_7426_ net269 _2880_ _2881_ VGND VGND VPWR VPWR _2882_ sky130_fd_sc_hd__nor3_1
XFILLER_116_572 VPWR VGND VPWR VGND sky130_ef_sc_hd__decap_12
XTAP_TAPCELL_ROW_77_1180 VGND VPWR sky130_fd_sc_hd__tapvpwrvgnd_1
X_7357_ _2814_ _2815_ VGND VGND VPWR VPWR _2816_ sky130_fd_sc_hd__or2_4
X_4569_ pe_array\[3\].u_pe.accum_reg\[5\] net492 net299 VGND VGND VPWR VPWR _4333_
+ sky130_fd_sc_hd__and3_4
XFILLER_103_222 VGND VGND VPWR VPWR sky130_fd_sc_hd__fill_2
X_6308_ _1832_ _1833_ _1802_ VGND VGND VPWR VPWR _1835_ sky130_fd_sc_hd__or3b_1
X_7288_ net169 _2747_ _2748_ VGND VGND VPWR VPWR _2749_ sky130_fd_sc_hd__nand3_1
X_6239_ _1765_ _1766_ _1767_ VGND VGND VPWR VPWR _1768_ sky130_fd_sc_hd__and3_1
XFILLER_77_629 VPWR VGND VPWR VGND sky130_ef_sc_hd__decap_12
X_9027_ clknet_leaf_46_clk _0139_ VGND VGND VPWR VPWR net98 sky130_fd_sc_hd__dfxtp_1
XFILLER_94_27 VGND VGND VPWR VPWR sky130_fd_sc_hd__fill_1
XFILLER_85_673 VGND VGND VPWR VPWR sky130_fd_sc_hd__decap_6
XFILLER_27_54 VGND VGND VPWR VPWR sky130_fd_sc_hd__fill_2
XFILLER_45_537 VGND VGND VPWR VPWR sky130_fd_sc_hd__decap_8
XFILLER_27_87 VGND VGND VPWR VPWR sky130_fd_sc_hd__decap_3
XTAP_TAPCELL_ROW_15_429 VGND VPWR sky130_fd_sc_hd__tapvpwrvgnd_1
XFILLER_25_261 VGND VGND VPWR VPWR sky130_fd_sc_hd__fill_2
XFILLER_9_405 VPWR VGND VPWR VGND sky130_ef_sc_hd__decap_12
XFILLER_40_253 VGND VGND VPWR VPWR sky130_fd_sc_hd__decap_3
XFILLER_9_449 VPWR VGND VPWR VGND sky130_ef_sc_hd__decap_12
XFILLER_99_209 VGND VGND VPWR VPWR sky130_fd_sc_hd__fill_1
XFILLER_107_561 VGND VGND VPWR VPWR sky130_fd_sc_hd__decap_3
XFILLER_107_550 VGND VGND VPWR VPWR sky130_fd_sc_hd__decap_8
XFILLER_107_594 VGND VGND VPWR VPWR sky130_fd_sc_hd__fill_2
XFILLER_48_320 VGND VGND VPWR VPWR sky130_fd_sc_hd__fill_1
XFILLER_95_459 VGND VGND VPWR VPWR sky130_fd_sc_hd__decap_4
XFILLER_0_393 VGND VGND VPWR VPWR sky130_fd_sc_hd__fill_2
XFILLER_76_695 VGND VGND VPWR VPWR sky130_fd_sc_hd__decap_4
XFILLER_51_529 VGND VGND VPWR VPWR sky130_fd_sc_hd__decap_4
XFILLER_90_197 VGND VGND VPWR VPWR sky130_fd_sc_hd__decap_8
X_5610_ net1014 net387 VGND VGND VPWR VPWR _0151_ sky130_fd_sc_hd__and2_1
X_6590_ net198 _2105_ VGND VGND VPWR VPWR _2107_ sky130_fd_sc_hd__and2_1
XTAP_TAPCELL_ROW_42_760 VGND VPWR sky130_fd_sc_hd__tapvpwrvgnd_1
X_5541_ net20 _1226_ _1227_ pe_array\[1\].u_pe.weight_in\[7\] VGND VGND VPWR VPWR
+ _0084_ sky130_fd_sc_hd__a22o_1
X_8260_ _3645_ _3646_ _3633_ VGND VGND VPWR VPWR _3648_ sky130_fd_sc_hd__a21oi_1
XFILLER_8_493 VGND VGND VPWR VPWR sky130_fd_sc_hd__fill_1
X_5472_ net973 net252 _1196_ net371 VGND VGND VPWR VPWR _0046_ sky130_fd_sc_hd__o211a_1
X_7211_ _2670_ _2671_ _2632_ _2633_ VGND VGND VPWR VPWR _2674_ sky130_fd_sc_hd__a211o_1
XTAP_TAPCELL_ROW_113_1612 VGND VPWR sky130_fd_sc_hd__tapvpwrvgnd_1
X_8191_ _3417_ net560 VGND VGND VPWR VPWR _3580_ sky130_fd_sc_hd__nor2_2
X_7142_ _2559_ _2561_ _2605_ _2606_ VGND VGND VPWR VPWR _2607_ sky130_fd_sc_hd__o211a_1
XFILLER_98_253 VGND VGND VPWR VPWR sky130_fd_sc_hd__decap_4
Xfanout428 net429 VGND VGND VPWR VPWR net428 sky130_fd_sc_hd__buf_2
Xfanout439 net440 VGND VGND VPWR VPWR net439 sky130_fd_sc_hd__buf_6
XFILLER_59_629 VPWR VGND VPWR VGND sky130_ef_sc_hd__decap_12
Xfanout406 _4225_ VGND VGND VPWR VPWR net406 sky130_fd_sc_hd__buf_2
Xfanout417 net418 VGND VGND VPWR VPWR net417 sky130_fd_sc_hd__clkbuf_2
X_7073_ _2532_ _2537_ VGND VGND VPWR VPWR _2539_ sky130_fd_sc_hd__xor2_1
XFILLER_113_597 VPWR VGND VPWR VGND sky130_ef_sc_hd__decap_12
XFILLER_98_286 VGND VGND VPWR VPWR sky130_fd_sc_hd__decap_6
X_6024_ net466 net347 net345 net473 VGND VGND VPWR VPWR _1558_ sky130_fd_sc_hd__a22oi_1
XFILLER_104_15 VPWR VGND VPWR VGND sky130_ef_sc_hd__decap_12
XFILLER_67_673 VPWR VGND VPWR VGND sky130_ef_sc_hd__decap_12
XFILLER_82_643 VGND VGND VPWR VPWR sky130_fd_sc_hd__fill_1
X_7975_ _3366_ _3368_ VGND VGND VPWR VPWR _3369_ sky130_fd_sc_hd__xor2_1
XFILLER_27_548 VGND VGND VPWR VPWR sky130_fd_sc_hd__fill_1
XFILLER_82_687 VPWR VGND VPWR VGND sky130_ef_sc_hd__decap_12
X_6926_ _2322_ _2383_ _2382_ VGND VGND VPWR VPWR _2395_ sky130_fd_sc_hd__a21bo_1
XFILLER_35_592 VPWR VGND VPWR VGND sky130_ef_sc_hd__decap_12
XFILLER_80_29 VGND VGND VPWR VPWR sky130_fd_sc_hd__fill_1
X_6857_ _2326_ _2327_ VGND VGND VPWR VPWR _2328_ sky130_fd_sc_hd__and2b_1
XFILLER_50_551 VPWR VGND VPWR VGND sky130_ef_sc_hd__decap_12
XFILLER_22_231 VGND VGND VPWR VPWR sky130_fd_sc_hd__decap_4
X_5808_ _4228_ _4231_ _1346_ VGND VGND VPWR VPWR _1347_ sky130_fd_sc_hd__or3_1
X_6788_ net510 net330 _2258_ _2259_ VGND VGND VPWR VPWR _2261_ sky130_fd_sc_hd__o2bb2a_1
XFILLER_22_253 VPWR VGND VPWR VGND sky130_ef_sc_hd__decap_12
X_8527_ _3905_ _3906_ VGND VGND VPWR VPWR _3907_ sky130_fd_sc_hd__and2b_1
X_5739_ _1259_ _1261_ _1279_ VGND VGND VPWR VPWR _1281_ sky130_fd_sc_hd__nand3_1
XFILLER_13_78 VPWR VGND VPWR VGND sky130_ef_sc_hd__decap_12
XFILLER_6_419 VGND VGND VPWR VPWR sky130_fd_sc_hd__fill_1
X_8458_ net176 _3838_ _3839_ VGND VGND VPWR VPWR _3840_ sky130_fd_sc_hd__nand3_1
XTAP_TAPCELL_ROW_20_498 VGND VPWR sky130_fd_sc_hd__tapvpwrvgnd_1
X_8389_ net260 _3770_ _3771_ VGND VGND VPWR VPWR _3773_ sky130_fd_sc_hd__or3_1
X_7409_ _2863_ _2864_ VGND VGND VPWR VPWR _2866_ sky130_fd_sc_hd__xnor2_2
Xhold460 pe_accum\[2\]\[19\] VGND VGND VPWR VPWR net975 sky130_fd_sc_hd__dlygate4sd3_1
Xhold471 pe_accum\[3\]\[29\] VGND VGND VPWR VPWR net986 sky130_fd_sc_hd__dlygate4sd3_1
XFILLER_2_625 VPWR VGND VPWR VGND sky130_ef_sc_hd__decap_12
Xhold482 pe_accum\[2\]\[4\] VGND VGND VPWR VPWR net997 sky130_fd_sc_hd__dlygate4sd3_1
XFILLER_2_669 VPWR VGND VPWR VGND sky130_ef_sc_hd__decap_12
Xhold493 pe_accum\[1\]\[27\] VGND VGND VPWR VPWR net1008 sky130_fd_sc_hd__dlygate4sd3_1
XFILLER_38_53 VGND VGND VPWR VPWR sky130_fd_sc_hd__decap_4
XFILLER_73_610 VGND VGND VPWR VPWR sky130_fd_sc_hd__decap_6
XFILLER_38_97 VGND VGND VPWR VPWR sky130_fd_sc_hd__decap_4
XFILLER_73_632 VPWR VGND VPWR VGND sky130_ef_sc_hd__decap_12
XFILLER_54_41 VPWR VGND VPWR VGND sky130_ef_sc_hd__decap_12
XTAP_TAPCELL_ROW_28_587 VGND VPWR sky130_fd_sc_hd__tapvpwrvgnd_1
XFILLER_60_348 VGND VGND VPWR VPWR sky130_fd_sc_hd__fill_1
XFILLER_54_85 VPWR VGND VPWR VGND sky130_ef_sc_hd__decap_12
XFILLER_70_51 VGND VGND VPWR VPWR sky130_fd_sc_hd__fill_2
Xclkload16 clknet_leaf_55_clk VGND VGND VPWR VPWR clkload16/Y sky130_fd_sc_hd__clkinvlp_4
Xclkload38 clknet_leaf_7_clk VGND VGND VPWR VPWR clkload38/Y sky130_fd_sc_hd__clkinv_4
Xclkload49 clknet_leaf_31_clk VGND VGND VPWR VPWR clkload49/Y sky130_fd_sc_hd__bufinv_16
Xclkload27 clknet_leaf_37_clk VGND VGND VPWR VPWR clkload27/Y sky130_fd_sc_hd__clkinv_8
XFILLER_55_7 VPWR VGND VPWR VGND sky130_ef_sc_hd__decap_12
XFILLER_5_441 VGND VGND VPWR VPWR sky130_fd_sc_hd__decap_6
XFILLER_110_589 VGND VGND VPWR VPWR sky130_fd_sc_hd__decap_4
XFILLER_110_578 VGND VGND VPWR VPWR sky130_fd_sc_hd__decap_3
XFILLER_36_301 VGND VGND VPWR VPWR sky130_fd_sc_hd__decap_6
XFILLER_64_643 VGND VGND VPWR VPWR sky130_fd_sc_hd__fill_1
XTAP_TAPCELL_ROW_63_1010 VGND VPWR sky130_fd_sc_hd__tapvpwrvgnd_1
XFILLER_51_337 VGND VGND VPWR VPWR sky130_fd_sc_hd__decap_6
X_7760_ net985 net223 _3189_ net371 VGND VGND VPWR VPWR _0341_ sky130_fd_sc_hd__o211a_1
X_4972_ net398 pe_array\[3\].u_pe.accum_reg\[14\] net256 _0716_ VGND VGND VPWR VPWR
+ _0717_ sky130_fd_sc_hd__o2bb2a_4
X_6711_ net926 net237 _1976_ net245 VGND VGND VPWR VPWR _0281_ sky130_fd_sc_hd__o2bb2ai_1
X_7691_ _2367_ _3137_ VGND VGND VPWR VPWR _3138_ sky130_fd_sc_hd__xnor2_1
X_6642_ _2122_ _2125_ VGND VGND VPWR VPWR _2158_ sky130_fd_sc_hd__nand2_4
X_6573_ net429 _2090_ VGND VGND VPWR VPWR _0253_ sky130_fd_sc_hd__nor2_1
X_8312_ net419 _3698_ VGND VGND VPWR VPWR _0384_ sky130_fd_sc_hd__nor2_1
X_9292_ clknet_leaf_11_clk _0404_ VGND VGND VPWR VPWR pe_accum\[2\]\[2\] sky130_fd_sc_hd__dfxtp_1
X_5524_ net989 net250 _1222_ net367 VGND VGND VPWR VPWR _0072_ sky130_fd_sc_hd__o211a_1
XFILLER_105_317 VPWR VGND VPWR VGND sky130_ef_sc_hd__decap_12
X_8243_ _3582_ _3585_ _3584_ VGND VGND VPWR VPWR _3631_ sky130_fd_sc_hd__a21oi_1
X_5455_ pe_array\[3\].u_pe.accum_reg\[30\] _0521_ _1182_ VGND VGND VPWR VPWR _1183_
+ sky130_fd_sc_hd__a21o_1
X_8174_ _3561_ _3562_ _3549_ VGND VGND VPWR VPWR _3564_ sky130_fd_sc_hd__a21o_1
XFILLER_59_19 VPWR VGND VPWR VGND sky130_ef_sc_hd__decap_12
Xfanout214 net215 VGND VGND VPWR VPWR net214 sky130_fd_sc_hd__buf_2
XFILLER_99_573 VGND VGND VPWR VPWR sky130_fd_sc_hd__decap_6
Xfanout203 _1567_ VGND VGND VPWR VPWR net203 sky130_fd_sc_hd__buf_4
X_5386_ net181 _1081_ _1080_ VGND VGND VPWR VPWR _1117_ sky130_fd_sc_hd__a21oi_1
X_7125_ _2586_ _2587_ net268 VGND VGND VPWR VPWR _2590_ sky130_fd_sc_hd__o21ai_1
XFILLER_101_523 VGND VGND VPWR VPWR sky130_fd_sc_hd__decap_3
Xfanout236 net237 VGND VGND VPWR VPWR net236 sky130_fd_sc_hd__buf_2
XFILLER_86_212 VGND VGND VPWR VPWR sky130_fd_sc_hd__fill_1
Xfanout247 net248 VGND VGND VPWR VPWR net247 sky130_fd_sc_hd__buf_1
Xfanout225 net227 VGND VGND VPWR VPWR net225 sky130_fd_sc_hd__buf_2
XFILLER_115_69 VPWR VGND VPWR VGND sky130_ef_sc_hd__decap_12
XFILLER_86_256 VPWR VGND VPWR VGND sky130_ef_sc_hd__decap_12
Xfanout258 _4243_ VGND VGND VPWR VPWR net258 sky130_fd_sc_hd__clkbuf_2
Xfanout269 _2413_ VGND VGND VPWR VPWR net269 sky130_fd_sc_hd__buf_6
X_7056_ _2520_ _2521_ _2475_ _2478_ VGND VGND VPWR VPWR _2523_ sky130_fd_sc_hd__o211a_1
X_6007_ _1539_ _1540_ _1492_ _1495_ VGND VGND VPWR VPWR _1542_ sky130_fd_sc_hd__o211a_1
XFILLER_55_610 VGND VGND VPWR VPWR sky130_fd_sc_hd__decap_6
XFILLER_82_462 VPWR VGND VPWR VGND sky130_ef_sc_hd__decap_12
XFILLER_55_665 VGND VGND VPWR VPWR sky130_fd_sc_hd__decap_6
XFILLER_82_495 VPWR VGND VPWR VGND sky130_ef_sc_hd__decap_12
X_7958_ _3306_ _3311_ _3351_ _3352_ VGND VGND VPWR VPWR _3353_ sky130_fd_sc_hd__o211a_1
XFILLER_70_613 VPWR VGND VPWR VGND sky130_ef_sc_hd__decap_12
XFILLER_54_197 VPWR VGND VPWR VGND sky130_ef_sc_hd__decap_12
XFILLER_42_326 VPWR VGND VPWR VGND sky130_ef_sc_hd__decap_12
X_7889_ _3283_ _3284_ VGND VGND VPWR VPWR _3286_ sky130_fd_sc_hd__xor2_2
XFILLER_70_657 VGND VGND VPWR VPWR sky130_fd_sc_hd__decap_3
XTAP_TAPCELL_ROW_25_557 VGND VPWR sky130_fd_sc_hd__tapvpwrvgnd_1
X_6909_ _2362_ _2378_ VGND VGND VPWR VPWR _2379_ sky130_fd_sc_hd__nor2_1
XTAP_TAPCELL_ROW_53_888 VGND VPWR sky130_fd_sc_hd__tapvpwrvgnd_1
XFILLER_50_381 VGND VGND VPWR VPWR sky130_fd_sc_hd__fill_2
XFILLER_10_289 VGND VGND VPWR VPWR sky130_fd_sc_hd__decap_8
XFILLER_6_227 VGND VGND VPWR VPWR sky130_fd_sc_hd__decap_6
XFILLER_108_188 VGND VGND VPWR VPWR sky130_fd_sc_hd__decap_8
XFILLER_2_433 VPWR VGND VPWR VGND sky130_ef_sc_hd__decap_12
XFILLER_2_477 VPWR VGND VPWR VGND sky130_ef_sc_hd__decap_12
XFILLER_92_204 VGND VGND VPWR VPWR sky130_fd_sc_hd__decap_4
XTAP_TAPCELL_ROW_88_1308 VGND VPWR sky130_fd_sc_hd__tapvpwrvgnd_1
XFILLER_1_15 VPWR VGND VPWR VGND sky130_ef_sc_hd__decap_12
XFILLER_65_51 VGND VGND VPWR VPWR sky130_fd_sc_hd__decap_4
XFILLER_18_389 VPWR VGND VPWR VGND sky130_ef_sc_hd__decap_12
XFILLER_33_337 VGND VGND VPWR VPWR sky130_fd_sc_hd__decap_8
XTAP_TAPCELL_ROW_99_1437 VGND VPWR sky130_fd_sc_hd__tapvpwrvgnd_1
XFILLER_115_615 VGND VGND VPWR VPWR sky130_fd_sc_hd__fill_1
X_5240_ _0944_ _0974_ VGND VGND VPWR VPWR _0976_ sky130_fd_sc_hd__xnor2_1
XFILLER_102_309 VGND VGND VPWR VPWR sky130_fd_sc_hd__fill_2
XFILLER_68_201 VGND VGND VPWR VPWR sky130_fd_sc_hd__fill_2
X_5171_ net205 _0908_ VGND VGND VPWR VPWR _0909_ sky130_fd_sc_hd__xnor2_1
XPHY_EDGE_ROW_18_Right_18 VGND VGND VPWR VPWR sky130_fd_sc_hd__decap_3
XFILLER_68_267 VGND VGND VPWR VPWR sky130_fd_sc_hd__fill_2
X_8930_ clknet_leaf_58_clk _0042_ VGND VGND VPWR VPWR pe_array\[3\].u_pe.accum_reg\[30\]
+ sky130_fd_sc_hd__dfxtp_1
Xinput3 pixel_in[2] VGND VGND VPWR VPWR net3 sky130_fd_sc_hd__clkbuf_2
XFILLER_83_248 VGND VGND VPWR VPWR sky130_fd_sc_hd__decap_8
XFILLER_36_120 VPWR VGND VPWR VGND sky130_ef_sc_hd__decap_12
XTAP_TAPCELL_ROW_108_1555 VGND VPWR sky130_fd_sc_hd__tapvpwrvgnd_1
XTAP_TAPCELL_ROW_108_1544 VGND VPWR sky130_fd_sc_hd__tapvpwrvgnd_1
X_8861_ net937 net211 _4211_ net381 VGND VGND VPWR VPWR _0420_ sky130_fd_sc_hd__o211a_1
XFILLER_37_654 VGND VGND VPWR VPWR sky130_fd_sc_hd__fill_2
X_7812_ _3213_ _3214_ VGND VGND VPWR VPWR _0368_ sky130_fd_sc_hd__nor2_1
X_8792_ net188 _4162_ VGND VGND VPWR VPWR _4163_ sky130_fd_sc_hd__xnor2_1
XFILLER_91_281 VGND VGND VPWR VPWR sky130_fd_sc_hd__decap_4
XFILLER_91_270 VGND VGND VPWR VPWR sky130_fd_sc_hd__decap_8
XFILLER_64_495 VPWR VGND VPWR VGND sky130_ef_sc_hd__decap_12
XFILLER_52_635 VGND VGND VPWR VPWR sky130_fd_sc_hd__fill_1
XFILLER_51_101 VGND VGND VPWR VPWR sky130_fd_sc_hd__fill_2
XFILLER_101_27 VGND VGND VPWR VPWR sky130_fd_sc_hd__decap_3
XFILLER_52_657 VGND VGND VPWR VPWR sky130_fd_sc_hd__decap_8
XPHY_EDGE_ROW_27_Right_27 VGND VGND VPWR VPWR sky130_fd_sc_hd__decap_3
XFILLER_36_197 VGND VGND VPWR VPWR sky130_fd_sc_hd__decap_8
X_4955_ _0697_ _0698_ _0699_ VGND VGND VPWR VPWR _0700_ sky130_fd_sc_hd__nand3_1
X_7743_ net224 _2393_ VGND VGND VPWR VPWR _3181_ sky130_fd_sc_hd__nand2_1
XTAP_TAPCELL_ROW_22_516 VGND VPWR sky130_fd_sc_hd__tapvpwrvgnd_1
XTAP_TAPCELL_ROW_50_858 VGND VPWR sky130_fd_sc_hd__tapvpwrvgnd_1
X_4886_ _0631_ _0632_ VGND VGND VPWR VPWR _0633_ sky130_fd_sc_hd__and2b_1
X_7674_ _3086_ _3089_ _3120_ VGND VGND VPWR VPWR _3122_ sky130_fd_sc_hd__nor3_1
X_6625_ _2104_ _2106_ _2139_ VGND VGND VPWR VPWR _2141_ sky130_fd_sc_hd__nor3_1
X_6556_ net198 _2046_ _2045_ VGND VGND VPWR VPWR _2074_ sky130_fd_sc_hd__o21ai_1
X_9275_ clknet_leaf_4_clk _0387_ VGND VGND VPWR VPWR pe_array\[2\].u_pe.accum_reg\[17\]
+ sky130_fd_sc_hd__dfxtp_1
X_5507_ net248 _0899_ VGND VGND VPWR VPWR _1214_ sky130_fd_sc_hd__nand2_2
X_6487_ _1972_ _2006_ VGND VGND VPWR VPWR _2008_ sky130_fd_sc_hd__nor2_1
XFILLER_105_125 VPWR VGND VPWR VGND sky130_ef_sc_hd__decap_12
X_8226_ _3572_ _3613_ _3614_ VGND VGND VPWR VPWR _3615_ sky130_fd_sc_hd__or3_4
XFILLER_105_169 VPWR VGND VPWR VGND sky130_ef_sc_hd__decap_12
X_5438_ net627 _1166_ VGND VGND VPWR VPWR _1167_ sky130_fd_sc_hd__xnor2_1
XPHY_EDGE_ROW_36_Right_36 VGND VGND VPWR VPWR sky130_fd_sc_hd__decap_3
XFILLER_114_681 VPWR VGND VPWR VGND sky130_ef_sc_hd__decap_12
X_8157_ _3546_ _3545_ VGND VGND VPWR VPWR _3547_ sky130_fd_sc_hd__nand2b_1
X_5369_ _1097_ _1098_ net630 VGND VGND VPWR VPWR _1100_ sky130_fd_sc_hd__o21a_1
X_8088_ _3477_ _3478_ _3479_ VGND VGND VPWR VPWR _3480_ sky130_fd_sc_hd__and3_1
XFILLER_59_223 VGND VGND VPWR VPWR sky130_fd_sc_hd__fill_1
X_7108_ net424 _2573_ VGND VGND VPWR VPWR _0305_ sky130_fd_sc_hd__nor2_1
XFILLER_101_364 VGND VGND VPWR VPWR sky130_fd_sc_hd__fill_1
X_7039_ _2503_ net270 _2504_ VGND VGND VPWR VPWR _2506_ sky130_fd_sc_hd__or3_4
XFILLER_101_397 VGND VGND VPWR VPWR sky130_fd_sc_hd__fill_1
XTAP_TAPCELL_ROW_58_947 VGND VPWR sky130_fd_sc_hd__tapvpwrvgnd_1
XFILLER_28_632 VPWR VGND VPWR VGND sky130_ef_sc_hd__decap_12
XTAP_TAPCELL_ROW_2_274 VGND VPWR sky130_fd_sc_hd__tapvpwrvgnd_1
XFILLER_19_99 VGND VGND VPWR VPWR sky130_fd_sc_hd__fill_2
XFILLER_27_164 VGND VGND VPWR VPWR sky130_fd_sc_hd__fill_1
XFILLER_35_21 VGND VGND VPWR VPWR sky130_fd_sc_hd__fill_2
XPHY_EDGE_ROW_45_Right_45 VGND VGND VPWR VPWR sky130_fd_sc_hd__decap_3
XTAP_TAPCELL_ROW_83_1249 VGND VPWR sky130_fd_sc_hd__tapvpwrvgnd_1
XFILLER_15_337 VPWR VGND VPWR VGND sky130_ef_sc_hd__decap_12
XFILLER_43_657 VGND VGND VPWR VPWR sky130_fd_sc_hd__decap_4
XFILLER_70_465 VGND VGND VPWR VPWR sky130_fd_sc_hd__fill_2
XFILLER_7_503 VGND VGND VPWR VPWR sky130_fd_sc_hd__fill_1
XFILLER_109_497 VGND VGND VPWR VPWR sky130_fd_sc_hd__decap_6
XPHY_EDGE_ROW_54_Right_54 VGND VGND VPWR VPWR sky130_fd_sc_hd__decap_3
XTAP_TAPCELL_ROW_94_1378 VGND VPWR sky130_fd_sc_hd__tapvpwrvgnd_1
XFILLER_104_191 VGND VGND VPWR VPWR sky130_fd_sc_hd__decap_4
XFILLER_38_407 VGND VGND VPWR VPWR sky130_fd_sc_hd__fill_2
XFILLER_19_621 VGND VGND VPWR VPWR sky130_fd_sc_hd__fill_1
XPHY_EDGE_ROW_63_Right_63 VGND VGND VPWR VPWR sky130_fd_sc_hd__decap_3
XFILLER_46_473 VGND VGND VPWR VPWR sky130_fd_sc_hd__decap_3
XFILLER_46_495 VPWR VGND VPWR VGND sky130_ef_sc_hd__decap_12
XFILLER_73_281 VGND VGND VPWR VPWR sky130_fd_sc_hd__decap_8
XFILLER_61_465 VGND VGND VPWR VPWR sky130_fd_sc_hd__decap_8
XFILLER_33_178 VGND VGND VPWR VPWR sky130_fd_sc_hd__fill_1
XTAP_TAPCELL_ROW_103_1485 VGND VPWR sky130_fd_sc_hd__tapvpwrvgnd_1
X_4740_ _0487_ _0488_ _0481_ VGND VGND VPWR VPWR _0490_ sky130_fd_sc_hd__a21o_1
X_4671_ net417 _4432_ VGND VGND VPWR VPWR _0019_ sky130_fd_sc_hd__nor2_1
X_6410_ _1932_ _1931_ VGND VGND VPWR VPWR _1933_ sky130_fd_sc_hd__and2b_1
X_7390_ _2786_ _2787_ _2816_ _2817_ _2820_ VGND VGND VPWR VPWR _2848_ sky130_fd_sc_hd__o32a_4
X_6341_ _1865_ _1866_ VGND VGND VPWR VPWR _1867_ sky130_fd_sc_hd__and2b_1
XPHY_EDGE_ROW_72_Right_72 VGND VGND VPWR VPWR sky130_fd_sc_hd__decap_3
XFILLER_115_445 VGND VGND VPWR VPWR sky130_fd_sc_hd__decap_3
X_9060_ clknet_leaf_5_clk _0172_ VGND VGND VPWR VPWR net134 sky130_fd_sc_hd__dfxtp_1
X_6272_ _1797_ _1798_ net171 VGND VGND VPWR VPWR _1800_ sky130_fd_sc_hd__a21o_1
XFILLER_103_629 VPWR VGND VPWR VGND sky130_ef_sc_hd__decap_12
XFILLER_88_329 VPWR VGND VPWR VGND sky130_ef_sc_hd__decap_12
X_8011_ _3400_ _3361_ _3399_ VGND VGND VPWR VPWR _3404_ sky130_fd_sc_hd__a21o_1
X_5223_ _0926_ _0927_ _0957_ _0958_ VGND VGND VPWR VPWR _0959_ sky130_fd_sc_hd__o211a_1
XFILLER_102_139 VGND VGND VPWR VPWR sky130_fd_sc_hd__fill_1
X_5154_ _0865_ _0891_ VGND VGND VPWR VPWR _0893_ sky130_fd_sc_hd__xnor2_2
XFILLER_111_673 VPWR VGND VPWR VGND sky130_ef_sc_hd__decap_12
XPHY_EDGE_ROW_81_Right_81 VGND VGND VPWR VPWR sky130_fd_sc_hd__decap_3
X_5085_ _0823_ _0824_ _0825_ VGND VGND VPWR VPWR _0826_ sky130_fd_sc_hd__and3_1
XFILLER_112_15 VPWR VGND VPWR VGND sky130_ef_sc_hd__decap_12
XFILLER_84_579 VGND VGND VPWR VPWR sky130_fd_sc_hd__decap_8
XTAP_TAPCELL_ROW_55_917 VGND VPWR sky130_fd_sc_hd__tapvpwrvgnd_1
X_8913_ clknet_leaf_67_clk _0025_ VGND VGND VPWR VPWR pe_array\[3\].u_pe.accum_reg\[13\]
+ sky130_fd_sc_hd__dfxtp_1
X_8844_ net210 _3536_ VGND VGND VPWR VPWR _4203_ sky130_fd_sc_hd__nand2_1
XFILLER_71_218 VGND VGND VPWR VPWR sky130_fd_sc_hd__decap_6
XFILLER_25_624 VGND VGND VPWR VPWR sky130_fd_sc_hd__decap_3
XTAP_TAPCELL_ROW_69_1082 VGND VPWR sky130_fd_sc_hd__tapvpwrvgnd_1
XFILLER_25_646 VGND VGND VPWR VPWR sky130_fd_sc_hd__decap_4
X_8775_ _3699_ _4114_ _4112_ VGND VGND VPWR VPWR _4147_ sky130_fd_sc_hd__a21oi_1
X_5987_ _1477_ _1521_ VGND VGND VPWR VPWR _1522_ sky130_fd_sc_hd__and2b_2
XFILLER_52_454 VGND VGND VPWR VPWR sky130_fd_sc_hd__fill_1
XTAP_TAPCELL_ROW_35_674 VGND VPWR sky130_fd_sc_hd__tapvpwrvgnd_1
X_7726_ _3171_ _3160_ VGND VGND VPWR VPWR _3172_ sky130_fd_sc_hd__xnor2_2
X_4938_ _0602_ _0645_ _4230_ net436 VGND VGND VPWR VPWR _0683_ sky130_fd_sc_hd__o2bb2a_2
XFILLER_20_340 VPWR VGND VPWR VGND sky130_ef_sc_hd__decap_12
X_4869_ _0570_ _0571_ _0613_ _0614_ VGND VGND VPWR VPWR _0616_ sky130_fd_sc_hd__o211ai_1
X_7657_ net426 _3105_ VGND VGND VPWR VPWR _0322_ sky130_fd_sc_hd__nor2_1
X_6608_ _2124_ _2097_ VGND VGND VPWR VPWR _2125_ sky130_fd_sc_hd__or2_4
XPHY_EDGE_ROW_90_Right_90 VGND VGND VPWR VPWR sky130_fd_sc_hd__decap_3
X_7588_ _3014_ _3012_ _3038_ VGND VGND VPWR VPWR _3039_ sky130_fd_sc_hd__a21oi_2
X_6539_ _2055_ _2056_ VGND VGND VPWR VPWR _2058_ sky130_fd_sc_hd__xor2_1
X_9258_ clknet_leaf_13_clk _0370_ VGND VGND VPWR VPWR pe_array\[2\].u_pe.accum_reg\[0\]
+ sky130_fd_sc_hd__dfxtp_1
XFILLER_79_318 VGND VGND VPWR VPWR sky130_fd_sc_hd__decap_8
X_8209_ _3553_ _3555_ _3595_ _3596_ VGND VGND VPWR VPWR _3598_ sky130_fd_sc_hd__o211ai_1
X_9189_ clknet_leaf_37_clk _0301_ VGND VGND VPWR VPWR pe_array\[1\].u_pe.accum_reg\[7\]
+ sky130_fd_sc_hd__dfxtp_1
XTAP_TAPCELL_ROW_7_333 VGND VPWR sky130_fd_sc_hd__tapvpwrvgnd_1
XFILLER_87_340 VGND VGND VPWR VPWR sky130_fd_sc_hd__decap_8
XFILLER_47_215 VGND VGND VPWR VPWR sky130_fd_sc_hd__decap_8
XFILLER_46_53 VPWR VGND VPWR VGND sky130_ef_sc_hd__decap_12
XFILLER_55_281 VGND VGND VPWR VPWR sky130_fd_sc_hd__decap_3
XFILLER_15_145 VGND VGND VPWR VPWR sky130_fd_sc_hd__decap_3
XFILLER_16_679 VGND VGND VPWR VPWR sky130_fd_sc_hd__fill_2
XFILLER_70_295 VGND VGND VPWR VPWR sky130_fd_sc_hd__decap_3
XFILLER_62_41 VPWR VGND VPWR VGND sky130_ef_sc_hd__decap_12
XFILLER_30_104 VGND VGND VPWR VPWR sky130_fd_sc_hd__decap_3
XFILLER_30_159 VGND VGND VPWR VPWR sky130_fd_sc_hd__fill_1
XTAP_TAPCELL_ROW_96_1407 VGND VPWR sky130_fd_sc_hd__tapvpwrvgnd_1
XFILLER_11_373 VPWR VGND VPWR VGND sky130_ef_sc_hd__decap_12
XFILLER_7_333 VGND VGND VPWR VPWR sky130_fd_sc_hd__decap_3
XFILLER_7_366 VGND VGND VPWR VPWR sky130_fd_sc_hd__decap_3
XFILLER_7_69 VGND VGND VPWR VPWR sky130_fd_sc_hd__decap_8
XFILLER_98_616 VGND VGND VPWR VPWR sky130_fd_sc_hd__fill_1
XFILLER_3_561 VPWR VGND VPWR VGND sky130_ef_sc_hd__decap_12
XFILLER_98_649 VGND VGND VPWR VPWR sky130_fd_sc_hd__fill_1
XFILLER_66_557 VPWR VGND VPWR VGND sky130_ef_sc_hd__decap_12
XTAP_TAPCELL_ROW_105_1514 VGND VPWR sky130_fd_sc_hd__tapvpwrvgnd_1
X_5910_ _1437_ _1445_ _1446_ VGND VGND VPWR VPWR _1447_ sky130_fd_sc_hd__nand3_1
X_6890_ _2355_ _2359_ VGND VGND VPWR VPWR _2360_ sky130_fd_sc_hd__xor2_1
X_5841_ net428 _1379_ VGND VGND VPWR VPWR _0232_ sky130_fd_sc_hd__nor2_1
XFILLER_34_454 VGND VGND VPWR VPWR sky130_fd_sc_hd__decap_4
XFILLER_34_465 VGND VGND VPWR VPWR sky130_fd_sc_hd__decap_8
X_8560_ _3938_ _3937_ _3936_ VGND VGND VPWR VPWR _3939_ sky130_fd_sc_hd__and3_1
X_5772_ net428 _1312_ VGND VGND VPWR VPWR _0230_ sky130_fd_sc_hd__nor2_1
XFILLER_21_104 VGND VGND VPWR VPWR sky130_fd_sc_hd__decap_8
XTAP_TAPCELL_ROW_32_633 VGND VPWR sky130_fd_sc_hd__tapvpwrvgnd_1
X_8491_ _3869_ _3870_ VGND VGND VPWR VPWR _3872_ sky130_fd_sc_hd__xnor2_1
XTAP_TAPCELL_ROW_60_975 VGND VPWR sky130_fd_sc_hd__tapvpwrvgnd_1
X_4723_ _0471_ _0472_ VGND VGND VPWR VPWR _0473_ sky130_fd_sc_hd__nor2_1
XFILLER_21_148 VGND VGND VPWR VPWR sky130_fd_sc_hd__decap_8
X_7511_ _2960_ _2762_ _2761_ _2963_ VGND VGND VPWR VPWR _2964_ sky130_fd_sc_hd__o31a_1
X_7442_ _2897_ _2896_ VGND VGND VPWR VPWR _2898_ sky130_fd_sc_hd__nand2b_1
XFILLER_107_209 VGND VGND VPWR VPWR sky130_fd_sc_hd__fill_2
X_4654_ _4411_ _4412_ _4413_ VGND VGND VPWR VPWR _4416_ sky130_fd_sc_hd__a21oi_1
XTAP_TAPCELL_ROW_116_1643 VGND VPWR sky130_fd_sc_hd__tapvpwrvgnd_1
X_7373_ _2828_ _2829_ net196 VGND VGND VPWR VPWR _2831_ sky130_fd_sc_hd__a21o_1
X_4585_ _4347_ _4348_ VGND VGND VPWR VPWR _4349_ sky130_fd_sc_hd__nand2_1
X_9112_ clknet_leaf_21_clk _0224_ VGND VGND VPWR VPWR pe_array\[0\].u_pe.tap_count\[2\]
+ sky130_fd_sc_hd__dfxtp_1
X_6324_ net202 _1848_ _1849_ VGND VGND VPWR VPWR _1850_ sky130_fd_sc_hd__nand3_1
X_9043_ clknet_leaf_10_clk _0155_ VGND VGND VPWR VPWR net115 sky130_fd_sc_hd__dfxtp_1
XFILLER_107_15 VPWR VGND VPWR VGND sky130_ef_sc_hd__decap_12
X_6255_ net706 _1781_ _1782_ VGND VGND VPWR VPWR _1783_ sky130_fd_sc_hd__nor3_1
X_5206_ net178 _0916_ _0915_ VGND VGND VPWR VPWR _0943_ sky130_fd_sc_hd__a21oi_1
X_6186_ _1599_ _1679_ _1681_ VGND VGND VPWR VPWR _1716_ sky130_fd_sc_hd__o21ai_2
XFILLER_69_362 VGND VGND VPWR VPWR sky130_fd_sc_hd__decap_4
XTAP_TAPCELL_ROW_4_303 VGND VPWR sky130_fd_sc_hd__tapvpwrvgnd_1
XFILLER_84_321 VGND VGND VPWR VPWR sky130_fd_sc_hd__decap_6
X_5137_ _0872_ _0873_ net282 VGND VGND VPWR VPWR _0876_ sky130_fd_sc_hd__o21ai_1
X_5068_ _0807_ _0808_ _0771_ VGND VGND VPWR VPWR _0810_ sky130_fd_sc_hd__a21o_1
XFILLER_84_365 VGND VGND VPWR VPWR sky130_fd_sc_hd__decap_8
XFILLER_65_590 VPWR VGND VPWR VGND sky130_ef_sc_hd__decap_12
XFILLER_37_281 VGND VGND VPWR VPWR sky130_fd_sc_hd__decap_3
X_8827_ net1014 net215 _4194_ net387 VGND VGND VPWR VPWR _0403_ sky130_fd_sc_hd__o211a_1
XTAP_TAPCELL_ROW_80_1208 VGND VPWR sky130_fd_sc_hd__tapvpwrvgnd_1
XFILLER_52_251 VGND VGND VPWR VPWR sky130_fd_sc_hd__fill_1
XPHY_EDGE_ROW_0_Right_0 VGND VGND VPWR VPWR sky130_fd_sc_hd__decap_3
X_8758_ _4128_ _4129_ VGND VGND VPWR VPWR _4130_ sky130_fd_sc_hd__nor2_1
XTAP_TAPCELL_ROW_80_1219 VGND VPWR sky130_fd_sc_hd__tapvpwrvgnd_1
XFILLER_12_126 VPWR VGND VPWR VGND sky130_ef_sc_hd__decap_12
XFILLER_9_609 VGND VGND VPWR VPWR sky130_fd_sc_hd__decap_6
X_7709_ _3099_ _3132_ _3102_ _3155_ _3130_ VGND VGND VPWR VPWR _3156_ sky130_fd_sc_hd__o311a_4
X_8689_ net159 _4052_ _4050_ VGND VGND VPWR VPWR _4063_ sky130_fd_sc_hd__a21oi_1
XFILLER_21_671 VGND VGND VPWR VPWR sky130_fd_sc_hd__fill_1
XFILLER_113_3 VPWR VGND VPWR VGND sky130_ef_sc_hd__decap_12
XFILLER_106_253 VGND VGND VPWR VPWR sky130_fd_sc_hd__decap_3
XTAP_TAPCELL_ROW_91_1348 VGND VPWR sky130_fd_sc_hd__tapvpwrvgnd_1
XFILLER_0_531 VGND VGND VPWR VPWR sky130_fd_sc_hd__fill_1
XFILLER_88_693 VGND VGND VPWR VPWR sky130_fd_sc_hd__decap_3
XFILLER_87_181 VGND VGND VPWR VPWR sky130_fd_sc_hd__decap_8
XFILLER_75_332 VGND VGND VPWR VPWR sky130_fd_sc_hd__decap_4
XFILLER_16_421 VPWR VGND VPWR VGND sky130_ef_sc_hd__decap_12
XFILLER_73_73 VGND VGND VPWR VPWR sky130_fd_sc_hd__decap_3
XFILLER_31_457 VPWR VGND VPWR VGND sky130_ef_sc_hd__decap_12
XTAP_TAPCELL_ROW_100_1455 VGND VPWR sky130_fd_sc_hd__tapvpwrvgnd_1
XFILLER_98_413 VGND VGND VPWR VPWR sky130_fd_sc_hd__fill_1
XFILLER_112_267 VPWR VGND VPWR VGND sky130_ef_sc_hd__decap_12
XFILLER_112_245 VGND VGND VPWR VPWR sky130_fd_sc_hd__decap_6
X_6040_ _1526_ _1528_ _1572_ _1573_ VGND VGND VPWR VPWR _1574_ sky130_fd_sc_hd__o211a_1
XFILLER_3_391 VGND VGND VPWR VPWR sky130_fd_sc_hd__fill_1
XTAP_TAPCELL_ROW_111_1584 VGND VPWR sky130_fd_sc_hd__tapvpwrvgnd_1
XFILLER_79_682 VPWR VGND VPWR VGND sky130_ef_sc_hd__decap_12
XFILLER_79_671 VGND VGND VPWR VPWR sky130_fd_sc_hd__fill_1
XFILLER_66_321 VPWR VGND VPWR VGND sky130_ef_sc_hd__decap_12
XFILLER_39_546 VGND VGND VPWR VPWR sky130_fd_sc_hd__fill_1
X_7991_ _3383_ _3384_ VGND VGND VPWR VPWR _3385_ sky130_fd_sc_hd__nor2_1
XFILLER_66_365 VGND VGND VPWR VPWR sky130_fd_sc_hd__decap_8
XTAP_TAPCELL_ROW_37_703 VGND VPWR sky130_fd_sc_hd__tapvpwrvgnd_1
XFILLER_19_281 VGND VGND VPWR VPWR sky130_fd_sc_hd__decap_8
X_6942_ net482 net330 VGND VGND VPWR VPWR _2411_ sky130_fd_sc_hd__nand2_1
XFILLER_47_590 VGND VGND VPWR VPWR sky130_fd_sc_hd__decap_3
XTAP_TAPCELL_ROW_66_1041 VGND VPWR sky130_fd_sc_hd__tapvpwrvgnd_1
XFILLER_62_560 VGND VGND VPWR VPWR sky130_fd_sc_hd__decap_3
X_6873_ _2303_ _2305_ _2342_ _2343_ VGND VGND VPWR VPWR _2344_ sky130_fd_sc_hd__o211a_1
X_8612_ _3949_ _3950_ _3987_ _3988_ VGND VGND VPWR VPWR _3989_ sky130_fd_sc_hd__o211a_1
X_5824_ _1360_ _1361_ _1323_ _1324_ VGND VGND VPWR VPWR _1363_ sky130_fd_sc_hd__o211ai_2
XTAP_TAPCELL_ROW_17_460 VGND VPWR sky130_fd_sc_hd__tapvpwrvgnd_1
XFILLER_22_435 VGND VGND VPWR VPWR sky130_fd_sc_hd__fill_2
XTAP_TAPCELL_ROW_45_791 VGND VPWR sky130_fd_sc_hd__tapvpwrvgnd_1
XFILLER_22_446 VGND VGND VPWR VPWR sky130_fd_sc_hd__decap_6
X_8543_ _3918_ _3919_ net265 VGND VGND VPWR VPWR _3922_ sky130_fd_sc_hd__o21ai_1
X_5755_ _1293_ _1294_ net490 net354 VGND VGND VPWR VPWR _1296_ sky130_fd_sc_hd__or4bb_1
X_5686_ net1034 _1233_ _1234_ net394 VGND VGND VPWR VPWR _0222_ sky130_fd_sc_hd__o211a_1
X_8474_ pe_array\[2\].u_pe.accum_reg\[20\] net441 net315 VGND VGND VPWR VPWR _3855_
+ sky130_fd_sc_hd__and3_4
X_4706_ _0454_ _0455_ _4415_ _4418_ VGND VGND VPWR VPWR _0457_ sky130_fd_sc_hd__o211a_1
Xrebuffer227 net741 VGND VGND VPWR VPWR net742 sky130_fd_sc_hd__dlygate4sd1_1
X_4637_ net307 net438 VGND VGND VPWR VPWR _4399_ sky130_fd_sc_hd__nand2_1
X_7425_ pe_array\[1\].u_pe.accum_reg\[21\] net447 net340 VGND VGND VPWR VPWR _2881_
+ sky130_fd_sc_hd__and3_1
XTAP_TAPCELL_ROW_77_1181 VGND VPWR sky130_fd_sc_hd__tapvpwrvgnd_1
X_7356_ _2811_ _2812_ _2813_ VGND VGND VPWR VPWR _2815_ sky130_fd_sc_hd__a21oi_1
X_4568_ net492 net299 pe_array\[3\].u_pe.accum_reg\[5\] VGND VGND VPWR VPWR _4332_
+ sky130_fd_sc_hd__a21oi_1
XFILLER_116_584 VGND VGND VPWR VPWR sky130_fd_sc_hd__decap_4
X_6307_ _1832_ _1833_ VGND VGND VPWR VPWR _1834_ sky130_fd_sc_hd__or2_4
X_7287_ _2744_ _2745_ _2746_ VGND VGND VPWR VPWR _2748_ sky130_fd_sc_hd__a21o_1
X_4499_ _4264_ _4265_ VGND VGND VPWR VPWR _4266_ sky130_fd_sc_hd__or2_1
X_6238_ net173 _1731_ _1730_ VGND VGND VPWR VPWR _1767_ sky130_fd_sc_hd__o21bai_1
X_9026_ clknet_leaf_46_clk _0138_ VGND VGND VPWR VPWR net97 sky130_fd_sc_hd__dfxtp_1
X_6169_ _1697_ _1698_ _1685_ VGND VGND VPWR VPWR _1700_ sky130_fd_sc_hd__a21o_1
XFILLER_97_490 VPWR VGND VPWR VGND sky130_ef_sc_hd__decap_12
XFILLER_85_652 VGND VGND VPWR VPWR sky130_fd_sc_hd__fill_1
XFILLER_57_354 VGND VGND VPWR VPWR sky130_fd_sc_hd__decap_8
XFILLER_17_207 VGND VGND VPWR VPWR sky130_fd_sc_hd__fill_1
XFILLER_84_184 VGND VGND VPWR VPWR sky130_fd_sc_hd__decap_6
XFILLER_40_210 VPWR VGND VPWR VGND sky130_ef_sc_hd__decap_12
XFILLER_9_417 VPWR VGND VPWR VGND sky130_ef_sc_hd__decap_12
Xclkbuf_leaf_20_clk clknet_3_5__leaf_clk VGND VGND VPWR VPWR clknet_leaf_20_clk sky130_fd_sc_hd__clkbuf_8
Xclone97 net614 VGND VGND VPWR VPWR net612 sky130_fd_sc_hd__clkbuf_1
XFILLER_4_15 VPWR VGND VPWR VGND sky130_ef_sc_hd__decap_12
XFILLER_95_449 VGND VGND VPWR VPWR sky130_fd_sc_hd__decap_4
XFILLER_76_674 VGND VGND VPWR VPWR sky130_fd_sc_hd__fill_1
XFILLER_84_83 VGND VGND VPWR VPWR sky130_fd_sc_hd__fill_1
XFILLER_44_582 VGND VGND VPWR VPWR sky130_fd_sc_hd__decap_6
XFILLER_31_232 VPWR VGND VPWR VGND sky130_ef_sc_hd__decap_12
XTAP_TAPCELL_ROW_42_761 VGND VPWR sky130_fd_sc_hd__tapvpwrvgnd_1
Xclkbuf_leaf_11_clk clknet_3_5__leaf_clk VGND VGND VPWR VPWR clknet_leaf_11_clk sky130_fd_sc_hd__clkbuf_8
X_5540_ net19 _1226_ _1227_ net327 VGND VGND VPWR VPWR _0083_ sky130_fd_sc_hd__a22o_1
X_5471_ net251 _4275_ VGND VGND VPWR VPWR _1196_ sky130_fd_sc_hd__nand2_1
X_7210_ _2632_ _2633_ _2670_ _2671_ VGND VGND VPWR VPWR _2673_ sky130_fd_sc_hd__o211ai_1
XTAP_TAPCELL_ROW_113_1613 VGND VPWR sky130_fd_sc_hd__tapvpwrvgnd_1
X_8190_ net419 _3579_ VGND VGND VPWR VPWR _0381_ sky130_fd_sc_hd__nor2_1
X_7141_ _2602_ _2604_ _2538_ _2540_ VGND VGND VPWR VPWR _2606_ sky130_fd_sc_hd__o211ai_1
XFILLER_113_554 VGND VGND VPWR VPWR sky130_fd_sc_hd__decap_6
Xfanout429 net432 VGND VGND VPWR VPWR net429 sky130_fd_sc_hd__clkbuf_2
Xfanout418 net423 VGND VGND VPWR VPWR net418 sky130_fd_sc_hd__clkbuf_4
X_7072_ _2532_ _2537_ VGND VGND VPWR VPWR _2538_ sky130_fd_sc_hd__nand2_1
Xfanout407 net408 VGND VGND VPWR VPWR net407 sky130_fd_sc_hd__buf_2
XFILLER_98_298 VGND VGND VPWR VPWR sky130_fd_sc_hd__decap_8
X_6023_ net466 net349 _1521_ _1477_ VGND VGND VPWR VPWR _1557_ sky130_fd_sc_hd__a31o_1
XFILLER_104_27 VGND VGND VPWR VPWR sky130_fd_sc_hd__fill_1
XFILLER_67_641 VPWR VGND VPWR VGND sky130_ef_sc_hd__decap_12
XFILLER_39_332 VGND VGND VPWR VPWR sky130_fd_sc_hd__decap_4
XFILLER_67_685 VPWR VGND VPWR VGND sky130_ef_sc_hd__decap_12
XFILLER_27_505 VGND VGND VPWR VPWR sky130_fd_sc_hd__fill_2
XFILLER_94_493 VGND VGND VPWR VPWR sky130_fd_sc_hd__decap_3
X_7974_ net321 _3334_ _3367_ VGND VGND VPWR VPWR _3368_ sky130_fd_sc_hd__a21bo_1
XFILLER_54_335 VGND VGND VPWR VPWR sky130_fd_sc_hd__fill_1
X_6925_ net424 _2394_ VGND VGND VPWR VPWR _0301_ sky130_fd_sc_hd__nor2_1
XFILLER_82_699 VGND VGND VPWR VPWR sky130_fd_sc_hd__fill_1
X_6856_ net479 net335 net332 net488 VGND VGND VPWR VPWR _2327_ sky130_fd_sc_hd__a22o_1
X_5807_ net588 net344 VGND VGND VPWR VPWR _1346_ sky130_fd_sc_hd__nand2_1
X_6787_ _2258_ _2259_ net511 net330 VGND VGND VPWR VPWR _2260_ sky130_fd_sc_hd__and4bb_1
XFILLER_50_563 VPWR VGND VPWR VGND sky130_ef_sc_hd__decap_12
XFILLER_22_265 VGND VGND VPWR VPWR sky130_fd_sc_hd__decap_3
X_8526_ _3902_ _3903_ _3904_ VGND VGND VPWR VPWR _3906_ sky130_fd_sc_hd__a21o_1
X_5738_ _1259_ _1261_ _1279_ VGND VGND VPWR VPWR _1280_ sky130_fd_sc_hd__a21o_1
XFILLER_50_596 VGND VGND VPWR VPWR sky130_fd_sc_hd__decap_4
X_8457_ _3835_ _3836_ _3837_ VGND VGND VPWR VPWR _3839_ sky130_fd_sc_hd__a21o_1
X_5669_ net989 net366 VGND VGND VPWR VPWR _0210_ sky130_fd_sc_hd__and2_1
XTAP_TAPCELL_ROW_20_488 VGND VPWR sky130_fd_sc_hd__tapvpwrvgnd_1
XTAP_TAPCELL_ROW_20_499 VGND VPWR sky130_fd_sc_hd__tapvpwrvgnd_1
X_8388_ net263 _3770_ _3771_ VGND VGND VPWR VPWR _3772_ sky130_fd_sc_hd__nor3_1
X_7408_ _2864_ _2863_ VGND VGND VPWR VPWR _2865_ sky130_fd_sc_hd__and2b_1
Xhold472 pe_accum\[2\]\[14\] VGND VGND VPWR VPWR net987 sky130_fd_sc_hd__dlygate4sd3_1
X_7339_ _2767_ _2769_ _2796_ _2797_ VGND VGND VPWR VPWR _2798_ sky130_fd_sc_hd__o211a_1
Xhold450 pe_accum\[3\]\[17\] VGND VGND VPWR VPWR net965 sky130_fd_sc_hd__dlygate4sd3_1
XFILLER_2_637 VGND VGND VPWR VPWR sky130_fd_sc_hd__decap_6
Xhold461 pe_accum\[1\]\[11\] VGND VGND VPWR VPWR net976 sky130_fd_sc_hd__dlygate4sd3_1
Xhold483 pe_accum\[2\]\[30\] VGND VGND VPWR VPWR net998 sky130_fd_sc_hd__dlygate4sd3_1
XFILLER_77_405 VGND VGND VPWR VPWR sky130_fd_sc_hd__decap_4
Xhold494 pe_accum\[1\]\[0\] VGND VGND VPWR VPWR net1009 sky130_fd_sc_hd__dlygate4sd3_1
X_9009_ clknet_leaf_30_clk _0121_ VGND VGND VPWR VPWR net78 sky130_fd_sc_hd__dfxtp_1
XFILLER_1_169 VGND VGND VPWR VPWR sky130_fd_sc_hd__fill_2
XFILLER_92_408 VPWR VGND VPWR VGND sky130_ef_sc_hd__decap_12
XFILLER_85_493 VGND VGND VPWR VPWR sky130_fd_sc_hd__decap_8
XFILLER_73_644 VGND VGND VPWR VPWR sky130_fd_sc_hd__decap_4
XFILLER_45_335 VGND VGND VPWR VPWR sky130_fd_sc_hd__fill_1
XFILLER_54_53 VPWR VGND VPWR VGND sky130_ef_sc_hd__decap_12
XTAP_TAPCELL_ROW_28_588 VGND VPWR sky130_fd_sc_hd__tapvpwrvgnd_1
XFILLER_54_97 VPWR VGND VPWR VGND sky130_ef_sc_hd__decap_12
XFILLER_9_225 VGND VGND VPWR VPWR sky130_fd_sc_hd__decap_8
XFILLER_70_85 VGND VGND VPWR VPWR sky130_fd_sc_hd__decap_8
Xclkload17 clknet_leaf_57_clk VGND VGND VPWR VPWR clkload17/Y sky130_fd_sc_hd__clkinv_4
Xclkload39 clknet_leaf_8_clk VGND VGND VPWR VPWR clkload39/Y sky130_fd_sc_hd__inv_12
Xclkload28 clknet_leaf_38_clk VGND VGND VPWR VPWR clkload28/Y sky130_fd_sc_hd__inv_12
XFILLER_110_513 VGND VGND VPWR VPWR sky130_fd_sc_hd__fill_1
XFILLER_68_449 VGND VGND VPWR VPWR sky130_fd_sc_hd__decap_4
XFILLER_49_652 VGND VGND VPWR VPWR sky130_fd_sc_hd__decap_8
Xclkbuf_leaf_0_clk clknet_3_1__leaf_clk VGND VGND VPWR VPWR clknet_leaf_0_clk sky130_fd_sc_hd__clkbuf_8
XFILLER_63_110 VGND VGND VPWR VPWR sky130_fd_sc_hd__fill_2
XTAP_TAPCELL_ROW_47_820 VGND VPWR sky130_fd_sc_hd__tapvpwrvgnd_1
XFILLER_48_195 VGND VGND VPWR VPWR sky130_fd_sc_hd__fill_1
XFILLER_51_305 VGND VGND VPWR VPWR sky130_fd_sc_hd__fill_2
X_4971_ _0715_ _0713_ VGND VGND VPWR VPWR _0716_ sky130_fd_sc_hd__xnor2_2
X_6710_ net906 net237 _1950_ net245 VGND VGND VPWR VPWR _0280_ sky130_fd_sc_hd__o2bb2ai_1
XTAP_TAPCELL_ROW_63_1011 VGND VPWR sky130_fd_sc_hd__tapvpwrvgnd_1
X_7690_ pe_array\[1\].u_pe.accum_reg\[30\] net272 VGND VGND VPWR VPWR _3137_ sky130_fd_sc_hd__xor2_1
XFILLER_51_349 VGND VGND VPWR VPWR sky130_fd_sc_hd__decap_4
X_6641_ _2155_ _2156_ VGND VGND VPWR VPWR _2157_ sky130_fd_sc_hd__nand2b_1
XFILLER_32_596 VGND VGND VPWR VPWR sky130_fd_sc_hd__fill_1
X_6572_ net410 pe_array\[0\].u_pe.accum_reg\[27\] net239 _2089_ VGND VGND VPWR VPWR
+ _2090_ sky130_fd_sc_hd__o2bb2a_1
X_8311_ net401 pe_array\[2\].u_pe.accum_reg\[14\] net217 _3697_ VGND VGND VPWR VPWR
+ _3698_ sky130_fd_sc_hd__o2bb2a_1
X_9291_ clknet_leaf_13_clk _0403_ VGND VGND VPWR VPWR pe_accum\[2\]\[1\] sky130_fd_sc_hd__dfxtp_1
X_5523_ net250 _1125_ VGND VGND VPWR VPWR _1222_ sky130_fd_sc_hd__nand2_2
X_8242_ _3580_ _3629_ VGND VGND VPWR VPWR _3630_ sky130_fd_sc_hd__xnor2_1
X_5454_ pe_array\[3\].u_pe.accum_reg\[30\] _0521_ net630 VGND VGND VPWR VPWR _1182_
+ sky130_fd_sc_hd__o21a_1
XFILLER_105_329 VGND VGND VPWR VPWR sky130_fd_sc_hd__decap_6
X_8173_ net867 net869 _3562_ VGND VGND VPWR VPWR _3563_ sky130_fd_sc_hd__nand3_4
X_5385_ net181 _1115_ VGND VGND VPWR VPWR _1116_ sky130_fd_sc_hd__xor2_1
XTAP_TAPCELL_ROW_74_1140 VGND VPWR sky130_fd_sc_hd__tapvpwrvgnd_1
X_7124_ net268 _2586_ _2587_ VGND VGND VPWR VPWR _2589_ sky130_fd_sc_hd__or3_1
Xfanout204 _0568_ VGND VGND VPWR VPWR net204 sky130_fd_sc_hd__buf_8
XFILLER_115_15 VPWR VGND VPWR VGND sky130_ef_sc_hd__decap_12
Xfanout237 _1239_ VGND VGND VPWR VPWR net237 sky130_fd_sc_hd__buf_2
Xfanout215 net216 VGND VGND VPWR VPWR net215 sky130_fd_sc_hd__clkbuf_2
XFILLER_59_405 VPWR VGND VPWR VGND sky130_ef_sc_hd__decap_12
Xfanout226 net227 VGND VGND VPWR VPWR net226 sky130_fd_sc_hd__buf_2
XFILLER_101_535 VGND VGND VPWR VPWR sky130_fd_sc_hd__decap_8
Xfanout259 net260 VGND VGND VPWR VPWR net259 sky130_fd_sc_hd__buf_8
XFILLER_59_449 VGND VGND VPWR VPWR sky130_fd_sc_hd__decap_3
Xfanout248 net249 VGND VGND VPWR VPWR net248 sky130_fd_sc_hd__dlymetal6s2s_1
X_7055_ _2475_ _2478_ _2520_ _2521_ VGND VGND VPWR VPWR _2522_ sky130_fd_sc_hd__a211oi_4
XFILLER_86_268 VGND VGND VPWR VPWR sky130_fd_sc_hd__decap_8
X_6006_ _1492_ _1495_ _1539_ _1540_ VGND VGND VPWR VPWR _1541_ sky130_fd_sc_hd__a211oi_2
XFILLER_55_600 VGND VGND VPWR VPWR sky130_fd_sc_hd__decap_4
XFILLER_67_493 VGND VGND VPWR VPWR sky130_fd_sc_hd__fill_1
XFILLER_55_677 VGND VGND VPWR VPWR sky130_fd_sc_hd__fill_1
XFILLER_91_29 VGND VGND VPWR VPWR sky130_fd_sc_hd__decap_4
XFILLER_82_474 VGND VGND VPWR VPWR sky130_fd_sc_hd__fill_2
X_7957_ _3341_ _3342_ _3350_ VGND VGND VPWR VPWR _3352_ sky130_fd_sc_hd__a21o_1
XFILLER_70_625 VPWR VGND VPWR VGND sky130_ef_sc_hd__decap_12
X_7888_ _3283_ _3284_ VGND VGND VPWR VPWR _3285_ sky130_fd_sc_hd__nand2b_1
XFILLER_24_23 VGND VGND VPWR VPWR sky130_fd_sc_hd__fill_1
XTAP_TAPCELL_ROW_25_558 VGND VPWR sky130_fd_sc_hd__tapvpwrvgnd_1
XFILLER_42_338 VGND VGND VPWR VPWR sky130_fd_sc_hd__decap_8
X_6908_ _2375_ _2376_ VGND VGND VPWR VPWR _2378_ sky130_fd_sc_hd__xor2_2
X_6839_ _2277_ _2310_ VGND VGND VPWR VPWR _2311_ sky130_fd_sc_hd__and2b_1
XTAP_TAPCELL_ROW_53_889 VGND VPWR sky130_fd_sc_hd__tapvpwrvgnd_1
XFILLER_24_45 VPWR VGND VPWR VGND sky130_ef_sc_hd__decap_12
XFILLER_24_89 VGND VGND VPWR VPWR sky130_fd_sc_hd__decap_3
XFILLER_40_11 VGND VGND VPWR VPWR sky130_fd_sc_hd__fill_2
X_8509_ net441 net315 pe_array\[2\].u_pe.accum_reg\[21\] VGND VGND VPWR VPWR _3889_
+ sky130_fd_sc_hd__a21oi_2
XFILLER_6_3 VPWR VGND VPWR VGND sky130_ef_sc_hd__decap_12
XFILLER_2_445 VPWR VGND VPWR VGND sky130_ef_sc_hd__decap_12
XFILLER_77_213 VGND VGND VPWR VPWR sky130_fd_sc_hd__decap_8
XFILLER_2_489 VGND VGND VPWR VPWR sky130_fd_sc_hd__decap_8
XTAP_TAPCELL_ROW_88_1309 VGND VPWR sky130_fd_sc_hd__tapvpwrvgnd_1
XFILLER_77_268 VGND VGND VPWR VPWR sky130_fd_sc_hd__fill_2
XFILLER_1_27 VPWR VGND VPWR VGND sky130_ef_sc_hd__decap_12
XFILLER_46_611 VGND VGND VPWR VPWR sky130_fd_sc_hd__fill_2
XFILLER_45_165 VGND VGND VPWR VPWR sky130_fd_sc_hd__decap_3
XFILLER_81_51 VGND VGND VPWR VPWR sky130_fd_sc_hd__decap_4
XFILLER_60_179 VGND VGND VPWR VPWR sky130_fd_sc_hd__fill_1
XFILLER_60_168 VGND VGND VPWR VPWR sky130_fd_sc_hd__fill_1
XFILLER_14_574 VGND VGND VPWR VPWR sky130_fd_sc_hd__decap_8
XFILLER_41_360 VGND VGND VPWR VPWR sky130_fd_sc_hd__decap_6
XTAP_TAPCELL_ROW_99_1438 VGND VPWR sky130_fd_sc_hd__tapvpwrvgnd_1
X_5170_ _0906_ _0907_ VGND VGND VPWR VPWR _0908_ sky130_fd_sc_hd__and2b_1
XFILLER_39_3 VGND VGND VPWR VPWR sky130_fd_sc_hd__decap_8
XFILLER_110_321 VPWR VGND VPWR VGND sky130_ef_sc_hd__decap_12
XFILLER_96_533 VGND VGND VPWR VPWR sky130_fd_sc_hd__decap_8
XFILLER_68_279 VPWR VGND VPWR VGND sky130_ef_sc_hd__decap_12
Xinput4 pixel_in[3] VGND VGND VPWR VPWR net4 sky130_fd_sc_hd__buf_6
XTAP_TAPCELL_ROW_108_1545 VGND VPWR sky130_fd_sc_hd__tapvpwrvgnd_1
X_8860_ _3825_ net211 VGND VGND VPWR VPWR _4211_ sky130_fd_sc_hd__nand2_2
XFILLER_76_290 VGND VGND VPWR VPWR sky130_fd_sc_hd__decap_3
XFILLER_36_132 VGND VGND VPWR VPWR sky130_fd_sc_hd__decap_8
X_8791_ _4160_ _4161_ VGND VGND VPWR VPWR _4162_ sky130_fd_sc_hd__nand2_1
X_7811_ net1011 _3212_ net388 VGND VGND VPWR VPWR _3214_ sky130_fd_sc_hd__o21ai_1
X_7742_ net1016 net224 _3180_ net378 VGND VGND VPWR VPWR _0332_ sky130_fd_sc_hd__o211a_1
X_4954_ net206 _0660_ _0658_ VGND VGND VPWR VPWR _0699_ sky130_fd_sc_hd__a21o_1
XFILLER_32_360 VGND VGND VPWR VPWR sky130_fd_sc_hd__decap_4
XTAP_TAPCELL_ROW_50_859 VGND VPWR sky130_fd_sc_hd__tapvpwrvgnd_1
XFILLER_20_511 VGND VGND VPWR VPWR sky130_fd_sc_hd__fill_1
XFILLER_20_533 VGND VGND VPWR VPWR sky130_fd_sc_hd__decap_3
XTAP_TAPCELL_ROW_22_517 VGND VPWR sky130_fd_sc_hd__tapvpwrvgnd_1
X_4885_ _0629_ _0630_ _0585_ _0587_ VGND VGND VPWR VPWR _0632_ sky130_fd_sc_hd__a211o_1
X_7673_ _3086_ _3089_ _3120_ VGND VGND VPWR VPWR _3121_ sky130_fd_sc_hd__o21a_1
XTAP_TAPCELL_ROW_50_848 VGND VPWR sky130_fd_sc_hd__tapvpwrvgnd_1
X_6624_ _2104_ _2106_ _2139_ VGND VGND VPWR VPWR _2140_ sky130_fd_sc_hd__o21a_1
X_6555_ net202 _2071_ VGND VGND VPWR VPWR _2073_ sky130_fd_sc_hd__xnor2_1
X_9274_ clknet_leaf_4_clk _0386_ VGND VGND VPWR VPWR pe_array\[2\].u_pe.accum_reg\[16\]
+ sky130_fd_sc_hd__dfxtp_1
X_5506_ net971 net248 _1213_ net363 VGND VGND VPWR VPWR _0063_ sky130_fd_sc_hd__o211a_1
X_6486_ _1972_ _2006_ VGND VGND VPWR VPWR _2007_ sky130_fd_sc_hd__and2_1
XFILLER_106_638 VGND VGND VPWR VPWR sky130_fd_sc_hd__decap_6
X_8225_ _3611_ _3612_ net825 _3570_ VGND VGND VPWR VPWR _3614_ sky130_fd_sc_hd__a211oi_1
XFILLER_105_137 VGND VGND VPWR VPWR sky130_fd_sc_hd__decap_6
XFILLER_10_69 VGND VGND VPWR VPWR sky130_fd_sc_hd__fill_2
XFILLER_10_47 VGND VGND VPWR VPWR sky130_fd_sc_hd__fill_1
X_5437_ _1164_ _1165_ VGND VGND VPWR VPWR _1166_ sky130_fd_sc_hd__nand2_1
X_8156_ _3495_ _3497_ _3496_ VGND VGND VPWR VPWR _3546_ sky130_fd_sc_hd__o21ba_1
X_5368_ net288 _1097_ _1098_ VGND VGND VPWR VPWR _1099_ sky130_fd_sc_hd__nor3_1
XFILLER_114_693 VGND VGND VPWR VPWR sky130_fd_sc_hd__decap_6
XFILLER_87_533 VGND VGND VPWR VPWR sky130_fd_sc_hd__decap_6
X_8087_ _3416_ _3435_ _3434_ VGND VGND VPWR VPWR _3479_ sky130_fd_sc_hd__a21bo_1
X_5299_ _1006_ _1032_ VGND VGND VPWR VPWR _1033_ sky130_fd_sc_hd__nand2_1
X_7107_ net406 pe_array\[1\].u_pe.accum_reg\[11\] net229 _2572_ VGND VGND VPWR VPWR
+ _2573_ sky130_fd_sc_hd__o2bb2a_2
X_7038_ net270 _2503_ _2504_ VGND VGND VPWR VPWR _2505_ sky130_fd_sc_hd__nor3_1
XFILLER_74_227 VGND VGND VPWR VPWR sky130_fd_sc_hd__decap_8
XTAP_TAPCELL_ROW_58_948 VGND VPWR sky130_fd_sc_hd__tapvpwrvgnd_1
XFILLER_27_110 VGND VGND VPWR VPWR sky130_fd_sc_hd__fill_2
XFILLER_55_430 VPWR VGND VPWR VGND sky130_ef_sc_hd__decap_12
XFILLER_82_271 VGND VGND VPWR VPWR sky130_fd_sc_hd__decap_3
X_8989_ clknet_leaf_29_clk _0101_ VGND VGND VPWR VPWR net56 sky130_fd_sc_hd__dfxtp_1
XTAP_TAPCELL_ROW_2_275 VGND VPWR sky130_fd_sc_hd__tapvpwrvgnd_1
XFILLER_28_677 VGND VGND VPWR VPWR sky130_fd_sc_hd__decap_6
XFILLER_43_614 VGND VGND VPWR VPWR sky130_fd_sc_hd__fill_2
XFILLER_82_282 VGND VGND VPWR VPWR sky130_fd_sc_hd__decap_4
XFILLER_15_349 VPWR VGND VPWR VGND sky130_ef_sc_hd__decap_12
XFILLER_109_410 VGND VGND VPWR VPWR sky130_fd_sc_hd__decap_4
XTAP_TAPCELL_ROW_94_1379 VGND VPWR sky130_fd_sc_hd__tapvpwrvgnd_1
XFILLER_93_503 VGND VGND VPWR VPWR sky130_fd_sc_hd__fill_1
XFILLER_93_536 VGND VGND VPWR VPWR sky130_fd_sc_hd__decap_8
XFILLER_18_165 VGND VGND VPWR VPWR sky130_fd_sc_hd__decap_3
XFILLER_61_422 VPWR VGND VPWR VGND sky130_ef_sc_hd__decap_12
XFILLER_61_455 VGND VGND VPWR VPWR sky130_fd_sc_hd__decap_3
XTAP_TAPCELL_ROW_103_1486 VGND VPWR sky130_fd_sc_hd__tapvpwrvgnd_1
X_4670_ net399 pe_array\[3\].u_pe.accum_reg\[7\] net257 _4431_ VGND VGND VPWR VPWR
+ _4432_ sky130_fd_sc_hd__o2bb2a_1
X_6340_ _1832_ _1863_ _1864_ VGND VGND VPWR VPWR _1866_ sky130_fd_sc_hd__nand3_1
X_6271_ net171 _1797_ _1798_ VGND VGND VPWR VPWR _1799_ sky130_fd_sc_hd__nand3_1
X_8010_ net421 _3403_ VGND VGND VPWR VPWR _0377_ sky130_fd_sc_hd__nor2_1
XTAP_TAPCELL_ROW_71_1110 VGND VPWR sky130_fd_sc_hd__tapvpwrvgnd_1
XFILLER_69_511 VGND VGND VPWR VPWR sky130_fd_sc_hd__decap_4
X_5222_ _0954_ _0955_ net285 VGND VGND VPWR VPWR _0958_ sky130_fd_sc_hd__o21ai_1
X_5153_ _0865_ _0891_ VGND VGND VPWR VPWR _0892_ sky130_fd_sc_hd__nor2_1
XFILLER_111_641 VPWR VGND VPWR VGND sky130_ef_sc_hd__decap_12
XFILLER_111_685 VPWR VGND VPWR VGND sky130_ef_sc_hd__decap_12
XPHY_EDGE_ROW_16_Left_134 VGND VGND VPWR VPWR sky130_fd_sc_hd__decap_3
X_5084_ net206 _0793_ _0791_ VGND VGND VPWR VPWR _0825_ sky130_fd_sc_hd__a21o_1
X_8912_ clknet_leaf_67_clk _0024_ VGND VGND VPWR VPWR pe_array\[3\].u_pe.accum_reg\[12\]
+ sky130_fd_sc_hd__dfxtp_1
XFILLER_112_27 VGND VGND VPWR VPWR sky130_fd_sc_hd__fill_1
X_8843_ net963 net210 _4202_ net380 VGND VGND VPWR VPWR _0411_ sky130_fd_sc_hd__o211a_1
XTAP_TAPCELL_ROW_55_918 VGND VPWR sky130_fd_sc_hd__tapvpwrvgnd_1
XTAP_TAPCELL_ROW_69_1083 VGND VPWR sky130_fd_sc_hd__tapvpwrvgnd_1
X_8774_ _3700_ _4144_ VGND VGND VPWR VPWR _4146_ sky130_fd_sc_hd__xnor2_1
X_5986_ net352 net350 net454 VGND VGND VPWR VPWR _1521_ sky130_fd_sc_hd__o21a_4
XFILLER_52_477 VGND VGND VPWR VPWR sky130_fd_sc_hd__decap_8
XFILLER_40_606 VGND VGND VPWR VPWR sky130_fd_sc_hd__fill_2
X_7725_ _3151_ _3170_ VGND VGND VPWR VPWR _3171_ sky130_fd_sc_hd__xnor2_1
XTAP_TAPCELL_ROW_35_675 VGND VPWR sky130_fd_sc_hd__tapvpwrvgnd_1
X_4937_ _0681_ VGND VGND VPWR VPWR _0682_ sky130_fd_sc_hd__inv_2
XPHY_EDGE_ROW_25_Left_143 VGND VGND VPWR VPWR sky130_fd_sc_hd__decap_3
X_4868_ _0570_ _0571_ _0613_ _0614_ VGND VGND VPWR VPWR _0615_ sky130_fd_sc_hd__o211a_1
X_7656_ net408 pe_array\[1\].u_pe.accum_reg\[28\] net232 _3104_ VGND VGND VPWR VPWR
+ _3105_ sky130_fd_sc_hd__o2bb2a_4
X_6607_ _2122_ _2123_ VGND VGND VPWR VPWR _2124_ sky130_fd_sc_hd__nand2_1
XFILLER_20_352 VPWR VGND VPWR VGND sky130_ef_sc_hd__decap_12
X_4799_ _0545_ _0546_ VGND VGND VPWR VPWR _0548_ sky130_fd_sc_hd__or2_1
X_7587_ _3010_ _3036_ VGND VGND VPWR VPWR _3038_ sky130_fd_sc_hd__xnor2_1
X_6538_ _2056_ _2055_ VGND VGND VPWR VPWR _2057_ sky130_fd_sc_hd__and2b_1
X_6469_ _1986_ _1987_ net276 VGND VGND VPWR VPWR _1990_ sky130_fd_sc_hd__o21ai_1
X_9257_ clknet_leaf_14_clk _0369_ VGND VGND VPWR VPWR pe_array\[2\].u_pe.tap_count\[3\]
+ sky130_fd_sc_hd__dfxtp_1
X_8208_ _3553_ _3555_ _3595_ _3596_ VGND VGND VPWR VPWR _3597_ sky130_fd_sc_hd__o211a_1
X_9188_ clknet_leaf_37_clk _0300_ VGND VGND VPWR VPWR pe_array\[1\].u_pe.accum_reg\[6\]
+ sky130_fd_sc_hd__dfxtp_1
X_8139_ _3528_ _3529_ VGND VGND VPWR VPWR _3530_ sky130_fd_sc_hd__nand2b_1
XTAP_TAPCELL_ROW_7_334 VGND VPWR sky130_fd_sc_hd__tapvpwrvgnd_1
XPHY_EDGE_ROW_34_Left_152 VGND VGND VPWR VPWR sky130_fd_sc_hd__decap_3
XPHY_EDGE_ROW_102_Right_102 VGND VGND VPWR VPWR sky130_fd_sc_hd__decap_3
XFILLER_75_503 VGND VGND VPWR VPWR sky130_fd_sc_hd__fill_1
XFILLER_75_569 VGND VGND VPWR VPWR sky130_fd_sc_hd__decap_3
XFILLER_46_65 VPWR VGND VPWR VGND sky130_ef_sc_hd__decap_12
XFILLER_31_617 VPWR VGND VPWR VGND sky130_ef_sc_hd__decap_12
XFILLER_62_53 VPWR VGND VPWR VGND sky130_ef_sc_hd__decap_12
XPHY_EDGE_ROW_43_Left_161 VGND VGND VPWR VPWR sky130_fd_sc_hd__decap_3
XTAP_TAPCELL_ROW_96_1408 VGND VPWR sky130_fd_sc_hd__tapvpwrvgnd_1
XFILLER_7_15 VPWR VGND VPWR VGND sky130_ef_sc_hd__decap_12
XFILLER_11_385 VGND VGND VPWR VPWR sky130_fd_sc_hd__decap_6
XPHY_EDGE_ROW_52_Left_170 VGND VGND VPWR VPWR sky130_fd_sc_hd__decap_3
XFILLER_3_573 VPWR VGND VPWR VGND sky130_ef_sc_hd__decap_12
XFILLER_3_540 VGND VGND VPWR VPWR sky130_fd_sc_hd__fill_2
XFILLER_78_352 VGND VGND VPWR VPWR sky130_fd_sc_hd__decap_4
XFILLER_78_385 VPWR VGND VPWR VGND sky130_ef_sc_hd__decap_12
XFILLER_66_569 VPWR VGND VPWR VGND sky130_ef_sc_hd__decap_12
XFILLER_81_539 VGND VGND VPWR VPWR sky130_fd_sc_hd__fill_2
XTAP_TAPCELL_ROW_105_1515 VGND VPWR sky130_fd_sc_hd__tapvpwrvgnd_1
XFILLER_74_580 VGND VGND VPWR VPWR sky130_fd_sc_hd__decap_8
X_5840_ net409 pe_array\[0\].u_pe.accum_reg\[6\] net238 _1378_ VGND VGND VPWR VPWR
+ _1379_ sky130_fd_sc_hd__o2bb2a_1
X_5771_ net409 pe_array\[0\].u_pe.accum_reg\[4\] net238 _1311_ VGND VGND VPWR VPWR
+ _1312_ sky130_fd_sc_hd__o2bb2a_1
XFILLER_61_263 VGND VGND VPWR VPWR sky130_fd_sc_hd__decap_8
XFILLER_22_628 VGND VGND VPWR VPWR sky130_fd_sc_hd__decap_3
X_8490_ _3869_ _3870_ VGND VGND VPWR VPWR _3871_ sky130_fd_sc_hd__and2b_1
X_4722_ net476 net291 net289 net483 VGND VGND VPWR VPWR _0472_ sky130_fd_sc_hd__a22oi_1
X_7510_ _2874_ _2876_ _2959_ VGND VGND VPWR VPWR _2963_ sky130_fd_sc_hd__o21bai_1
XTAP_TAPCELL_ROW_32_634 VGND VPWR sky130_fd_sc_hd__tapvpwrvgnd_1
XTAP_TAPCELL_ROW_60_976 VGND VPWR sky130_fd_sc_hd__tapvpwrvgnd_1
X_7441_ net168 _2866_ _2865_ VGND VGND VPWR VPWR _2897_ sky130_fd_sc_hd__a21oi_2
XFILLER_30_661 VPWR VGND VPWR VGND sky130_ef_sc_hd__decap_12
X_4653_ net535 VGND VGND VPWR VPWR _4415_ sky130_fd_sc_hd__inv_2
X_7372_ net196 _2828_ _2829_ VGND VGND VPWR VPWR _2830_ sky130_fd_sc_hd__nand3_1
X_4584_ _4285_ _4314_ _4313_ VGND VGND VPWR VPWR _4348_ sky130_fd_sc_hd__a21o_1
XTAP_TAPCELL_ROW_116_1644 VGND VPWR sky130_fd_sc_hd__tapvpwrvgnd_1
X_9111_ clknet_leaf_20_clk _0223_ VGND VGND VPWR VPWR pe_array\[0\].u_pe.tap_count\[1\]
+ sky130_fd_sc_hd__dfxtp_1
X_6323_ _1847_ _1846_ _1811_ _1813_ VGND VGND VPWR VPWR _1849_ sky130_fd_sc_hd__a211o_1
X_9042_ clknet_leaf_12_clk _0154_ VGND VGND VPWR VPWR net114 sky130_fd_sc_hd__dfxtp_1
XFILLER_115_254 VGND VGND VPWR VPWR sky130_fd_sc_hd__fill_2
XFILLER_107_27 VPWR VGND VPWR VGND sky130_ef_sc_hd__decap_12
X_6254_ net457 net360 pe_array\[0\].u_pe.accum_reg\[17\] VGND VGND VPWR VPWR _1782_
+ sky130_fd_sc_hd__a21oi_1
XFILLER_88_138 VGND VGND VPWR VPWR sky130_fd_sc_hd__fill_2
X_5205_ net178 _0941_ VGND VGND VPWR VPWR _0942_ sky130_fd_sc_hd__xor2_1
X_6185_ net430 _1715_ VGND VGND VPWR VPWR _0240_ sky130_fd_sc_hd__nor2_1
XTAP_TAPCELL_ROW_4_304 VGND VPWR sky130_fd_sc_hd__tapvpwrvgnd_1
XFILLER_111_482 VGND VGND VPWR VPWR sky130_fd_sc_hd__fill_2
XFILLER_96_171 VGND VGND VPWR VPWR sky130_fd_sc_hd__decap_8
X_5136_ net282 _0872_ _0873_ VGND VGND VPWR VPWR _0875_ sky130_fd_sc_hd__or3_1
XFILLER_84_333 VGND VGND VPWR VPWR sky130_fd_sc_hd__fill_1
X_5067_ _0771_ _0807_ _0808_ VGND VGND VPWR VPWR _0809_ sky130_fd_sc_hd__and3_1
XFILLER_25_422 VGND VGND VPWR VPWR sky130_fd_sc_hd__decap_8
XFILLER_37_293 VGND VGND VPWR VPWR sky130_fd_sc_hd__fill_1
X_8826_ net215 _3228_ VGND VGND VPWR VPWR _4194_ sky130_fd_sc_hd__nand2_1
XTAP_TAPCELL_ROW_80_1209 VGND VPWR sky130_fd_sc_hd__tapvpwrvgnd_1
X_8757_ _4126_ _4127_ net264 VGND VGND VPWR VPWR _4129_ sky130_fd_sc_hd__o21a_1
X_5969_ _1420_ _1458_ _1501_ _1502_ VGND VGND VPWR VPWR _1505_ sky130_fd_sc_hd__a22o_1
XFILLER_12_138 VGND VGND VPWR VPWR sky130_fd_sc_hd__fill_2
XFILLER_40_447 VGND VGND VPWR VPWR sky130_fd_sc_hd__fill_1
X_7708_ _3154_ VGND VGND VPWR VPWR _3155_ sky130_fd_sc_hd__inv_2
X_8688_ net420 _4062_ VGND VGND VPWR VPWR _0396_ sky130_fd_sc_hd__nor2_1
XFILLER_20_193 VGND VGND VPWR VPWR sky130_fd_sc_hd__decap_3
XFILLER_32_89 VPWR VGND VPWR VGND sky130_ef_sc_hd__decap_12
X_7639_ _3086_ _3087_ VGND VGND VPWR VPWR _3088_ sky130_fd_sc_hd__or2_1
XFILLER_4_304 VGND VGND VPWR VPWR sky130_fd_sc_hd__decap_4
X_9309_ clknet_leaf_5_clk _0421_ VGND VGND VPWR VPWR pe_accum\[2\]\[19\] sky130_fd_sc_hd__dfxtp_1
XTAP_TAPCELL_ROW_91_1349 VGND VPWR sky130_fd_sc_hd__tapvpwrvgnd_1
XFILLER_88_661 VGND VGND VPWR VPWR sky130_fd_sc_hd__fill_1
XFILLER_57_31 VPWR VGND VPWR VGND sky130_ef_sc_hd__decap_12
XFILLER_35_219 VGND VGND VPWR VPWR sky130_fd_sc_hd__decap_4
XFILLER_113_81 VPWR VGND VPWR VGND sky130_ef_sc_hd__decap_12
XFILLER_90_336 VGND VGND VPWR VPWR sky130_fd_sc_hd__fill_1
XFILLER_16_433 VPWR VGND VPWR VGND sky130_ef_sc_hd__decap_12
XFILLER_16_477 VGND VGND VPWR VPWR sky130_fd_sc_hd__decap_8
XFILLER_31_469 VGND VGND VPWR VPWR sky130_fd_sc_hd__decap_4
XTAP_TAPCELL_ROW_100_1456 VGND VPWR sky130_fd_sc_hd__tapvpwrvgnd_1
XFILLER_12_661 VGND VGND VPWR VPWR sky130_fd_sc_hd__decap_4
XFILLER_8_621 VPWR VGND VPWR VGND sky130_ef_sc_hd__decap_12
XFILLER_112_213 VPWR VGND VPWR VGND sky130_ef_sc_hd__decap_12
XFILLER_86_609 VGND VGND VPWR VPWR sky130_fd_sc_hd__fill_2
XFILLER_112_279 VGND VGND VPWR VPWR sky130_fd_sc_hd__fill_1
XTAP_TAPCELL_ROW_111_1585 VGND VPWR sky130_fd_sc_hd__tapvpwrvgnd_1
XFILLER_79_694 VGND VGND VPWR VPWR sky130_fd_sc_hd__decap_6
XFILLER_21_3 VPWR VGND VPWR VGND sky130_ef_sc_hd__decap_12
XFILLER_39_514 VGND VGND VPWR VPWR sky130_fd_sc_hd__decap_6
XFILLER_66_333 VPWR VGND VPWR VGND sky130_ef_sc_hd__decap_12
X_7990_ net497 net485 net312 net310 VGND VGND VPWR VPWR _3384_ sky130_fd_sc_hd__and4_1
XFILLER_66_355 VGND VGND VPWR VPWR sky130_fd_sc_hd__decap_8
X_6941_ _2408_ _2409_ VGND VGND VPWR VPWR _2410_ sky130_fd_sc_hd__nor2_1
XTAP_TAPCELL_ROW_66_1042 VGND VPWR sky130_fd_sc_hd__tapvpwrvgnd_1
X_6872_ _2341_ _2340_ _2323_ VGND VGND VPWR VPWR _2343_ sky130_fd_sc_hd__a21o_1
X_8611_ _3984_ _3985_ net573 VGND VGND VPWR VPWR _3988_ sky130_fd_sc_hd__o21ai_1
X_5823_ _1323_ _1324_ _1360_ _1361_ VGND VGND VPWR VPWR _1362_ sky130_fd_sc_hd__a211o_1
XTAP_TAPCELL_ROW_17_461 VGND VPWR sky130_fd_sc_hd__tapvpwrvgnd_1
X_8542_ _3919_ _3918_ net262 VGND VGND VPWR VPWR _3921_ sky130_fd_sc_hd__or3_4
XFILLER_10_609 VPWR VGND VPWR VGND sky130_ef_sc_hd__decap_12
XTAP_TAPCELL_ROW_45_792 VGND VPWR sky130_fd_sc_hd__tapvpwrvgnd_1
X_5754_ _1293_ _1294_ net490 net354 VGND VGND VPWR VPWR _1295_ sky130_fd_sc_hd__and4bb_1
X_5685_ net508 net1034 VGND VGND VPWR VPWR _1234_ sky130_fd_sc_hd__nand2_1
X_8473_ net420 _3854_ VGND VGND VPWR VPWR _0389_ sky130_fd_sc_hd__nor2_1
X_4705_ _4415_ _4418_ _0454_ _0455_ VGND VGND VPWR VPWR _0456_ sky130_fd_sc_hd__a211oi_2
XFILLER_108_519 VPWR VGND VPWR VGND sky130_ef_sc_hd__decap_12
X_7424_ net447 net339 pe_array\[1\].u_pe.accum_reg\[21\] VGND VGND VPWR VPWR _2880_
+ sky130_fd_sc_hd__a21oi_1
X_4636_ _4357_ _4397_ VGND VGND VPWR VPWR _4398_ sky130_fd_sc_hd__xnor2_1
XFILLER_116_530 VGND VGND VPWR VPWR sky130_fd_sc_hd__fill_2
X_7355_ _2811_ _2812_ _2813_ VGND VGND VPWR VPWR _2814_ sky130_fd_sc_hd__and3_1
X_6306_ _1829_ _1830_ _1831_ VGND VGND VPWR VPWR _1833_ sky130_fd_sc_hd__a21oi_1
XFILLER_78_19 VGND VGND VPWR VPWR sky130_fd_sc_hd__decap_8
XTAP_TAPCELL_ROW_77_1182 VGND VPWR sky130_fd_sc_hd__tapvpwrvgnd_1
X_4567_ _4327_ _4330_ VGND VGND VPWR VPWR _4331_ sky130_fd_sc_hd__xnor2_1
X_7286_ _2744_ _2745_ _2746_ VGND VGND VPWR VPWR _2747_ sky130_fd_sc_hd__nand3_1
X_4498_ net306 net305 net500 net495 VGND VGND VPWR VPWR _4265_ sky130_fd_sc_hd__and4_1
XFILLER_103_257 VPWR VGND VPWR VGND sky130_ef_sc_hd__decap_12
XFILLER_89_458 VPWR VGND VPWR VGND sky130_ef_sc_hd__decap_12
X_6237_ _1763_ _1764_ net173 VGND VGND VPWR VPWR _1766_ sky130_fd_sc_hd__o21ai_1
X_9025_ clknet_leaf_45_clk _0137_ VGND VGND VPWR VPWR net96 sky130_fd_sc_hd__dfxtp_1
X_6168_ _1685_ _1697_ _1698_ VGND VGND VPWR VPWR _1699_ sky130_fd_sc_hd__nand3_1
XFILLER_76_119 VGND VGND VPWR VPWR sky130_fd_sc_hd__fill_1
XFILLER_69_193 VGND VGND VPWR VPWR sky130_fd_sc_hd__decap_6
X_5119_ net183 _0827_ _0826_ VGND VGND VPWR VPWR _0859_ sky130_fd_sc_hd__o21bai_1
XFILLER_84_141 VGND VGND VPWR VPWR sky130_fd_sc_hd__decap_3
X_6099_ _1629_ _1630_ _1584_ _1586_ VGND VGND VPWR VPWR _1632_ sky130_fd_sc_hd__a211o_1
XFILLER_57_377 VGND VGND VPWR VPWR sky130_fd_sc_hd__decap_8
XFILLER_72_314 VGND VGND VPWR VPWR sky130_fd_sc_hd__decap_8
XFILLER_57_388 VGND VGND VPWR VPWR sky130_fd_sc_hd__decap_4
X_8809_ _4148_ _4172_ _4173_ _4157_ _4176_ VGND VGND VPWR VPWR _4179_ sky130_fd_sc_hd__a32o_2
XFILLER_53_594 VGND VGND VPWR VPWR sky130_fd_sc_hd__decap_4
XFILLER_53_561 VGND VGND VPWR VPWR sky130_fd_sc_hd__decap_4
XFILLER_13_447 VGND VGND VPWR VPWR sky130_fd_sc_hd__fill_1
XFILLER_40_222 VGND VGND VPWR VPWR sky130_fd_sc_hd__fill_2
XFILLER_43_55 VGND VGND VPWR VPWR sky130_fd_sc_hd__fill_1
XFILLER_9_429 VPWR VGND VPWR VGND sky130_ef_sc_hd__decap_12
Xclone76 net593 VGND VGND VPWR VPWR net591 sky130_fd_sc_hd__clkbuf_1
XFILLER_107_585 VGND VGND VPWR VPWR sky130_fd_sc_hd__fill_2
XFILLER_4_27 VGND VGND VPWR VPWR sky130_fd_sc_hd__fill_1
XFILLER_68_63 VPWR VGND VPWR VGND sky130_ef_sc_hd__decap_12
XFILLER_68_85 VGND VGND VPWR VPWR sky130_fd_sc_hd__decap_8
XFILLER_90_100 VGND VGND VPWR VPWR sky130_fd_sc_hd__fill_1
XFILLER_75_174 VGND VGND VPWR VPWR sky130_fd_sc_hd__decap_8
XFILLER_44_561 VGND VGND VPWR VPWR sky130_fd_sc_hd__fill_1
XTAP_TAPCELL_ROW_14_420 VGND VPWR sky130_fd_sc_hd__tapvpwrvgnd_1
XFILLER_16_285 VGND VGND VPWR VPWR sky130_fd_sc_hd__decap_6
XFILLER_31_244 VPWR VGND VPWR VGND sky130_ef_sc_hd__decap_12
XTAP_TAPCELL_ROW_42_762 VGND VPWR sky130_fd_sc_hd__tapvpwrvgnd_1
X_5470_ net1015 net254 _1195_ net372 VGND VGND VPWR VPWR _0045_ sky130_fd_sc_hd__o211a_1
XTAP_TAPCELL_ROW_113_1614 VGND VPWR sky130_fd_sc_hd__tapvpwrvgnd_1
X_7140_ _2538_ _2540_ _2602_ _2604_ VGND VGND VPWR VPWR _2605_ sky130_fd_sc_hd__a211o_1
Xfanout419 net423 VGND VGND VPWR VPWR net419 sky130_fd_sc_hd__clkbuf_4
X_7071_ _2535_ _2536_ VGND VGND VPWR VPWR _2537_ sky130_fd_sc_hd__xor2_1
Xfanout408 _4225_ VGND VGND VPWR VPWR net408 sky130_fd_sc_hd__clkbuf_4
XFILLER_98_277 VGND VGND VPWR VPWR sky130_fd_sc_hd__decap_6
X_6022_ _1514_ _1515_ _1513_ VGND VGND VPWR VPWR _1556_ sky130_fd_sc_hd__a21oi_1
XFILLER_67_653 VPWR VGND VPWR VGND sky130_ef_sc_hd__decap_12
XFILLER_54_303 VGND VGND VPWR VPWR sky130_fd_sc_hd__decap_4
XFILLER_39_366 VGND VGND VPWR VPWR sky130_fd_sc_hd__decap_4
XFILLER_67_697 VGND VGND VPWR VPWR sky130_fd_sc_hd__decap_3
X_7973_ net470 net321 net322 net463 VGND VGND VPWR VPWR _3367_ sky130_fd_sc_hd__a22o_1
X_6924_ net406 pe_array\[1\].u_pe.accum_reg\[7\] net231 _2393_ VGND VGND VPWR VPWR
+ _2394_ sky130_fd_sc_hd__o2bb2a_1
X_6855_ net488 net479 net335 net332 VGND VGND VPWR VPWR _2326_ sky130_fd_sc_hd__and4_1
X_5806_ net506 net346 net344 net515 VGND VGND VPWR VPWR _1345_ sky130_fd_sc_hd__a22o_1
X_6786_ net494 net334 net333 net583 VGND VGND VPWR VPWR _2259_ sky130_fd_sc_hd__a22oi_1
XFILLER_50_575 VGND VGND VPWR VPWR sky130_fd_sc_hd__decap_4
X_8525_ _3902_ _3903_ _3904_ VGND VGND VPWR VPWR _3905_ sky130_fd_sc_hd__and3_1
X_5737_ _1275_ _1278_ VGND VGND VPWR VPWR _1279_ sky130_fd_sc_hd__xnor2_1
XTAP_TAPCELL_ROW_79_1200 VGND VPWR sky130_fd_sc_hd__tapvpwrvgnd_1
XFILLER_108_305 VGND VGND VPWR VPWR sky130_fd_sc_hd__decap_3
X_8456_ _3835_ _3836_ _3837_ VGND VGND VPWR VPWR _3838_ sky130_fd_sc_hd__nand3_1
X_7407_ _2833_ _2835_ VGND VGND VPWR VPWR _2864_ sky130_fd_sc_hd__and2b_1
X_5668_ net983 net366 VGND VGND VPWR VPWR _0209_ sky130_fd_sc_hd__and2_1
XTAP_TAPCELL_ROW_20_489 VGND VPWR sky130_fd_sc_hd__tapvpwrvgnd_1
X_8387_ pe_array\[2\].u_pe.accum_reg\[17\] net441 net314 VGND VGND VPWR VPWR _3771_
+ sky130_fd_sc_hd__and3_1
X_5599_ net960 net373 VGND VGND VPWR VPWR _0140_ sky130_fd_sc_hd__and2_1
X_4619_ _4379_ _4380_ _4345_ _4342_ VGND VGND VPWR VPWR _4382_ sky130_fd_sc_hd__a211o_1
Xhold440 pe_accum\[1\]\[30\] VGND VGND VPWR VPWR net955 sky130_fd_sc_hd__dlygate4sd3_1
X_7338_ _2793_ _2794_ net269 VGND VGND VPWR VPWR _2797_ sky130_fd_sc_hd__o21ai_1
Xhold462 pe_accum\[3\]\[23\] VGND VGND VPWR VPWR net977 sky130_fd_sc_hd__dlygate4sd3_1
Xhold451 pe_accum\[1\]\[28\] VGND VGND VPWR VPWR net966 sky130_fd_sc_hd__dlygate4sd3_1
Xhold484 pe_accum\[0\]\[31\] VGND VGND VPWR VPWR net999 sky130_fd_sc_hd__dlygate4sd3_1
XFILLER_104_544 VPWR VGND VPWR VGND sky130_ef_sc_hd__decap_12
Xhold495 pe_accum\[0\]\[9\] VGND VGND VPWR VPWR net1010 sky130_fd_sc_hd__dlygate4sd3_1
Xhold473 pe_accum\[3\]\[0\] VGND VGND VPWR VPWR net988 sky130_fd_sc_hd__dlygate4sd3_1
XPHY_EDGE_ROW_8_Left_126 VGND VGND VPWR VPWR sky130_fd_sc_hd__decap_3
X_7269_ net427 _2730_ VGND VGND VPWR VPWR _0309_ sky130_fd_sc_hd__nor2_1
XFILLER_104_577 VGND VGND VPWR VPWR sky130_fd_sc_hd__fill_1
X_9008_ clknet_leaf_30_clk _0120_ VGND VGND VPWR VPWR net77 sky130_fd_sc_hd__dfxtp_1
XFILLER_58_642 VGND VGND VPWR VPWR sky130_fd_sc_hd__fill_2
XFILLER_85_461 VGND VGND VPWR VPWR sky130_fd_sc_hd__decap_8
XFILLER_57_141 VGND VGND VPWR VPWR sky130_fd_sc_hd__fill_2
XFILLER_18_506 VGND VGND VPWR VPWR sky130_fd_sc_hd__fill_2
XFILLER_72_111 VGND VGND VPWR VPWR sky130_fd_sc_hd__fill_1
XFILLER_57_196 VGND VGND VPWR VPWR sky130_fd_sc_hd__decap_3
XFILLER_57_185 VGND VGND VPWR VPWR sky130_fd_sc_hd__fill_2
XFILLER_60_317 VPWR VGND VPWR VGND sky130_ef_sc_hd__decap_12
XFILLER_54_65 VPWR VGND VPWR VGND sky130_ef_sc_hd__decap_12
XTAP_TAPCELL_ROW_28_589 VGND VPWR sky130_fd_sc_hd__tapvpwrvgnd_1
XFILLER_13_233 VGND VGND VPWR VPWR sky130_fd_sc_hd__decap_3
XFILLER_13_211 VGND VGND VPWR VPWR sky130_fd_sc_hd__decap_8
XFILLER_41_575 VPWR VGND VPWR VGND sky130_ef_sc_hd__decap_12
XFILLER_41_597 VPWR VGND VPWR VGND sky130_ef_sc_hd__decap_12
Xclkload29 clknet_leaf_39_clk VGND VGND VPWR VPWR clkload29/Y sky130_fd_sc_hd__inv_8
Xclkload18 clknet_leaf_62_clk VGND VGND VPWR VPWR clkload18/Y sky130_fd_sc_hd__inv_8
XFILLER_5_498 VGND VGND VPWR VPWR sky130_fd_sc_hd__fill_1
XFILLER_1_671 VGND VGND VPWR VPWR sky130_fd_sc_hd__fill_1
XFILLER_95_236 VPWR VGND VPWR VGND sky130_ef_sc_hd__decap_12
XFILLER_95_225 VGND VGND VPWR VPWR sky130_fd_sc_hd__decap_4
XFILLER_49_631 VGND VGND VPWR VPWR sky130_fd_sc_hd__decap_8
XFILLER_64_601 VPWR VGND VPWR VGND sky130_ef_sc_hd__decap_12
XFILLER_48_141 VPWR VGND VPWR VGND sky130_ef_sc_hd__decap_12
XFILLER_95_94 VPWR VGND VPWR VGND sky130_ef_sc_hd__decap_12
XFILLER_76_483 VGND VGND VPWR VPWR sky130_fd_sc_hd__fill_1
XFILLER_64_645 VPWR VGND VPWR VGND sky130_ef_sc_hd__decap_12
XFILLER_36_336 VGND VGND VPWR VPWR sky130_fd_sc_hd__decap_8
XTAP_TAPCELL_ROW_47_821 VGND VPWR sky130_fd_sc_hd__tapvpwrvgnd_1
XFILLER_48_163 VGND VGND VPWR VPWR sky130_fd_sc_hd__decap_8
XFILLER_91_442 VGND VGND VPWR VPWR sky130_fd_sc_hd__decap_6
XFILLER_63_133 VGND VGND VPWR VPWR sky130_fd_sc_hd__fill_1
X_4970_ _0677_ _0640_ _0714_ VGND VGND VPWR VPWR _0715_ sky130_fd_sc_hd__a21o_1
XTAP_TAPCELL_ROW_63_1012 VGND VPWR sky130_fd_sc_hd__tapvpwrvgnd_1
X_6640_ _2119_ _2154_ VGND VGND VPWR VPWR _2156_ sky130_fd_sc_hd__nand2_1
XFILLER_32_553 VGND VGND VPWR VPWR sky130_fd_sc_hd__decap_8
X_6571_ _2087_ _2088_ VGND VGND VPWR VPWR _2089_ sky130_fd_sc_hd__xnor2_1
X_8310_ _3696_ _3695_ VGND VGND VPWR VPWR _3697_ sky130_fd_sc_hd__xnor2_2
X_5522_ net983 net250 _1221_ net366 VGND VGND VPWR VPWR _0071_ sky130_fd_sc_hd__o211a_1
XFILLER_117_113 VPWR VGND VPWR VGND sky130_ef_sc_hd__decap_12
X_9290_ clknet_leaf_13_clk _0402_ VGND VGND VPWR VPWR pe_accum\[2\]\[0\] sky130_fd_sc_hd__dfxtp_1
XFILLER_105_308 VGND VGND VPWR VPWR sky130_fd_sc_hd__fill_1
X_8241_ _3626_ _3627_ VGND VGND VPWR VPWR _3629_ sky130_fd_sc_hd__xnor2_1
X_5453_ net182 _1169_ _1168_ VGND VGND VPWR VPWR _1181_ sky130_fd_sc_hd__a21oi_1
X_8172_ _3559_ _3560_ net190 VGND VGND VPWR VPWR _3562_ sky130_fd_sc_hd__a21o_1
X_5384_ _1113_ _1114_ VGND VGND VPWR VPWR _1115_ sky130_fd_sc_hd__nor2_1
XFILLER_113_330 VGND VGND VPWR VPWR sky130_fd_sc_hd__decap_6
XTAP_TAPCELL_ROW_74_1141 VGND VPWR sky130_fd_sc_hd__tapvpwrvgnd_1
Xfanout205 net207 VGND VGND VPWR VPWR net205 sky130_fd_sc_hd__buf_6
X_7123_ net268 _2586_ _2587_ VGND VGND VPWR VPWR _2588_ sky130_fd_sc_hd__nor3_1
XFILLER_115_27 VPWR VGND VPWR VGND sky130_ef_sc_hd__decap_12
Xfanout238 net241 VGND VGND VPWR VPWR net238 sky130_fd_sc_hd__buf_2
Xfanout216 _3215_ VGND VGND VPWR VPWR net216 sky130_fd_sc_hd__buf_2
Xfanout227 net228 VGND VGND VPWR VPWR net227 sky130_fd_sc_hd__clkbuf_2
Xfanout249 net254 VGND VGND VPWR VPWR net249 sky130_fd_sc_hd__clkbuf_4
X_7054_ _2518_ _2519_ _2451_ _2453_ VGND VGND VPWR VPWR _2521_ sky130_fd_sc_hd__o211a_1
XFILLER_74_409 VGND VGND VPWR VPWR sky130_fd_sc_hd__decap_8
X_6005_ _1536_ _1538_ _1520_ VGND VGND VPWR VPWR _1540_ sky130_fd_sc_hd__a21oi_1
XFILLER_27_303 VGND VGND VPWR VPWR sky130_fd_sc_hd__fill_1
XFILLER_54_122 VGND VGND VPWR VPWR sky130_fd_sc_hd__fill_2
XFILLER_91_19 VGND VGND VPWR VPWR sky130_fd_sc_hd__decap_6
X_7956_ _3341_ _3342_ _3350_ VGND VGND VPWR VPWR _3351_ sky130_fd_sc_hd__nand3_1
XFILLER_70_637 VGND VGND VPWR VPWR sky130_fd_sc_hd__decap_6
XFILLER_54_177 VGND VGND VPWR VPWR sky130_fd_sc_hd__fill_1
XFILLER_42_306 VGND VGND VPWR VPWR sky130_fd_sc_hd__fill_2
XFILLER_42_317 VGND VGND VPWR VPWR sky130_fd_sc_hd__fill_1
X_7887_ _3231_ _3236_ _3256_ VGND VGND VPWR VPWR _3284_ sky130_fd_sc_hd__o21a_1
XTAP_TAPCELL_ROW_85_1270 VGND VPWR sky130_fd_sc_hd__tapvpwrvgnd_1
XTAP_TAPCELL_ROW_25_548 VGND VPWR sky130_fd_sc_hd__tapvpwrvgnd_1
XFILLER_35_391 VGND VGND VPWR VPWR sky130_fd_sc_hd__fill_1
X_6907_ _2375_ _2376_ VGND VGND VPWR VPWR _2377_ sky130_fd_sc_hd__and2b_1
X_6838_ _2307_ _2308_ VGND VGND VPWR VPWR _2310_ sky130_fd_sc_hd__xnor2_1
XFILLER_24_57 VGND VGND VPWR VPWR sky130_fd_sc_hd__fill_1
XTAP_TAPCELL_ROW_25_559 VGND VPWR sky130_fd_sc_hd__tapvpwrvgnd_1
XFILLER_50_372 VGND VGND VPWR VPWR sky130_fd_sc_hd__fill_2
XFILLER_10_203 VGND VGND VPWR VPWR sky130_fd_sc_hd__fill_1
X_8508_ net420 _3888_ VGND VGND VPWR VPWR _0390_ sky130_fd_sc_hd__nor2_1
X_6769_ _2224_ _2225_ _2241_ _2242_ VGND VGND VPWR VPWR _2243_ sky130_fd_sc_hd__o211a_1
X_8439_ _3789_ _3790_ _3819_ _3820_ VGND VGND VPWR VPWR _3822_ sky130_fd_sc_hd__o22a_1
XFILLER_2_457 VPWR VGND VPWR VGND sky130_ef_sc_hd__decap_12
XFILLER_77_203 VGND VGND VPWR VPWR sky130_fd_sc_hd__fill_1
XFILLER_104_396 VPWR VGND VPWR VGND sky130_ef_sc_hd__decap_12
XFILLER_77_258 VGND VGND VPWR VPWR sky130_fd_sc_hd__fill_2
XFILLER_92_228 VGND VGND VPWR VPWR sky130_fd_sc_hd__decap_4
XFILLER_1_39 VPWR VGND VPWR VGND sky130_ef_sc_hd__decap_12
XFILLER_45_111 VGND VGND VPWR VPWR sky130_fd_sc_hd__fill_1
XFILLER_46_645 VGND VGND VPWR VPWR sky130_fd_sc_hd__decap_6
XFILLER_14_531 VGND VGND VPWR VPWR sky130_fd_sc_hd__fill_1
XFILLER_60_147 VGND VGND VPWR VPWR sky130_fd_sc_hd__fill_1
XFILLER_81_85 VPWR VGND VPWR VGND sky130_ef_sc_hd__decap_12
XTAP_TAPCELL_ROW_99_1439 VGND VPWR sky130_fd_sc_hd__tapvpwrvgnd_1
XPHY_EDGE_ROW_116_Right_116 VGND VGND VPWR VPWR sky130_fd_sc_hd__decap_3
XFILLER_115_617 VPWR VGND VPWR VGND sky130_ef_sc_hd__decap_12
XFILLER_60_7 VPWR VGND VPWR VGND sky130_ef_sc_hd__decap_12
XFILLER_108_680 VPWR VGND VPWR VGND sky130_ef_sc_hd__decap_12
XFILLER_96_501 VGND VGND VPWR VPWR sky130_fd_sc_hd__fill_1
XFILLER_110_333 VPWR VGND VPWR VGND sky130_ef_sc_hd__decap_12
XFILLER_110_399 VGND VGND VPWR VPWR sky130_fd_sc_hd__decap_8
Xinput5 pixel_in[4] VGND VGND VPWR VPWR net5 sky130_fd_sc_hd__clkbuf_2
XFILLER_49_494 VGND VGND VPWR VPWR sky130_fd_sc_hd__decap_3
XTAP_TAPCELL_ROW_108_1546 VGND VPWR sky130_fd_sc_hd__tapvpwrvgnd_1
X_7810_ pe_array\[2\].u_pe.tap_count\[2\] _3212_ VGND VGND VPWR VPWR _3213_ sky130_fd_sc_hd__and2_1
XFILLER_64_442 VPWR VGND VPWR VGND sky130_ef_sc_hd__decap_12
X_8790_ _4127_ _4128_ _4159_ VGND VGND VPWR VPWR _4161_ sky130_fd_sc_hd__or3_1
XFILLER_64_464 VPWR VGND VPWR VGND sky130_ef_sc_hd__decap_12
XFILLER_52_615 VGND VGND VPWR VPWR sky130_fd_sc_hd__fill_1
X_7741_ net224 _2352_ VGND VGND VPWR VPWR _3180_ sky130_fd_sc_hd__nand2_1
XFILLER_17_391 VGND VGND VPWR VPWR sky130_fd_sc_hd__fill_1
X_4953_ _0695_ _0696_ net206 VGND VGND VPWR VPWR _0698_ sky130_fd_sc_hd__a21o_1
XFILLER_51_169 VPWR VGND VPWR VGND sky130_ef_sc_hd__decap_12
XFILLER_51_147 VGND VGND VPWR VPWR sky130_fd_sc_hd__decap_8
X_7672_ _2700_ _3118_ VGND VGND VPWR VPWR _3120_ sky130_fd_sc_hd__xnor2_1
X_6623_ _2137_ _2138_ VGND VGND VPWR VPWR _2139_ sky130_fd_sc_hd__nor2_1
XTAP_TAPCELL_ROW_22_518 VGND VPWR sky130_fd_sc_hd__tapvpwrvgnd_1
XFILLER_32_372 VPWR VGND VPWR VGND sky130_ef_sc_hd__decap_12
X_4884_ _0585_ _0587_ _0629_ _0630_ VGND VGND VPWR VPWR _0631_ sky130_fd_sc_hd__o211a_1
XTAP_TAPCELL_ROW_50_849 VGND VPWR sky130_fd_sc_hd__tapvpwrvgnd_1
X_6554_ net198 _2071_ VGND VGND VPWR VPWR _2072_ sky130_fd_sc_hd__nor2_1
XPHY_EDGE_ROW_89_Left_207 VGND VGND VPWR VPWR sky130_fd_sc_hd__decap_3
X_6485_ _2004_ _2005_ VGND VGND VPWR VPWR _2006_ sky130_fd_sc_hd__nor2_1
X_9273_ clknet_leaf_4_clk _0385_ VGND VGND VPWR VPWR pe_array\[2\].u_pe.accum_reg\[15\]
+ sky130_fd_sc_hd__dfxtp_1
X_5505_ _0870_ net248 VGND VGND VPWR VPWR _1213_ sky130_fd_sc_hd__nand2_1
X_8224_ net826 _3570_ _3611_ _3612_ VGND VGND VPWR VPWR _3613_ sky130_fd_sc_hd__o211a_1
XFILLER_10_15 VPWR VGND VPWR VGND sky130_ef_sc_hd__decap_12
X_5436_ _1133_ _1135_ _1163_ VGND VGND VPWR VPWR _1165_ sky130_fd_sc_hd__o21ai_1
X_8155_ _3538_ _3543_ VGND VGND VPWR VPWR _3545_ sky130_fd_sc_hd__xnor2_1
X_5367_ pe_array\[3\].u_pe.accum_reg\[28\] _0520_ VGND VGND VPWR VPWR _1098_ sky130_fd_sc_hd__nor2_1
X_8086_ _3475_ _3476_ _3461_ VGND VGND VPWR VPWR _3478_ sky130_fd_sc_hd__a21o_1
X_5298_ _1029_ _1030_ VGND VGND VPWR VPWR _1032_ sky130_fd_sc_hd__xnor2_1
X_7106_ _2570_ _2571_ VGND VGND VPWR VPWR _2572_ sky130_fd_sc_hd__xnor2_4
XFILLER_113_193 VGND VGND VPWR VPWR sky130_fd_sc_hd__decap_4
XFILLER_19_35 VGND VGND VPWR VPWR sky130_fd_sc_hd__decap_3
XFILLER_19_46 VGND VGND VPWR VPWR sky130_fd_sc_hd__decap_4
X_7037_ net526 net341 pe_array\[1\].u_pe.accum_reg\[10\] VGND VGND VPWR VPWR _2504_
+ sky130_fd_sc_hd__a21oi_2
XFILLER_47_409 VPWR VGND VPWR VGND sky130_ef_sc_hd__decap_12
XPHY_EDGE_ROW_98_Left_216 VGND VGND VPWR VPWR sky130_fd_sc_hd__decap_3
XTAP_TAPCELL_ROW_58_949 VGND VPWR sky130_fd_sc_hd__tapvpwrvgnd_1
XFILLER_28_601 VPWR VGND VPWR VGND sky130_ef_sc_hd__decap_12
XFILLER_55_442 VGND VGND VPWR VPWR sky130_fd_sc_hd__decap_6
XFILLER_27_133 VGND VGND VPWR VPWR sky130_fd_sc_hd__decap_6
XFILLER_82_250 VGND VGND VPWR VPWR sky130_fd_sc_hd__fill_2
X_8988_ clknet_leaf_30_clk _0100_ VGND VGND VPWR VPWR net55 sky130_fd_sc_hd__dfxtp_1
XFILLER_55_475 VGND VGND VPWR VPWR sky130_fd_sc_hd__decap_8
XTAP_TAPCELL_ROW_2_276 VGND VPWR sky130_fd_sc_hd__tapvpwrvgnd_1
X_7939_ net470 net463 net322 VGND VGND VPWR VPWR _3334_ sky130_fd_sc_hd__and3_1
XFILLER_42_136 VGND VGND VPWR VPWR sky130_fd_sc_hd__decap_4
XFILLER_11_567 VGND VGND VPWR VPWR sky130_fd_sc_hd__fill_1
XFILLER_51_55 VGND VGND VPWR VPWR sky130_fd_sc_hd__fill_1
XFILLER_76_52 VGND VGND VPWR VPWR sky130_fd_sc_hd__decap_6
XFILLER_78_589 VPWR VGND VPWR VGND sky130_ef_sc_hd__decap_12
XFILLER_76_74 VGND VGND VPWR VPWR sky130_fd_sc_hd__decap_3
XFILLER_61_434 VGND VGND VPWR VPWR sky130_fd_sc_hd__decap_8
XFILLER_33_136 VGND VGND VPWR VPWR sky130_fd_sc_hd__decap_6
XFILLER_33_158 VGND VGND VPWR VPWR sky130_fd_sc_hd__decap_8
XTAP_TAPCELL_ROW_103_1487 VGND VPWR sky130_fd_sc_hd__tapvpwrvgnd_1
XFILLER_41_191 VPWR VGND VPWR VGND sky130_ef_sc_hd__decap_12
X_6270_ _1794_ _1795_ _1796_ VGND VGND VPWR VPWR _1798_ sky130_fd_sc_hd__a21o_1
XFILLER_51_3 VPWR VGND VPWR VGND sky130_ef_sc_hd__decap_12
XFILLER_6_593 VPWR VGND VPWR VGND sky130_ef_sc_hd__decap_12
XFILLER_6_582 VGND VGND VPWR VPWR sky130_fd_sc_hd__decap_6
XTAP_TAPCELL_ROW_71_1111 VGND VPWR sky130_fd_sc_hd__tapvpwrvgnd_1
XTAP_TAPCELL_ROW_71_1100 VGND VPWR sky130_fd_sc_hd__tapvpwrvgnd_1
X_5221_ net285 _0954_ _0955_ VGND VGND VPWR VPWR _0957_ sky130_fd_sc_hd__or3_1
XFILLER_102_119 VGND VGND VPWR VPWR sky130_fd_sc_hd__decap_6
X_5152_ _0888_ _0889_ VGND VGND VPWR VPWR _0891_ sky130_fd_sc_hd__xor2_2
XFILLER_111_653 VPWR VGND VPWR VGND sky130_ef_sc_hd__decap_12
XFILLER_111_697 VGND VGND VPWR VPWR sky130_fd_sc_hd__decap_3
X_5083_ _0821_ _0822_ net205 VGND VGND VPWR VPWR _0824_ sky130_fd_sc_hd__a21o_1
XTAP_TAPCELL_ROW_55_908 VGND VPWR sky130_fd_sc_hd__tapvpwrvgnd_1
X_8911_ clknet_leaf_67_clk _0023_ VGND VGND VPWR VPWR pe_array\[3\].u_pe.accum_reg\[11\]
+ sky130_fd_sc_hd__dfxtp_1
XFILLER_37_442 VGND VGND VPWR VPWR sky130_fd_sc_hd__decap_3
X_8842_ net216 _3492_ VGND VGND VPWR VPWR _4202_ sky130_fd_sc_hd__nand2_1
XTAP_TAPCELL_ROW_55_919 VGND VPWR sky130_fd_sc_hd__tapvpwrvgnd_1
XFILLER_25_615 VGND VGND VPWR VPWR sky130_fd_sc_hd__fill_1
XFILLER_37_464 VGND VGND VPWR VPWR sky130_fd_sc_hd__fill_1
XFILLER_37_475 VGND VGND VPWR VPWR sky130_fd_sc_hd__fill_2
X_8773_ net159 _4144_ VGND VGND VPWR VPWR _4145_ sky130_fd_sc_hd__and2_1
XTAP_TAPCELL_ROW_69_1084 VGND VPWR sky130_fd_sc_hd__tapvpwrvgnd_1
XFILLER_52_434 VGND VGND VPWR VPWR sky130_fd_sc_hd__decap_3
XFILLER_24_125 VGND VGND VPWR VPWR sky130_fd_sc_hd__fill_1
XTAP_TAPCELL_ROW_82_1240 VGND VPWR sky130_fd_sc_hd__tapvpwrvgnd_1
X_5985_ _1510_ _1518_ VGND VGND VPWR VPWR _1520_ sky130_fd_sc_hd__xnor2_1
X_7724_ _3161_ _3169_ VGND VGND VPWR VPWR _3170_ sky130_fd_sc_hd__xnor2_1
XFILLER_12_309 VPWR VGND VPWR VGND sky130_ef_sc_hd__decap_12
XTAP_TAPCELL_ROW_35_676 VGND VPWR sky130_fd_sc_hd__tapvpwrvgnd_1
X_4936_ _0644_ _0651_ _0650_ VGND VGND VPWR VPWR _0681_ sky130_fd_sc_hd__a21o_1
XANTENNA_10 net423 VGND VGND VPWR VPWR sky130_fd_sc_hd__diode_2
X_4867_ _0610_ _0611_ net286 VGND VGND VPWR VPWR _0614_ sky130_fd_sc_hd__o21ai_1
X_7655_ _3102_ _3103_ VGND VGND VPWR VPWR _3104_ sky130_fd_sc_hd__or2_4
X_6606_ _2084_ _2121_ VGND VGND VPWR VPWR _2123_ sky130_fd_sc_hd__or2_1
X_7586_ _3010_ _3036_ VGND VGND VPWR VPWR _3037_ sky130_fd_sc_hd__and2_1
X_6537_ net172 _2027_ _2026_ VGND VGND VPWR VPWR _2056_ sky130_fd_sc_hd__a21oi_1
X_4798_ _0545_ _0546_ VGND VGND VPWR VPWR _0547_ sky130_fd_sc_hd__nor2_1
XFILLER_4_508 VGND VGND VPWR VPWR sky130_fd_sc_hd__fill_1
X_6468_ net276 _1986_ _1987_ VGND VGND VPWR VPWR _1989_ sky130_fd_sc_hd__or3_1
XFILLER_97_18 VGND VGND VPWR VPWR sky130_fd_sc_hd__decap_4
X_9256_ clknet_leaf_13_clk _0368_ VGND VGND VPWR VPWR pe_array\[2\].u_pe.tap_count\[2\]
+ sky130_fd_sc_hd__dfxtp_1
Xoutput150 net150 VGND VGND VPWR VPWR result_valid sky130_fd_sc_hd__buf_2
X_6399_ net456 net359 pe_array\[0\].u_pe.accum_reg\[22\] VGND VGND VPWR VPWR _1922_
+ sky130_fd_sc_hd__a21oi_1
X_8207_ _3592_ _3593_ net683 VGND VGND VPWR VPWR _3596_ sky130_fd_sc_hd__o21ai_1
X_9187_ clknet_leaf_39_clk _0299_ VGND VGND VPWR VPWR pe_array\[1\].u_pe.accum_reg\[5\]
+ sky130_fd_sc_hd__dfxtp_1
X_5419_ _1147_ _1148_ VGND VGND VPWR VPWR _1149_ sky130_fd_sc_hd__nor2_1
XFILLER_87_320 VGND VGND VPWR VPWR sky130_fd_sc_hd__decap_8
X_8138_ _3526_ _3527_ _3480_ _3482_ VGND VGND VPWR VPWR _3529_ sky130_fd_sc_hd__a211o_1
XTAP_TAPCELL_ROW_7_335 VGND VPWR sky130_fd_sc_hd__tapvpwrvgnd_1
XFILLER_102_642 VGND VGND VPWR VPWR sky130_fd_sc_hd__fill_2
XFILLER_87_386 VGND VGND VPWR VPWR sky130_fd_sc_hd__decap_6
X_8069_ _3458_ _3459_ VGND VGND VPWR VPWR _3461_ sky130_fd_sc_hd__xnor2_1
XFILLER_90_529 VGND VGND VPWR VPWR sky130_fd_sc_hd__decap_3
XFILLER_28_475 VGND VGND VPWR VPWR sky130_fd_sc_hd__fill_1
XFILLER_43_401 VPWR VGND VPWR VGND sky130_ef_sc_hd__decap_12
XFILLER_46_77 VGND VGND VPWR VPWR sky130_fd_sc_hd__decap_6
XFILLER_16_637 VGND VGND VPWR VPWR sky130_fd_sc_hd__fill_1
XFILLER_43_445 VGND VGND VPWR VPWR sky130_fd_sc_hd__decap_3
XFILLER_70_275 VPWR VGND VPWR VGND sky130_ef_sc_hd__decap_12
XFILLER_24_670 VGND VGND VPWR VPWR sky130_fd_sc_hd__fill_2
XFILLER_62_65 VGND VGND VPWR VPWR sky130_fd_sc_hd__decap_4
XFILLER_30_139 VGND VGND VPWR VPWR sky130_fd_sc_hd__fill_1
XFILLER_7_313 VPWR VGND VPWR VGND sky130_ef_sc_hd__decap_12
XFILLER_7_27 VPWR VGND VPWR VGND sky130_ef_sc_hd__decap_12
XTAP_TAPCELL_ROW_96_1409 VGND VPWR sky130_fd_sc_hd__tapvpwrvgnd_1
XFILLER_7_357 VGND VGND VPWR VPWR sky130_fd_sc_hd__fill_1
XFILLER_98_629 VGND VGND VPWR VPWR sky130_fd_sc_hd__fill_1
XFILLER_97_139 VPWR VGND VPWR VGND sky130_ef_sc_hd__decap_12
XFILLER_97_117 VGND VGND VPWR VPWR sky130_fd_sc_hd__decap_3
XFILLER_3_585 VPWR VGND VPWR VGND sky130_ef_sc_hd__decap_12
XFILLER_78_342 VGND VGND VPWR VPWR sky130_fd_sc_hd__decap_4
XFILLER_78_397 VGND VGND VPWR VPWR sky130_fd_sc_hd__fill_1
XFILLER_93_334 VGND VGND VPWR VPWR sky130_fd_sc_hd__fill_2
XFILLER_19_431 VGND VGND VPWR VPWR sky130_fd_sc_hd__decap_3
Xclone134 _2543_ VGND VGND VPWR VPWR net649 sky130_fd_sc_hd__clkbuf_1
XFILLER_93_378 VPWR VGND VPWR VGND sky130_ef_sc_hd__decap_12
XFILLER_81_529 VGND VGND VPWR VPWR sky130_fd_sc_hd__fill_2
XFILLER_19_475 VPWR VGND VPWR VGND sky130_ef_sc_hd__decap_12
XTAP_TAPCELL_ROW_105_1516 VGND VPWR sky130_fd_sc_hd__tapvpwrvgnd_1
XFILLER_99_3 VPWR VGND VPWR VGND sky130_ef_sc_hd__decap_12
X_5770_ _1309_ _1310_ VGND VGND VPWR VPWR _1311_ sky130_fd_sc_hd__or2_1
X_4721_ net483 net476 net291 net289 VGND VGND VPWR VPWR _0471_ sky130_fd_sc_hd__and4_1
XTAP_TAPCELL_ROW_32_635 VGND VPWR sky130_fd_sc_hd__tapvpwrvgnd_1
XTAP_TAPCELL_ROW_60_977 VGND VPWR sky130_fd_sc_hd__tapvpwrvgnd_1
X_7440_ net156 _2895_ VGND VGND VPWR VPWR _2896_ sky130_fd_sc_hd__xnor2_1
XFILLER_30_673 VGND VGND VPWR VPWR sky130_fd_sc_hd__fill_1
X_4652_ _4413_ _4412_ _4411_ VGND VGND VPWR VPWR _4414_ sky130_fd_sc_hd__and3_1
X_9110_ clknet_leaf_20_clk _0222_ VGND VGND VPWR VPWR pe_array\[0\].u_pe.tap_count\[0\]
+ sky130_fd_sc_hd__dfxtp_1
XTAP_TAPCELL_ROW_12_392 VGND VPWR sky130_fd_sc_hd__tapvpwrvgnd_1
X_7371_ _2826_ _2827_ _2793_ _2795_ VGND VGND VPWR VPWR _2829_ sky130_fd_sc_hd__a211o_1
X_4583_ _4345_ _4346_ VGND VGND VPWR VPWR _4347_ sky130_fd_sc_hd__and2b_1
XTAP_TAPCELL_ROW_116_1645 VGND VPWR sky130_fd_sc_hd__tapvpwrvgnd_1
X_6322_ _1811_ _1813_ _1846_ _1847_ VGND VGND VPWR VPWR _1848_ sky130_fd_sc_hd__o211ai_2
X_9041_ clknet_leaf_10_clk _0153_ VGND VGND VPWR VPWR net113 sky130_fd_sc_hd__dfxtp_1
XFILLER_107_39 VPWR VGND VPWR VGND sky130_ef_sc_hd__decap_12
X_6253_ pe_array\[0\].u_pe.accum_reg\[17\] net457 net360 VGND VGND VPWR VPWR _1781_
+ sky130_fd_sc_hd__and3_1
XFILLER_88_106 VPWR VGND VPWR VGND sky130_ef_sc_hd__decap_12
XFILLER_103_417 VGND VGND VPWR VPWR sky130_fd_sc_hd__fill_1
X_5204_ _0938_ _0939_ VGND VGND VPWR VPWR _0941_ sky130_fd_sc_hd__xnor2_1
X_6184_ net412 pe_array\[0\].u_pe.accum_reg\[14\] net240 _1714_ VGND VGND VPWR VPWR
+ _1715_ sky130_fd_sc_hd__o2bb2a_1
XTAP_TAPCELL_ROW_4_305 VGND VPWR sky130_fd_sc_hd__tapvpwrvgnd_1
XFILLER_97_673 VPWR VGND VPWR VGND sky130_ef_sc_hd__decap_12
XFILLER_69_386 VGND VGND VPWR VPWR sky130_fd_sc_hd__decap_6
X_5135_ net284 _0872_ _0873_ VGND VGND VPWR VPWR _0874_ sky130_fd_sc_hd__nor3_1
XFILLER_84_345 VGND VGND VPWR VPWR sky130_fd_sc_hd__decap_6
XFILLER_57_548 VPWR VGND VPWR VGND sky130_ef_sc_hd__decap_12
X_5066_ _0804_ _0805_ _0806_ VGND VGND VPWR VPWR _0808_ sky130_fd_sc_hd__a21o_1
X_8825_ net1004 net214 _4193_ net387 VGND VGND VPWR VPWR _0402_ sky130_fd_sc_hd__o211a_1
X_8756_ net264 _4126_ _4127_ VGND VGND VPWR VPWR _4128_ sky130_fd_sc_hd__nor3_1
X_5968_ _1502_ _1458_ _1501_ _1420_ VGND VGND VPWR VPWR _1504_ sky130_fd_sc_hd__nand4_4
X_4919_ _0662_ _0661_ _0663_ VGND VGND VPWR VPWR _0665_ sky130_fd_sc_hd__a21o_1
X_7707_ _3127_ _3153_ VGND VGND VPWR VPWR _3154_ sky130_fd_sc_hd__xnor2_1
X_8687_ net402 pe_array\[2\].u_pe.accum_reg\[26\] net218 _4061_ VGND VGND VPWR VPWR
+ _4062_ sky130_fd_sc_hd__o2bb2a_4
X_5899_ net480 net349 VGND VGND VPWR VPWR _1436_ sky130_fd_sc_hd__nand2_1
XFILLER_21_673 VGND VGND VPWR VPWR sky130_fd_sc_hd__decap_8
X_7638_ _3049_ _3051_ _3085_ VGND VGND VPWR VPWR _3087_ sky130_fd_sc_hd__nor3_1
X_7569_ _3018_ _3019_ VGND VGND VPWR VPWR _3020_ sky130_fd_sc_hd__nor2_1
X_9308_ clknet_leaf_5_clk _0420_ VGND VGND VPWR VPWR pe_accum\[2\]\[18\] sky130_fd_sc_hd__dfxtp_1
X_9239_ clknet_leaf_42_clk _0351_ VGND VGND VPWR VPWR pe_accum\[1\]\[25\] sky130_fd_sc_hd__dfxtp_1
XFILLER_0_533 VGND VGND VPWR VPWR sky130_fd_sc_hd__fill_2
XFILLER_57_43 VPWR VGND VPWR VGND sky130_ef_sc_hd__decap_12
XFILLER_56_581 VGND VGND VPWR VPWR sky130_fd_sc_hd__decap_6
XFILLER_16_401 VPWR VGND VPWR VGND sky130_ef_sc_hd__decap_12
XFILLER_113_93 VPWR VGND VPWR VGND sky130_ef_sc_hd__decap_12
XFILLER_90_359 VGND VGND VPWR VPWR sky130_fd_sc_hd__decap_4
XFILLER_71_551 VGND VGND VPWR VPWR sky130_fd_sc_hd__decap_8
XFILLER_16_445 VGND VGND VPWR VPWR sky130_fd_sc_hd__decap_4
XTAP_TAPCELL_ROW_100_1457 VGND VPWR sky130_fd_sc_hd__tapvpwrvgnd_1
XFILLER_8_633 VGND VGND VPWR VPWR sky130_fd_sc_hd__decap_8
XFILLER_8_699 VGND VGND VPWR VPWR sky130_fd_sc_hd__fill_1
XFILLER_112_225 VPWR VGND VPWR VGND sky130_ef_sc_hd__decap_12
XFILLER_98_448 VPWR VGND VPWR VGND sky130_ef_sc_hd__decap_12
XFILLER_3_393 VPWR VGND VPWR VGND sky130_ef_sc_hd__decap_12
XTAP_TAPCELL_ROW_111_1586 VGND VPWR sky130_fd_sc_hd__tapvpwrvgnd_1
XFILLER_79_673 VGND VGND VPWR VPWR sky130_fd_sc_hd__fill_2
XFILLER_94_654 VGND VGND VPWR VPWR sky130_fd_sc_hd__fill_2
XFILLER_14_3 VPWR VGND VPWR VGND sky130_ef_sc_hd__decap_12
XFILLER_39_559 VGND VGND VPWR VPWR sky130_fd_sc_hd__fill_1
XFILLER_81_304 VGND VGND VPWR VPWR sky130_fd_sc_hd__fill_1
X_6940_ net472 net464 net334 net332 VGND VGND VPWR VPWR _2409_ sky130_fd_sc_hd__and4_1
XFILLER_81_337 VPWR VGND VPWR VGND sky130_ef_sc_hd__decap_12
XFILLER_81_315 VGND VGND VPWR VPWR sky130_fd_sc_hd__decap_8
XTAP_TAPCELL_ROW_66_1043 VGND VPWR sky130_fd_sc_hd__tapvpwrvgnd_1
X_6871_ _2323_ _2340_ _2341_ VGND VGND VPWR VPWR _2342_ sky130_fd_sc_hd__nand3_1
X_8610_ net573 _3984_ _3985_ VGND VGND VPWR VPWR _3987_ sky130_fd_sc_hd__or3_1
X_5822_ _1358_ _1359_ _1357_ VGND VGND VPWR VPWR _1361_ sky130_fd_sc_hd__o21a_1
XTAP_TAPCELL_ROW_17_462 VGND VPWR sky130_fd_sc_hd__tapvpwrvgnd_1
XFILLER_34_253 VGND VGND VPWR VPWR sky130_fd_sc_hd__fill_1
X_8541_ net265 _3918_ _3919_ VGND VGND VPWR VPWR _3920_ sky130_fd_sc_hd__nor3_1
X_5753_ pe_array\[0\].u_pe.accum_reg\[4\] net480 net356 VGND VGND VPWR VPWR _1294_
+ sky130_fd_sc_hd__and3_4
XTAP_TAPCELL_ROW_45_793 VGND VPWR sky130_fd_sc_hd__tapvpwrvgnd_1
X_4704_ _0451_ _0453_ _0435_ VGND VGND VPWR VPWR _0455_ sky130_fd_sc_hd__a21oi_1
X_5684_ net239 VGND VGND VPWR VPWR _1233_ sky130_fd_sc_hd__inv_2
X_8472_ net402 pe_array\[2\].u_pe.accum_reg\[19\] net217 _3853_ VGND VGND VPWR VPWR
+ _3854_ sky130_fd_sc_hd__o2bb2a_4
X_7423_ net425 _2879_ VGND VGND VPWR VPWR _0314_ sky130_fd_sc_hd__nor2_1
X_4635_ _4391_ _4395_ VGND VGND VPWR VPWR _4397_ sky130_fd_sc_hd__xor2_1
X_7354_ net168 _2784_ _2783_ VGND VGND VPWR VPWR _2813_ sky130_fd_sc_hd__a21bo_1
X_4566_ _4328_ _4329_ VGND VGND VPWR VPWR _4330_ sky130_fd_sc_hd__nor2_1
X_6305_ _1829_ _1830_ _1831_ VGND VGND VPWR VPWR _1832_ sky130_fd_sc_hd__and3_1
XTAP_TAPCELL_ROW_77_1183 VGND VPWR sky130_fd_sc_hd__tapvpwrvgnd_1
XTAP_TAPCELL_ROW_77_1172 VGND VPWR sky130_fd_sc_hd__tapvpwrvgnd_1
XFILLER_103_225 VPWR VGND VPWR VGND sky130_ef_sc_hd__decap_12
XFILLER_1_319 VGND VGND VPWR VPWR sky130_fd_sc_hd__fill_1
X_7285_ net165 _2714_ _2713_ VGND VGND VPWR VPWR _2746_ sky130_fd_sc_hd__o21bai_1
X_9024_ clknet_leaf_45_clk _0136_ VGND VGND VPWR VPWR net95 sky130_fd_sc_hd__dfxtp_1
X_4497_ net305 net592 net495 net306 VGND VGND VPWR VPWR _4264_ sky130_fd_sc_hd__a22oi_1
X_6236_ net173 _1763_ _1764_ VGND VGND VPWR VPWR _1765_ sky130_fd_sc_hd__or3_4
XFILLER_103_269 VGND VGND VPWR VPWR sky130_fd_sc_hd__decap_8
X_6167_ _1694_ _1695_ _1696_ VGND VGND VPWR VPWR _1698_ sky130_fd_sc_hd__a21o_1
X_5118_ _0855_ _0856_ net183 VGND VGND VPWR VPWR _0858_ sky130_fd_sc_hd__o21ai_1
XFILLER_85_687 VPWR VGND VPWR VGND sky130_ef_sc_hd__decap_12
XFILLER_84_164 VGND VGND VPWR VPWR sky130_fd_sc_hd__decap_3
XPHY_EDGE_ROW_71_Left_189 VGND VGND VPWR VPWR sky130_fd_sc_hd__decap_3
X_6098_ _1584_ _1586_ _1629_ _1630_ VGND VGND VPWR VPWR _1631_ sky130_fd_sc_hd__o211a_1
XFILLER_84_197 VPWR VGND VPWR VGND sky130_ef_sc_hd__decap_12
X_5049_ _0750_ _0752_ _0789_ _0790_ VGND VGND VPWR VPWR _0791_ sky130_fd_sc_hd__o211a_1
XFILLER_45_529 VGND VGND VPWR VPWR sky130_fd_sc_hd__fill_2
XFILLER_53_551 VGND VGND VPWR VPWR sky130_fd_sc_hd__decap_8
XFILLER_27_79 VGND VGND VPWR VPWR sky130_fd_sc_hd__decap_8
X_8808_ net421 _4178_ VGND VGND VPWR VPWR _0400_ sky130_fd_sc_hd__nor2_1
X_8739_ _4076_ _4078_ _4111_ VGND VGND VPWR VPWR _4112_ sky130_fd_sc_hd__o21a_1
XPHY_EDGE_ROW_80_Left_198 VGND VGND VPWR VPWR sky130_fd_sc_hd__decap_3
XFILLER_40_289 VGND VGND VPWR VPWR sky130_fd_sc_hd__decap_3
Xclone77 net501 VGND VGND VPWR VPWR net592 sky130_fd_sc_hd__clkbuf_1
Xclone99 net608 VGND VGND VPWR VPWR net614 sky130_fd_sc_hd__clkbuf_1
XFILLER_4_124 VPWR VGND VPWR VGND sky130_ef_sc_hd__decap_12
XFILLER_68_75 VGND VGND VPWR VPWR sky130_fd_sc_hd__fill_1
XFILLER_0_385 VGND VGND VPWR VPWR sky130_fd_sc_hd__decap_3
XFILLER_48_312 VGND VGND VPWR VPWR sky130_fd_sc_hd__fill_1
XFILLER_63_304 VPWR VGND VPWR VGND sky130_ef_sc_hd__decap_12
XFILLER_48_356 VGND VGND VPWR VPWR sky130_fd_sc_hd__fill_2
XFILLER_91_635 VGND VGND VPWR VPWR sky130_fd_sc_hd__fill_1
XTAP_TAPCELL_ROW_14_421 VGND VPWR sky130_fd_sc_hd__tapvpwrvgnd_1
XFILLER_31_212 VPWR VGND VPWR VGND sky130_ef_sc_hd__decap_12
XFILLER_31_256 VPWR VGND VPWR VGND sky130_ef_sc_hd__decap_12
XTAP_TAPCELL_ROW_42_752 VGND VPWR sky130_fd_sc_hd__tapvpwrvgnd_1
XTAP_TAPCELL_ROW_42_763 VGND VPWR sky130_fd_sc_hd__tapvpwrvgnd_1
XTAP_TAPCELL_ROW_113_1615 VGND VPWR sky130_fd_sc_hd__tapvpwrvgnd_1
XTAP_TAPCELL_ROW_113_1604 VGND VPWR sky130_fd_sc_hd__tapvpwrvgnd_1
Xfanout409 net410 VGND VGND VPWR VPWR net409 sky130_fd_sc_hd__buf_2
X_7070_ net482 _4234_ VGND VGND VPWR VPWR _2536_ sky130_fd_sc_hd__nor2_1
XFILLER_86_429 VPWR VGND VPWR VGND sky130_ef_sc_hd__decap_12
X_6021_ _1550_ net151 _1549_ VGND VGND VPWR VPWR _1555_ sky130_fd_sc_hd__a21o_1
XFILLER_58_109 VGND VGND VPWR VPWR sky130_fd_sc_hd__decap_6
XFILLER_100_228 VPWR VGND VPWR VGND sky130_ef_sc_hd__decap_12
XFILLER_104_29 VPWR VGND VPWR VGND sky130_ef_sc_hd__decap_12
XFILLER_67_665 VGND VGND VPWR VPWR sky130_fd_sc_hd__decap_6
XFILLER_81_101 VGND VGND VPWR VPWR sky130_fd_sc_hd__decap_4
X_7972_ net561 net324 VGND VGND VPWR VPWR _3366_ sky130_fd_sc_hd__nand2_1
XFILLER_81_145 VGND VGND VPWR VPWR sky130_fd_sc_hd__fill_2
XFILLER_81_123 VGND VGND VPWR VPWR sky130_fd_sc_hd__decap_3
X_6923_ _2391_ _2392_ VGND VGND VPWR VPWR _2393_ sky130_fd_sc_hd__nand2_1
X_6854_ net479 net332 VGND VGND VPWR VPWR _2325_ sky130_fd_sc_hd__nand2_1
X_5805_ net506 net348 _1319_ _1317_ VGND VGND VPWR VPWR _1344_ sky130_fd_sc_hd__a31o_1
X_6785_ net587 net494 net334 net332 VGND VGND VPWR VPWR _2258_ sky130_fd_sc_hd__and4_1
XFILLER_13_15 VPWR VGND VPWR VGND sky130_ef_sc_hd__decap_12
X_8524_ net176 _3867_ _3866_ VGND VGND VPWR VPWR _3904_ sky130_fd_sc_hd__a21o_1
X_5736_ _1276_ _1277_ VGND VGND VPWR VPWR _1278_ sky130_fd_sc_hd__nor2_1
X_8455_ net191 _3805_ _3803_ VGND VGND VPWR VPWR _3837_ sky130_fd_sc_hd__a21o_1
XTAP_TAPCELL_ROW_79_1201 VGND VPWR sky130_fd_sc_hd__tapvpwrvgnd_1
X_5667_ net919 net366 VGND VGND VPWR VPWR _0208_ sky130_fd_sc_hd__and2_1
X_7406_ net166 _2862_ VGND VGND VPWR VPWR _2863_ sky130_fd_sc_hd__xnor2_1
X_4618_ _4342_ _4345_ _4379_ net545 VGND VGND VPWR VPWR _4381_ sky130_fd_sc_hd__o211ai_4
X_8386_ net441 net313 pe_array\[2\].u_pe.accum_reg\[17\] VGND VGND VPWR VPWR _3770_
+ sky130_fd_sc_hd__a21oi_1
X_5598_ net922 net375 VGND VGND VPWR VPWR _0139_ sky130_fd_sc_hd__and2_1
Xhold452 pe_accum\[2\]\[27\] VGND VGND VPWR VPWR net967 sky130_fd_sc_hd__dlygate4sd3_1
Xhold430 pe_accum\[0\]\[0\] VGND VGND VPWR VPWR net945 sky130_fd_sc_hd__dlygate4sd3_1
XFILLER_104_501 VGND VGND VPWR VPWR sky130_fd_sc_hd__decap_8
X_7337_ net269 _2793_ _2794_ VGND VGND VPWR VPWR _2796_ sky130_fd_sc_hd__or3_4
X_4549_ _4310_ _4311_ _4312_ VGND VGND VPWR VPWR _4314_ sky130_fd_sc_hd__a21o_1
Xhold463 pe_accum\[1\]\[9\] VGND VGND VPWR VPWR net978 sky130_fd_sc_hd__dlygate4sd3_1
Xhold441 pe_accum\[1\]\[26\] VGND VGND VPWR VPWR net956 sky130_fd_sc_hd__dlygate4sd3_1
XFILLER_104_556 VPWR VGND VPWR VGND sky130_ef_sc_hd__decap_12
Xhold496 pe_array\[2\].u_pe.tap_count\[2\] VGND VGND VPWR VPWR net1011 sky130_fd_sc_hd__dlygate4sd3_1
Xhold485 pe_accum\[3\]\[31\] VGND VGND VPWR VPWR net1000 sky130_fd_sc_hd__dlygate4sd3_1
X_7268_ net408 pe_array\[1\].u_pe.accum_reg\[15\] net229 _2729_ VGND VGND VPWR VPWR
+ _2730_ sky130_fd_sc_hd__o2bb2a_4
Xhold474 pe_accum\[3\]\[28\] VGND VGND VPWR VPWR net989 sky130_fd_sc_hd__dlygate4sd3_1
XFILLER_89_278 VGND VGND VPWR VPWR sky130_fd_sc_hd__fill_2
X_6219_ _1668_ _1706_ _1707_ _1741_ VGND VGND VPWR VPWR _1748_ sky130_fd_sc_hd__or4b_4
X_9007_ clknet_leaf_31_clk _0119_ VGND VGND VPWR VPWR net76 sky130_fd_sc_hd__dfxtp_1
XFILLER_58_610 VGND VGND VPWR VPWR sky130_fd_sc_hd__fill_2
X_7199_ _2576_ _2661_ VGND VGND VPWR VPWR _2662_ sky130_fd_sc_hd__xnor2_1
XFILLER_73_657 VPWR VGND VPWR VGND sky130_ef_sc_hd__decap_12
XFILLER_45_337 VPWR VGND VPWR VGND sky130_ef_sc_hd__decap_12
XFILLER_60_329 VGND VGND VPWR VPWR sky130_fd_sc_hd__fill_2
XFILLER_26_562 VPWR VGND VPWR VGND sky130_ef_sc_hd__decap_12
XFILLER_54_77 VGND VGND VPWR VPWR sky130_fd_sc_hd__decap_6
XFILLER_13_223 VGND VGND VPWR VPWR sky130_fd_sc_hd__fill_1
XPHY_EDGE_ROW_109_Left_227 VGND VGND VPWR VPWR sky130_fd_sc_hd__decap_3
XFILLER_9_216 VGND VGND VPWR VPWR sky130_fd_sc_hd__decap_3
XFILLER_110_83 VGND VGND VPWR VPWR sky130_fd_sc_hd__fill_1
XFILLER_70_43 VGND VGND VPWR VPWR sky130_fd_sc_hd__decap_8
XFILLER_13_289 VPWR VGND VPWR VGND sky130_ef_sc_hd__decap_12
XFILLER_13_278 VGND VGND VPWR VPWR sky130_fd_sc_hd__fill_2
XFILLER_41_587 VGND VGND VPWR VPWR sky130_fd_sc_hd__decap_6
Xclkload19 clknet_leaf_66_clk VGND VGND VPWR VPWR clkload19/Y sky130_fd_sc_hd__clkinv_4
XFILLER_114_309 VGND VGND VPWR VPWR sky130_fd_sc_hd__decap_3
XFILLER_79_30 VGND VGND VPWR VPWR sky130_fd_sc_hd__decap_3
XFILLER_79_52 VGND VGND VPWR VPWR sky130_fd_sc_hd__decap_4
XFILLER_79_74 VGND VGND VPWR VPWR sky130_fd_sc_hd__fill_1
XFILLER_95_248 VGND VGND VPWR VPWR sky130_fd_sc_hd__decap_3
XFILLER_110_559 VGND VGND VPWR VPWR sky130_fd_sc_hd__fill_2
XFILLER_95_73 VGND VGND VPWR VPWR sky130_fd_sc_hd__decap_6
XFILLER_76_451 VGND VGND VPWR VPWR sky130_fd_sc_hd__decap_6
XFILLER_48_131 VGND VGND VPWR VPWR sky130_fd_sc_hd__fill_1
XFILLER_48_153 VGND VGND VPWR VPWR sky130_fd_sc_hd__decap_4
XFILLER_64_613 VPWR VGND VPWR VGND sky130_ef_sc_hd__decap_12
XTAP_TAPCELL_ROW_47_822 VGND VPWR sky130_fd_sc_hd__tapvpwrvgnd_1
XFILLER_64_657 VPWR VGND VPWR VGND sky130_ef_sc_hd__decap_12
XFILLER_17_540 VGND VGND VPWR VPWR sky130_fd_sc_hd__fill_1
XFILLER_48_197 VGND VGND VPWR VPWR sky130_fd_sc_hd__decap_8
XFILLER_51_318 VGND VGND VPWR VPWR sky130_fd_sc_hd__fill_1
XFILLER_91_498 VGND VGND VPWR VPWR sky130_fd_sc_hd__decap_3
XTAP_TAPCELL_ROW_63_1013 VGND VPWR sky130_fd_sc_hd__tapvpwrvgnd_1
XFILLER_44_392 VPWR VGND VPWR VGND sky130_ef_sc_hd__decap_12
X_6570_ _2060_ _2061_ _2059_ VGND VGND VPWR VPWR _2088_ sky130_fd_sc_hd__a21o_1
XFILLER_32_587 VGND VGND VPWR VPWR sky130_fd_sc_hd__fill_1
X_5521_ _1089_ net253 VGND VGND VPWR VPWR _1221_ sky130_fd_sc_hd__nand2_1
XFILLER_117_125 VPWR VGND VPWR VGND sky130_ef_sc_hd__decap_12
X_8240_ net463 _4238_ _3626_ VGND VGND VPWR VPWR _3628_ sky130_fd_sc_hd__or3_1
XFILLER_117_147 VPWR VGND VPWR VGND sky130_ef_sc_hd__decap_12
X_5452_ _1147_ _1173_ _1176_ VGND VGND VPWR VPWR _1180_ sky130_fd_sc_hd__a21o_1
X_8171_ net187 _3558_ _3560_ VGND VGND VPWR VPWR _3561_ sky130_fd_sc_hd__or3b_4
X_5383_ _1074_ _1077_ _1112_ VGND VGND VPWR VPWR _1114_ sky130_fd_sc_hd__nor3_1
XTAP_TAPCELL_ROW_74_1142 VGND VPWR sky130_fd_sc_hd__tapvpwrvgnd_1
X_7122_ pe_array\[1\].u_pe.accum_reg\[12\] net446 net339 VGND VGND VPWR VPWR _2587_
+ sky130_fd_sc_hd__and3_1
Xfanout217 _3209_ VGND VGND VPWR VPWR net217 sky130_fd_sc_hd__buf_2
Xfanout228 _2209_ VGND VGND VPWR VPWR net228 sky130_fd_sc_hd__clkbuf_2
Xfanout206 net207 VGND VGND VPWR VPWR net206 sky130_fd_sc_hd__buf_8
X_7053_ _2451_ _2453_ _2518_ _2519_ VGND VGND VPWR VPWR _2520_ sky130_fd_sc_hd__a211oi_4
XFILLER_115_39 VPWR VGND VPWR VGND sky130_ef_sc_hd__decap_12
XFILLER_101_548 VPWR VGND VPWR VGND sky130_ef_sc_hd__decap_12
Xfanout239 net241 VGND VGND VPWR VPWR net239 sky130_fd_sc_hd__clkbuf_2
X_6004_ _1520_ _1536_ _1538_ VGND VGND VPWR VPWR _1539_ sky130_fd_sc_hd__and3_1
XFILLER_67_462 VGND VGND VPWR VPWR sky130_fd_sc_hd__decap_4
XFILLER_94_281 VGND VGND VPWR VPWR sky130_fd_sc_hd__fill_2
XFILLER_82_421 VPWR VGND VPWR VGND sky130_ef_sc_hd__decap_12
XFILLER_27_348 VGND VGND VPWR VPWR sky130_fd_sc_hd__fill_2
X_7955_ _3348_ _3349_ VGND VGND VPWR VPWR _3350_ sky130_fd_sc_hd__nor2_1
X_7886_ _3254_ _3282_ VGND VGND VPWR VPWR _3283_ sky130_fd_sc_hd__xnor2_2
XTAP_TAPCELL_ROW_85_1271 VGND VPWR sky130_fd_sc_hd__tapvpwrvgnd_1
X_6906_ _2329_ _2336_ _2335_ VGND VGND VPWR VPWR _2376_ sky130_fd_sc_hd__a21bo_1
XTAP_TAPCELL_ROW_25_549 VGND VPWR sky130_fd_sc_hd__tapvpwrvgnd_1
X_6837_ _2305_ _2306_ _2308_ VGND VGND VPWR VPWR _2309_ sky130_fd_sc_hd__or3_1
XFILLER_50_351 VPWR VGND VPWR VGND sky130_ef_sc_hd__decap_12
XFILLER_24_36 VGND VGND VPWR VPWR sky130_fd_sc_hd__decap_4
XFILLER_23_576 VGND VGND VPWR VPWR sky130_fd_sc_hd__fill_2
XFILLER_109_615 VGND VGND VPWR VPWR sky130_fd_sc_hd__fill_1
X_8507_ net402 pe_array\[2\].u_pe.accum_reg\[20\] net218 _3887_ VGND VGND VPWR VPWR
+ _3888_ sky130_fd_sc_hd__o2bb2a_4
X_6768_ _2238_ _2239_ net495 net336 VGND VGND VPWR VPWR _2242_ sky130_fd_sc_hd__a2bb2o_1
XFILLER_10_226 VGND VGND VPWR VPWR sky130_fd_sc_hd__fill_2
XFILLER_108_103 VPWR VGND VPWR VGND sky130_ef_sc_hd__decap_12
X_5719_ net514 net353 _1260_ VGND VGND VPWR VPWR _1262_ sky130_fd_sc_hd__a21o_1
X_6699_ net244 _1594_ net236 net896 VGND VGND VPWR VPWR _0269_ sky130_fd_sc_hd__a2bb2o_1
XFILLER_6_219 VGND VGND VPWR VPWR sky130_fd_sc_hd__decap_3
X_8438_ _3789_ _3790_ _3819_ _3820_ VGND VGND VPWR VPWR _3821_ sky130_fd_sc_hd__nor4_2
X_8369_ _3753_ VGND VGND VPWR VPWR _3754_ sky130_fd_sc_hd__inv_2
XFILLER_2_469 VGND VGND VPWR VPWR sky130_fd_sc_hd__decap_6
XFILLER_49_55 VGND VGND VPWR VPWR sky130_fd_sc_hd__fill_1
XFILLER_18_304 VGND VGND VPWR VPWR sky130_fd_sc_hd__decap_4
XFILLER_85_281 VGND VGND VPWR VPWR sky130_fd_sc_hd__fill_1
XFILLER_73_465 VGND VGND VPWR VPWR sky130_fd_sc_hd__decap_4
XFILLER_45_178 VGND VGND VPWR VPWR sky130_fd_sc_hd__fill_2
XTAP_TAPCELL_ROW_52_880 VGND VPWR sky130_fd_sc_hd__tapvpwrvgnd_1
XFILLER_14_587 VGND VGND VPWR VPWR sky130_fd_sc_hd__fill_1
XFILLER_115_629 VPWR VGND VPWR VGND sky130_ef_sc_hd__decap_12
XFILLER_5_241 VGND VGND VPWR VPWR sky130_fd_sc_hd__fill_1
XFILLER_108_692 VGND VGND VPWR VPWR sky130_fd_sc_hd__decap_8
XFILLER_110_301 VGND VGND VPWR VPWR sky130_fd_sc_hd__decap_6
XFILLER_110_345 VPWR VGND VPWR VGND sky130_ef_sc_hd__decap_12
XFILLER_68_259 VGND VGND VPWR VPWR sky130_fd_sc_hd__decap_8
XFILLER_83_229 VPWR VGND VPWR VGND sky130_ef_sc_hd__decap_12
Xinput6 pixel_in[5] VGND VGND VPWR VPWR net6 sky130_fd_sc_hd__buf_6
XTAP_TAPCELL_ROW_108_1547 VGND VPWR sky130_fd_sc_hd__tapvpwrvgnd_1
XFILLER_64_421 VPWR VGND VPWR VGND sky130_ef_sc_hd__decap_12
XFILLER_91_251 VGND VGND VPWR VPWR sky130_fd_sc_hd__fill_2
XFILLER_64_454 VGND VGND VPWR VPWR sky130_fd_sc_hd__decap_6
X_7740_ net1021 net226 _3179_ net378 VGND VGND VPWR VPWR _0331_ sky130_fd_sc_hd__o211a_1
X_4952_ net204 _0694_ _0696_ VGND VGND VPWR VPWR _0697_ sky130_fd_sc_hd__or3b_4
XFILLER_32_340 VGND VGND VPWR VPWR sky130_fd_sc_hd__fill_1
X_4883_ _0626_ _0628_ _0562_ _0564_ VGND VGND VPWR VPWR _0630_ sky130_fd_sc_hd__o211ai_1
X_7671_ net167 _3118_ VGND VGND VPWR VPWR _3119_ sky130_fd_sc_hd__nor2_1
X_6622_ net201 _2136_ VGND VGND VPWR VPWR _2138_ sky130_fd_sc_hd__nor2_1
XTAP_TAPCELL_ROW_22_519 VGND VPWR sky130_fd_sc_hd__tapvpwrvgnd_1
XFILLER_32_384 VPWR VGND VPWR VGND sky130_ef_sc_hd__decap_12
X_6553_ _2068_ _2069_ VGND VGND VPWR VPWR _2071_ sky130_fd_sc_hd__xnor2_1
X_6484_ _2002_ _2003_ VGND VGND VPWR VPWR _2005_ sky130_fd_sc_hd__and2b_1
X_9272_ clknet_leaf_4_clk _0384_ VGND VGND VPWR VPWR pe_array\[2\].u_pe.accum_reg\[14\]
+ sky130_fd_sc_hd__dfxtp_1
X_5504_ net947 net247 _1212_ net364 VGND VGND VPWR VPWR _0062_ sky130_fd_sc_hd__o211a_1
X_8223_ _3608_ _3610_ _3544_ _3547_ VGND VGND VPWR VPWR _3612_ sky130_fd_sc_hd__o211ai_1
XFILLER_10_27 VGND VGND VPWR VPWR sky130_fd_sc_hd__fill_1
X_5435_ _1133_ _1135_ _1163_ VGND VGND VPWR VPWR _1164_ sky130_fd_sc_hd__or3_1
X_8154_ _3543_ _3538_ VGND VGND VPWR VPWR _3544_ sky130_fd_sc_hd__nand2b_1
X_5366_ pe_array\[3\].u_pe.accum_reg\[28\] net301 net629 VGND VGND VPWR VPWR _1097_
+ sky130_fd_sc_hd__and3_1
X_8085_ _3461_ _3475_ _3476_ VGND VGND VPWR VPWR _3477_ sky130_fd_sc_hd__nand3_2
X_5297_ _1030_ _1029_ VGND VGND VPWR VPWR _1031_ sky130_fd_sc_hd__and2b_1
X_7105_ _2528_ _2526_ _2524_ VGND VGND VPWR VPWR _2571_ sky130_fd_sc_hd__o21ba_4
X_7036_ pe_array\[1\].u_pe.accum_reg\[10\] net449 net341 VGND VGND VPWR VPWR _2503_
+ sky130_fd_sc_hd__and3_4
XTAP_TAPCELL_ROW_87_1300 VGND VPWR sky130_fd_sc_hd__tapvpwrvgnd_1
XFILLER_28_613 VPWR VGND VPWR VGND sky130_ef_sc_hd__decap_12
XFILLER_67_281 VPWR VGND VPWR VGND sky130_ef_sc_hd__decap_12
X_8987_ clknet_leaf_30_clk _0099_ VGND VGND VPWR VPWR net54 sky130_fd_sc_hd__dfxtp_1
XFILLER_55_454 VPWR VGND VPWR VGND sky130_ef_sc_hd__decap_12
XTAP_TAPCELL_ROW_2_277 VGND VPWR sky130_fd_sc_hd__tapvpwrvgnd_1
XFILLER_27_156 VGND VGND VPWR VPWR sky130_fd_sc_hd__decap_4
X_7938_ net497 pe_array\[2\].u_pe.weight_in\[4\] VGND VGND VPWR VPWR _3333_ sky130_fd_sc_hd__nand2_1
XFILLER_15_329 VGND VGND VPWR VPWR sky130_fd_sc_hd__decap_6
XFILLER_35_46 VGND VGND VPWR VPWR sky130_fd_sc_hd__decap_3
X_7869_ net504 pe_array\[2\].u_pe.accum_reg\[4\] net318 VGND VGND VPWR VPWR _3266_
+ sky130_fd_sc_hd__and3_1
XFILLER_51_671 VGND VGND VPWR VPWR sky130_fd_sc_hd__fill_1
XFILLER_11_546 VPWR VGND VPWR VGND sky130_ef_sc_hd__decap_12
XPHY_EDGE_ROW_14_Right_14 VGND VGND VPWR VPWR sky130_fd_sc_hd__decap_3
Xclkbuf_3_3__f_clk clknet_0_clk VGND VGND VPWR VPWR clknet_3_3__leaf_clk sky130_fd_sc_hd__clkbuf_16
XFILLER_2_222 VGND VGND VPWR VPWR sky130_fd_sc_hd__fill_1
XFILLER_111_109 VGND VGND VPWR VPWR sky130_fd_sc_hd__decap_3
XFILLER_105_673 VGND VGND VPWR VPWR sky130_fd_sc_hd__fill_1
XFILLER_2_244 VGND VGND VPWR VPWR sky130_fd_sc_hd__decap_8
XFILLER_2_266 VGND VGND VPWR VPWR sky130_fd_sc_hd__fill_2
XPHY_EDGE_ROW_23_Right_23 VGND VGND VPWR VPWR sky130_fd_sc_hd__decap_3
XFILLER_93_505 VPWR VGND VPWR VGND sky130_ef_sc_hd__decap_12
XFILLER_46_421 VGND VGND VPWR VPWR sky130_fd_sc_hd__decap_8
XFILLER_46_465 VGND VGND VPWR VPWR sky130_fd_sc_hd__fill_1
XPHY_EDGE_ROW_32_Right_32 VGND VGND VPWR VPWR sky130_fd_sc_hd__decap_3
XFILLER_14_362 VGND VGND VPWR VPWR sky130_fd_sc_hd__fill_2
XFILLER_42_682 VGND VGND VPWR VPWR sky130_fd_sc_hd__fill_2
XTAP_TAPCELL_ROW_103_1488 VGND VPWR sky130_fd_sc_hd__tapvpwrvgnd_1
XFILLER_41_181 VGND VGND VPWR VPWR sky130_fd_sc_hd__fill_2
X_5220_ net285 _0954_ _0955_ VGND VGND VPWR VPWR _0956_ sky130_fd_sc_hd__nor3_1
XTAP_TAPCELL_ROW_71_1101 VGND VPWR sky130_fd_sc_hd__tapvpwrvgnd_1
XPHY_EDGE_ROW_41_Right_41 VGND VGND VPWR VPWR sky130_fd_sc_hd__decap_3
XFILLER_44_3 VPWR VGND VPWR VGND sky130_ef_sc_hd__decap_12
X_5151_ _0889_ _0888_ VGND VGND VPWR VPWR _0890_ sky130_fd_sc_hd__and2b_2
XFILLER_111_665 VGND VGND VPWR VPWR sky130_fd_sc_hd__decap_6
XFILLER_110_131 VGND VGND VPWR VPWR sky130_fd_sc_hd__decap_4
XFILLER_110_120 VGND VGND VPWR VPWR sky130_fd_sc_hd__fill_1
X_5082_ net204 _0820_ _0822_ VGND VGND VPWR VPWR _0823_ sky130_fd_sc_hd__or3b_1
XFILLER_96_387 VGND VGND VPWR VPWR sky130_fd_sc_hd__fill_2
XFILLER_84_527 VGND VGND VPWR VPWR sky130_fd_sc_hd__decap_4
X_8910_ clknet_leaf_62_clk _0022_ VGND VGND VPWR VPWR pe_array\[3\].u_pe.accum_reg\[10\]
+ sky130_fd_sc_hd__dfxtp_1
XFILLER_110_197 VPWR VGND VPWR VGND sky130_ef_sc_hd__decap_12
XFILLER_2_83 VGND VGND VPWR VPWR sky130_fd_sc_hd__fill_1
XFILLER_37_410 VGND VGND VPWR VPWR sky130_fd_sc_hd__fill_1
XFILLER_112_29 VPWR VGND VPWR VGND sky130_ef_sc_hd__decap_12
X_8841_ net1033 net216 _4201_ net389 VGND VGND VPWR VPWR _0410_ sky130_fd_sc_hd__o211a_1
XTAP_TAPCELL_ROW_55_909 VGND VPWR sky130_fd_sc_hd__tapvpwrvgnd_1
X_8772_ _4142_ _4143_ VGND VGND VPWR VPWR _4144_ sky130_fd_sc_hd__nor2_1
XTAP_TAPCELL_ROW_69_1085 VGND VPWR sky130_fd_sc_hd__tapvpwrvgnd_1
XPHY_EDGE_ROW_50_Right_50 VGND VGND VPWR VPWR sky130_fd_sc_hd__decap_3
XTAP_TAPCELL_ROW_82_1241 VGND VPWR sky130_fd_sc_hd__tapvpwrvgnd_1
X_5984_ _1510_ _1518_ VGND VGND VPWR VPWR _1519_ sky130_fd_sc_hd__nand2b_1
X_7723_ _3167_ _3168_ VGND VGND VPWR VPWR _3169_ sky130_fd_sc_hd__xnor2_1
X_4935_ net414 _0680_ VGND VGND VPWR VPWR _0025_ sky130_fd_sc_hd__nor2_1
XTAP_TAPCELL_ROW_35_677 VGND VPWR sky130_fd_sc_hd__tapvpwrvgnd_1
XANTENNA_11 net375 VGND VGND VPWR VPWR sky130_fd_sc_hd__diode_2
X_4866_ net286 _0610_ _0611_ VGND VGND VPWR VPWR _0613_ sky130_fd_sc_hd__or3_4
X_7654_ _3072_ _3075_ _3101_ VGND VGND VPWR VPWR _3103_ sky130_fd_sc_hd__and3_1
X_6605_ _2084_ _2121_ VGND VGND VPWR VPWR _2122_ sky130_fd_sc_hd__nand2_1
XFILLER_20_365 VGND VGND VPWR VPWR sky130_fd_sc_hd__fill_1
X_7585_ _3033_ _3034_ VGND VGND VPWR VPWR _3036_ sky130_fd_sc_hd__xnor2_1
X_4797_ _0543_ _0544_ _0502_ VGND VGND VPWR VPWR _0546_ sky130_fd_sc_hd__a21oi_2
X_6536_ net157 _2054_ VGND VGND VPWR VPWR _2055_ sky130_fd_sc_hd__xnor2_1
XFILLER_21_15 VGND VGND VPWR VPWR sky130_fd_sc_hd__fill_1
X_6467_ net707 _1986_ _1987_ VGND VGND VPWR VPWR _1988_ sky130_fd_sc_hd__nor3_1
X_9255_ clknet_leaf_20_clk _0367_ VGND VGND VPWR VPWR pe_array\[2\].u_pe.tap_count\[1\]
+ sky130_fd_sc_hd__dfxtp_1
Xoutput140 net140 VGND VGND VPWR VPWR result_data[91] sky130_fd_sc_hd__buf_2
X_6398_ net431 _1921_ VGND VGND VPWR VPWR _0247_ sky130_fd_sc_hd__nor2_1
XTAP_TAPCELL_ROW_93_1370 VGND VPWR sky130_fd_sc_hd__tapvpwrvgnd_1
X_8206_ _3592_ net259 _3593_ VGND VGND VPWR VPWR _3595_ sky130_fd_sc_hd__or3_4
X_9186_ clknet_leaf_37_clk _0298_ VGND VGND VPWR VPWR pe_array\[1\].u_pe.accum_reg\[4\]
+ sky130_fd_sc_hd__dfxtp_1
X_5418_ _1145_ _1146_ VGND VGND VPWR VPWR _1148_ sky130_fd_sc_hd__and2b_1
X_8137_ _3480_ _3482_ _3526_ _3527_ VGND VGND VPWR VPWR _3528_ sky130_fd_sc_hd__o211a_4
XTAP_TAPCELL_ROW_7_336 VGND VPWR sky130_fd_sc_hd__tapvpwrvgnd_1
X_5349_ _1078_ _1079_ VGND VGND VPWR VPWR _1081_ sky130_fd_sc_hd__xnor2_1
XFILLER_102_676 VGND VGND VPWR VPWR sky130_fd_sc_hd__decap_8
XFILLER_87_376 VGND VGND VPWR VPWR sky130_fd_sc_hd__decap_4
XFILLER_75_505 VPWR VGND VPWR VGND sky130_ef_sc_hd__decap_12
X_8068_ _3459_ _3458_ VGND VGND VPWR VPWR _3460_ sky130_fd_sc_hd__and2b_1
X_7019_ net424 _2486_ VGND VGND VPWR VPWR _0303_ sky130_fd_sc_hd__nor2_1
XFILLER_47_229 VGND VGND VPWR VPWR sky130_fd_sc_hd__fill_1
XFILLER_90_508 VGND VGND VPWR VPWR sky130_fd_sc_hd__fill_2
XFILLER_16_616 VGND VGND VPWR VPWR sky130_fd_sc_hd__fill_2
XFILLER_83_593 VGND VGND VPWR VPWR sky130_fd_sc_hd__fill_1
XFILLER_43_413 VPWR VGND VPWR VGND sky130_ef_sc_hd__decap_12
XFILLER_43_435 VGND VGND VPWR VPWR sky130_fd_sc_hd__fill_2
XFILLER_46_89 VGND VGND VPWR VPWR sky130_fd_sc_hd__fill_1
XFILLER_15_137 VGND VGND VPWR VPWR sky130_fd_sc_hd__decap_8
XFILLER_70_287 VGND VGND VPWR VPWR sky130_fd_sc_hd__decap_8
XFILLER_11_332 VGND VGND VPWR VPWR sky130_fd_sc_hd__decap_4
Xclkbuf_leaf_50_clk clknet_3_2__leaf_clk VGND VGND VPWR VPWR clknet_leaf_50_clk sky130_fd_sc_hd__clkbuf_8
XFILLER_23_192 VGND VGND VPWR VPWR sky130_fd_sc_hd__decap_4
XFILLER_7_325 VGND VGND VPWR VPWR sky130_fd_sc_hd__decap_8
XFILLER_7_39 VPWR VGND VPWR VGND sky130_ef_sc_hd__decap_12
XFILLER_87_52 VGND VGND VPWR VPWR sky130_fd_sc_hd__decap_4
XFILLER_3_597 VPWR VGND VPWR VGND sky130_ef_sc_hd__decap_12
XFILLER_87_96 VGND VGND VPWR VPWR sky130_fd_sc_hd__decap_4
XFILLER_78_365 VGND VGND VPWR VPWR sky130_fd_sc_hd__decap_8
XFILLER_66_527 VGND VGND VPWR VPWR sky130_fd_sc_hd__fill_2
Xclone168 net260 VGND VGND VPWR VPWR net683 sky130_fd_sc_hd__clkbuf_1
XFILLER_19_465 VGND VGND VPWR VPWR sky130_fd_sc_hd__decap_4
XTAP_TAPCELL_ROW_105_1517 VGND VPWR sky130_fd_sc_hd__tapvpwrvgnd_1
XFILLER_19_487 VPWR VGND VPWR VGND sky130_ef_sc_hd__decap_12
XFILLER_34_435 VGND VGND VPWR VPWR sky130_fd_sc_hd__decap_4
XFILLER_14_181 VPWR VGND VPWR VGND sky130_ef_sc_hd__decap_12
XTAP_TAPCELL_ROW_32_636 VGND VPWR sky130_fd_sc_hd__tapvpwrvgnd_1
Xclkbuf_leaf_41_clk clknet_3_3__leaf_clk VGND VGND VPWR VPWR clknet_leaf_41_clk sky130_fd_sc_hd__clkbuf_8
X_4720_ net476 net293 _0437_ _0436_ VGND VGND VPWR VPWR _0470_ sky130_fd_sc_hd__a31o_1
XTAP_TAPCELL_ROW_60_978 VGND VPWR sky130_fd_sc_hd__tapvpwrvgnd_1
X_4651_ _4373_ _4366_ _4372_ VGND VGND VPWR VPWR _4413_ sky130_fd_sc_hd__a21bo_1
Xinput20 weight_din[7] VGND VGND VPWR VPWR net20 sky130_fd_sc_hd__buf_2
XTAP_TAPCELL_ROW_12_393 VGND VPWR sky130_fd_sc_hd__tapvpwrvgnd_1
X_7370_ _2793_ _2795_ _2826_ _2827_ VGND VGND VPWR VPWR _2828_ sky130_fd_sc_hd__o211ai_2
X_4582_ _4326_ _4344_ VGND VGND VPWR VPWR _4346_ sky130_fd_sc_hd__or2_1
XTAP_TAPCELL_ROW_116_1646 VGND VPWR sky130_fd_sc_hd__tapvpwrvgnd_1
X_6321_ _1843_ _1844_ net706 VGND VGND VPWR VPWR _1847_ sky130_fd_sc_hd__o21ai_1
X_9040_ clknet_leaf_11_clk _0152_ VGND VGND VPWR VPWR net112 sky130_fd_sc_hd__dfxtp_1
X_6252_ net431 _1780_ VGND VGND VPWR VPWR _0242_ sky130_fd_sc_hd__nor2_1
XFILLER_88_118 VGND VGND VPWR VPWR sky130_fd_sc_hd__decap_6
X_6183_ _1711_ _1713_ VGND VGND VPWR VPWR _1714_ sky130_fd_sc_hd__xnor2_1
X_5203_ _0939_ _0938_ VGND VGND VPWR VPWR _0940_ sky130_fd_sc_hd__and2b_1
XTAP_TAPCELL_ROW_4_306 VGND VPWR sky130_fd_sc_hd__tapvpwrvgnd_1
X_5134_ pe_array\[3\].u_pe.accum_reg\[20\] net295 net433 VGND VGND VPWR VPWR _0873_
+ sky130_fd_sc_hd__and3_1
XFILLER_111_473 VGND VGND VPWR VPWR sky130_fd_sc_hd__fill_2
XFILLER_97_685 VPWR VGND VPWR VGND sky130_ef_sc_hd__decap_12
XFILLER_69_354 VGND VGND VPWR VPWR sky130_fd_sc_hd__fill_1
XFILLER_57_505 VGND VGND VPWR VPWR sky130_fd_sc_hd__decap_3
XFILLER_96_195 VGND VGND VPWR VPWR sky130_fd_sc_hd__fill_1
X_5065_ _0804_ _0805_ _0806_ VGND VGND VPWR VPWR _0807_ sky130_fd_sc_hd__nand3_2
X_8824_ net214 _3219_ VGND VGND VPWR VPWR _4193_ sky130_fd_sc_hd__nand2_1
XFILLER_16_15 VPWR VGND VPWR VGND sky130_ef_sc_hd__decap_12
XFILLER_13_608 VGND VGND VPWR VPWR sky130_fd_sc_hd__fill_1
X_8755_ pe_array\[2\].u_pe.accum_reg\[29\] net444 net319 VGND VGND VPWR VPWR _4127_
+ sky130_fd_sc_hd__and3_1
XFILLER_80_574 VGND VGND VPWR VPWR sky130_fd_sc_hd__decap_6
X_5967_ _1501_ net613 VGND VGND VPWR VPWR _1503_ sky130_fd_sc_hd__nand2_1
X_8686_ _4059_ _4060_ VGND VGND VPWR VPWR _4061_ sky130_fd_sc_hd__or2_4
XFILLER_80_596 VPWR VGND VPWR VGND sky130_ef_sc_hd__decap_12
Xclkbuf_leaf_32_clk clknet_3_6__leaf_clk VGND VGND VPWR VPWR clknet_leaf_32_clk sky130_fd_sc_hd__clkbuf_8
XFILLER_52_298 VGND VGND VPWR VPWR sky130_fd_sc_hd__fill_1
X_7706_ _3151_ _3152_ VGND VGND VPWR VPWR _3153_ sky130_fd_sc_hd__nor2_1
X_4918_ _0661_ _0662_ _0663_ VGND VGND VPWR VPWR _0664_ sky130_fd_sc_hd__nand3_1
X_5898_ _1433_ _1434_ VGND VGND VPWR VPWR _1435_ sky130_fd_sc_hd__nor2_1
X_7637_ _3049_ _3051_ _3085_ VGND VGND VPWR VPWR _3086_ sky130_fd_sc_hd__o21a_1
X_4849_ net414 _0596_ VGND VGND VPWR VPWR _0023_ sky130_fd_sc_hd__nor2_1
X_7568_ pe_array\[1\].u_pe.accum_reg\[26\] _2367_ VGND VGND VPWR VPWR _3019_ sky130_fd_sc_hd__nor2_1
X_6519_ net410 pe_array\[0\].u_pe.accum_reg\[25\] net239 _2038_ VGND VGND VPWR VPWR
+ _2039_ sky130_fd_sc_hd__o2bb2a_1
X_9307_ clknet_leaf_4_clk _0419_ VGND VGND VPWR VPWR pe_accum\[2\]\[17\] sky130_fd_sc_hd__dfxtp_1
X_7499_ _2950_ _2951_ VGND VGND VPWR VPWR _2953_ sky130_fd_sc_hd__xnor2_1
XFILLER_106_245 VGND VGND VPWR VPWR sky130_fd_sc_hd__decap_6
X_9238_ clknet_leaf_45_clk _0350_ VGND VGND VPWR VPWR pe_accum\[1\]\[24\] sky130_fd_sc_hd__dfxtp_1
XFILLER_0_501 VGND VGND VPWR VPWR sky130_fd_sc_hd__decap_3
X_9169_ clknet_leaf_26_clk _0281_ VGND VGND VPWR VPWR pe_accum\[0\]\[23\] sky130_fd_sc_hd__dfxtp_1
XFILLER_102_451 VGND VGND VPWR VPWR sky130_fd_sc_hd__fill_2
XFILLER_0_589 VPWR VGND VPWR VGND sky130_ef_sc_hd__decap_12
XFILLER_57_55 VGND VGND VPWR VPWR sky130_fd_sc_hd__fill_1
XFILLER_16_413 VGND VGND VPWR VPWR sky130_fd_sc_hd__decap_6
Xclkbuf_leaf_23_clk clknet_3_7__leaf_clk VGND VGND VPWR VPWR clknet_leaf_23_clk sky130_fd_sc_hd__clkbuf_8
XFILLER_31_449 VGND VGND VPWR VPWR sky130_fd_sc_hd__fill_1
XTAP_TAPCELL_ROW_100_1458 VGND VPWR sky130_fd_sc_hd__tapvpwrvgnd_1
XFILLER_8_645 VPWR VGND VPWR VGND sky130_ef_sc_hd__decap_12
XFILLER_7_166 VGND VGND VPWR VPWR sky130_fd_sc_hd__fill_2
XFILLER_7_177 VGND VGND VPWR VPWR sky130_fd_sc_hd__decap_6
XFILLER_98_95 VGND VGND VPWR VPWR sky130_fd_sc_hd__fill_1
XFILLER_79_641 VPWR VGND VPWR VGND sky130_ef_sc_hd__decap_12
XFILLER_3_383 VGND VGND VPWR VPWR sky130_fd_sc_hd__decap_8
XTAP_TAPCELL_ROW_111_1587 VGND VPWR sky130_fd_sc_hd__tapvpwrvgnd_1
XFILLER_94_611 VGND VGND VPWR VPWR sky130_fd_sc_hd__fill_1
XFILLER_78_151 VGND VGND VPWR VPWR sky130_fd_sc_hd__decap_3
XFILLER_47_582 VGND VGND VPWR VPWR sky130_fd_sc_hd__fill_1
XTAP_TAPCELL_ROW_66_1044 VGND VPWR sky130_fd_sc_hd__tapvpwrvgnd_1
X_6870_ _2337_ _2338_ _2339_ VGND VGND VPWR VPWR _2341_ sky130_fd_sc_hd__a21o_1
X_5821_ _1357_ _1358_ _1359_ VGND VGND VPWR VPWR _1360_ sky130_fd_sc_hd__nor3_1
XTAP_TAPCELL_ROW_17_452 VGND VPWR sky130_fd_sc_hd__tapvpwrvgnd_1
XTAP_TAPCELL_ROW_17_463 VGND VPWR sky130_fd_sc_hd__tapvpwrvgnd_1
XFILLER_22_405 VGND VGND VPWR VPWR sky130_fd_sc_hd__fill_1
X_8540_ pe_array\[2\].u_pe.accum_reg\[22\] net442 net315 VGND VGND VPWR VPWR _3919_
+ sky130_fd_sc_hd__and3_4
X_5752_ net480 net356 pe_array\[0\].u_pe.accum_reg\[4\] VGND VGND VPWR VPWR _1293_
+ sky130_fd_sc_hd__a21oi_1
XTAP_TAPCELL_ROW_45_794 VGND VPWR sky130_fd_sc_hd__tapvpwrvgnd_1
Xclkbuf_leaf_14_clk clknet_3_4__leaf_clk VGND VGND VPWR VPWR clknet_leaf_14_clk sky130_fd_sc_hd__clkbuf_8
X_4703_ _0435_ _0453_ _0451_ VGND VGND VPWR VPWR _0454_ sky130_fd_sc_hd__and3_4
X_5683_ net508 _1228_ VGND VGND VPWR VPWR _1232_ sky130_fd_sc_hd__nand2_1
X_8471_ _3851_ _3852_ VGND VGND VPWR VPWR _3853_ sky130_fd_sc_hd__xor2_2
X_7422_ net407 pe_array\[1\].u_pe.accum_reg\[20\] net230 _2878_ VGND VGND VPWR VPWR
+ _2879_ sky130_fd_sc_hd__o2bb2a_4
X_4634_ _4391_ _4395_ VGND VGND VPWR VPWR _4396_ sky130_fd_sc_hd__and2_1
X_7353_ _2809_ _2810_ net168 VGND VGND VPWR VPWR _2812_ sky130_fd_sc_hd__a21o_1
X_4565_ net304 net479 net472 net307 VGND VGND VPWR VPWR _4329_ sky130_fd_sc_hd__a22oi_1
X_6304_ net171 _1798_ _1797_ VGND VGND VPWR VPWR _1831_ sky130_fd_sc_hd__a21bo_1
XFILLER_89_405 VGND VGND VPWR VPWR sky130_fd_sc_hd__fill_1
XTAP_TAPCELL_ROW_77_1173 VGND VPWR sky130_fd_sc_hd__tapvpwrvgnd_1
XPHY_EDGE_ROW_4_Right_4 VGND VGND VPWR VPWR sky130_fd_sc_hd__decap_3
X_7284_ _2742_ _2743_ net165 VGND VGND VPWR VPWR _2745_ sky130_fd_sc_hd__o21ai_1
X_9023_ clknet_leaf_45_clk _0135_ VGND VGND VPWR VPWR net93 sky130_fd_sc_hd__dfxtp_1
X_4496_ net509 net302 pe_array\[3\].u_pe.accum_reg\[2\] VGND VGND VPWR VPWR _4263_
+ sky130_fd_sc_hd__a21oi_1
XFILLER_103_237 VGND VGND VPWR VPWR sky130_fd_sc_hd__decap_4
XFILLER_89_449 VGND VGND VPWR VPWR sky130_fd_sc_hd__fill_2
X_6235_ _1760_ _1761_ _1762_ VGND VGND VPWR VPWR _1764_ sky130_fd_sc_hd__a21oi_1
X_6166_ _1694_ _1695_ _1696_ VGND VGND VPWR VPWR _1697_ sky130_fd_sc_hd__nand3_1
XFILLER_57_302 VPWR VGND VPWR VGND sky130_ef_sc_hd__decap_12
X_6097_ _1626_ _1628_ _1563_ _1565_ VGND VGND VPWR VPWR _1630_ sky130_fd_sc_hd__o211ai_1
X_5117_ net183 _0855_ _0856_ VGND VGND VPWR VPWR _0857_ sky130_fd_sc_hd__or3_4
X_5048_ _0786_ _0787_ net283 VGND VGND VPWR VPWR _0790_ sky130_fd_sc_hd__o21ai_1
XFILLER_85_699 VGND VGND VPWR VPWR sky130_fd_sc_hd__fill_1
XFILLER_25_221 VGND VGND VPWR VPWR sky130_fd_sc_hd__decap_3
X_8807_ net403 pe_array\[2\].u_pe.accum_reg\[30\] net220 _4177_ VGND VGND VPWR VPWR
+ _4178_ sky130_fd_sc_hd__o2bb2a_4
XFILLER_13_405 VPWR VGND VPWR VGND sky130_ef_sc_hd__decap_12
X_8738_ net176 _4109_ VGND VGND VPWR VPWR _4111_ sky130_fd_sc_hd__xnor2_1
XFILLER_13_449 VPWR VGND VPWR VGND sky130_ef_sc_hd__decap_12
X_6999_ _2459_ _2465_ _2466_ VGND VGND VPWR VPWR _2467_ sky130_fd_sc_hd__nand3_1
XFILLER_43_57 VPWR VGND VPWR VGND sky130_ef_sc_hd__decap_12
X_8669_ net192 _4043_ VGND VGND VPWR VPWR _4044_ sky130_fd_sc_hd__and2_1
XFILLER_111_3 VPWR VGND VPWR VGND sky130_ef_sc_hd__decap_12
XFILLER_107_521 VGND VGND VPWR VPWR sky130_fd_sc_hd__fill_1
XFILLER_4_136 VGND VGND VPWR VPWR sky130_fd_sc_hd__decap_4
XFILLER_4_29 VPWR VGND VPWR VGND sky130_ef_sc_hd__decap_12
XFILLER_108_83 VGND VGND VPWR VPWR sky130_fd_sc_hd__fill_1
XFILLER_102_281 VGND VGND VPWR VPWR sky130_fd_sc_hd__fill_1
XFILLER_88_482 VGND VGND VPWR VPWR sky130_fd_sc_hd__fill_1
XFILLER_91_603 VPWR VGND VPWR VGND sky130_ef_sc_hd__decap_12
XFILLER_76_699 VGND VGND VPWR VPWR sky130_fd_sc_hd__fill_1
XFILLER_63_316 VPWR VGND VPWR VGND sky130_ef_sc_hd__decap_12
XFILLER_91_647 VGND VGND VPWR VPWR sky130_fd_sc_hd__fill_2
XFILLER_84_97 VGND VGND VPWR VPWR sky130_fd_sc_hd__decap_4
XFILLER_84_75 VGND VGND VPWR VPWR sky130_fd_sc_hd__decap_8
XFILLER_29_593 VGND VGND VPWR VPWR sky130_fd_sc_hd__decap_3
XFILLER_44_541 VGND VGND VPWR VPWR sky130_fd_sc_hd__decap_3
XFILLER_71_360 VGND VGND VPWR VPWR sky130_fd_sc_hd__decap_4
XFILLER_44_552 VGND VGND VPWR VPWR sky130_fd_sc_hd__fill_2
XFILLER_44_574 VGND VGND VPWR VPWR sky130_fd_sc_hd__fill_1
XTAP_TAPCELL_ROW_14_422 VGND VPWR sky130_fd_sc_hd__tapvpwrvgnd_1
XFILLER_31_268 VGND VGND VPWR VPWR sky130_fd_sc_hd__fill_1
XTAP_TAPCELL_ROW_42_753 VGND VPWR sky130_fd_sc_hd__tapvpwrvgnd_1
XFILLER_117_307 VGND VGND VPWR VPWR sky130_fd_sc_hd__fill_1
XFILLER_117_329 VGND VGND VPWR VPWR sky130_fd_sc_hd__decap_3
XFILLER_8_475 VGND VGND VPWR VPWR sky130_fd_sc_hd__fill_1
XTAP_TAPCELL_ROW_113_1605 VGND VPWR sky130_fd_sc_hd__tapvpwrvgnd_1
XFILLER_4_681 VPWR VGND VPWR VGND sky130_ef_sc_hd__decap_12
XFILLER_98_257 VGND VGND VPWR VPWR sky130_fd_sc_hd__fill_1
X_6020_ net431 _1554_ VGND VGND VPWR VPWR _0236_ sky130_fd_sc_hd__nor2_1
XFILLER_86_408 VGND VGND VPWR VPWR sky130_fd_sc_hd__fill_1
Xclkbuf_leaf_3_clk clknet_3_4__leaf_clk VGND VGND VPWR VPWR clknet_leaf_3_clk sky130_fd_sc_hd__clkbuf_8
XFILLER_66_154 VGND VGND VPWR VPWR sky130_fd_sc_hd__decap_3
XFILLER_66_132 VGND VGND VPWR VPWR sky130_fd_sc_hd__decap_8
XFILLER_82_625 VPWR VGND VPWR VGND sky130_ef_sc_hd__decap_12
XFILLER_81_113 VGND VGND VPWR VPWR sky130_fd_sc_hd__decap_4
X_7971_ _3332_ _3338_ _3331_ VGND VGND VPWR VPWR _3365_ sky130_fd_sc_hd__a21bo_1
X_6922_ _2350_ _2351_ _2389_ _2390_ VGND VGND VPWR VPWR _2392_ sky130_fd_sc_hd__a2bb2o_1
X_6853_ net494 net331 VGND VGND VPWR VPWR _2324_ sky130_fd_sc_hd__nand2_1
X_5804_ net432 _1343_ VGND VGND VPWR VPWR _0231_ sky130_fd_sc_hd__nor2_1
X_6784_ net430 _2257_ VGND VGND VPWR VPWR _0297_ sky130_fd_sc_hd__nor2_1
XFILLER_22_235 VGND VGND VPWR VPWR sky130_fd_sc_hd__fill_1
X_8523_ _3900_ _3901_ net162 VGND VGND VPWR VPWR _3903_ sky130_fd_sc_hd__o21ai_1
X_5735_ net514 net505 net353 net351 VGND VGND VPWR VPWR _1277_ sky130_fd_sc_hd__and4_1
XFILLER_13_27 VGND VGND VPWR VPWR sky130_fd_sc_hd__decap_6
XFILLER_10_419 VGND VGND VPWR VPWR sky130_fd_sc_hd__fill_1
X_8454_ _3833_ _3834_ net191 VGND VGND VPWR VPWR _3836_ sky130_fd_sc_hd__a21o_1
XTAP_TAPCELL_ROW_79_1202 VGND VPWR sky130_fd_sc_hd__tapvpwrvgnd_1
X_5666_ net991 net365 VGND VGND VPWR VPWR _0207_ sky130_fd_sc_hd__and2_1
X_7405_ _2859_ _2860_ VGND VGND VPWR VPWR _2862_ sky130_fd_sc_hd__xnor2_1
X_4617_ _4378_ _4377_ _4361_ VGND VGND VPWR VPWR _4380_ sky130_fd_sc_hd__a21o_1
X_8385_ net419 _3769_ VGND VGND VPWR VPWR _0386_ sky130_fd_sc_hd__nor2_1
Xhold420 pe_accum\[2\]\[13\] VGND VGND VPWR VPWR net935 sky130_fd_sc_hd__dlygate4sd3_1
X_5597_ net951 net375 VGND VGND VPWR VPWR _0138_ sky130_fd_sc_hd__and2_1
XFILLER_116_362 VGND VGND VPWR VPWR sky130_fd_sc_hd__fill_2
Xhold431 pe_accum\[2\]\[2\] VGND VGND VPWR VPWR net946 sky130_fd_sc_hd__dlygate4sd3_1
Xhold453 pe_accum\[2\]\[3\] VGND VGND VPWR VPWR net968 sky130_fd_sc_hd__dlygate4sd3_1
X_7336_ net267 _2793_ _2794_ VGND VGND VPWR VPWR _2795_ sky130_fd_sc_hd__nor3_1
Xhold442 pe_accum\[3\]\[22\] VGND VGND VPWR VPWR net957 sky130_fd_sc_hd__dlygate4sd3_1
X_4548_ _4310_ _4311_ _4312_ VGND VGND VPWR VPWR _4313_ sky130_fd_sc_hd__and3_1
Xhold486 pe_accum\[2\]\[10\] VGND VGND VPWR VPWR net1001 sky130_fd_sc_hd__dlygate4sd3_1
Xhold475 pe_accum\[2\]\[15\] VGND VGND VPWR VPWR net990 sky130_fd_sc_hd__dlygate4sd3_1
X_7267_ _2727_ _2728_ VGND VGND VPWR VPWR _2729_ sky130_fd_sc_hd__xnor2_2
Xhold464 pe_accum\[1\]\[17\] VGND VGND VPWR VPWR net979 sky130_fd_sc_hd__dlygate4sd3_1
X_4479_ net400 _4242_ VGND VGND VPWR VPWR _4249_ sky130_fd_sc_hd__nor2_1
X_6218_ _1636_ _1673_ VGND VGND VPWR VPWR _1747_ sky130_fd_sc_hd__nor2_1
X_9006_ clknet_leaf_30_clk _0118_ VGND VGND VPWR VPWR net75 sky130_fd_sc_hd__dfxtp_1
Xhold497 pe_accum\[1\]\[3\] VGND VGND VPWR VPWR net1012 sky130_fd_sc_hd__dlygate4sd3_1
XFILLER_58_622 VPWR VGND VPWR VGND sky130_ef_sc_hd__decap_12
X_7198_ net452 _4234_ _2622_ _2623_ VGND VGND VPWR VPWR _2661_ sky130_fd_sc_hd__o22a_1
XFILLER_38_24 VGND VGND VPWR VPWR sky130_fd_sc_hd__decap_4
XFILLER_85_430 VGND VGND VPWR VPWR sky130_fd_sc_hd__fill_2
X_6149_ _1679_ _1600_ VGND VGND VPWR VPWR _1680_ sky130_fd_sc_hd__xnor2_4
XFILLER_38_57 VGND VGND VPWR VPWR sky130_fd_sc_hd__fill_1
XPHY_EDGE_ROW_79_Right_79 VGND VGND VPWR VPWR sky130_fd_sc_hd__decap_3
XFILLER_58_699 VGND VGND VPWR VPWR sky130_fd_sc_hd__fill_1
XFILLER_18_519 VGND VGND VPWR VPWR sky130_fd_sc_hd__decap_4
XFILLER_73_669 VGND VGND VPWR VPWR sky130_fd_sc_hd__decap_3
XFILLER_45_349 VGND VGND VPWR VPWR sky130_fd_sc_hd__decap_6
XFILLER_72_179 VGND VGND VPWR VPWR sky130_fd_sc_hd__decap_8
XFILLER_26_574 VPWR VGND VPWR VGND sky130_ef_sc_hd__decap_12
XFILLER_53_393 VGND VGND VPWR VPWR sky130_fd_sc_hd__fill_2
XPHY_EDGE_ROW_88_Right_88 VGND VGND VPWR VPWR sky130_fd_sc_hd__decap_3
XFILLER_5_489 VGND VGND VPWR VPWR sky130_fd_sc_hd__fill_1
XFILLER_107_384 VGND VGND VPWR VPWR sky130_fd_sc_hd__decap_4
XFILLER_1_673 VPWR VGND VPWR VGND sky130_ef_sc_hd__decap_12
XPHY_EDGE_ROW_97_Right_97 VGND VGND VPWR VPWR sky130_fd_sc_hd__decap_3
XFILLER_88_290 VPWR VGND VPWR VGND sky130_ef_sc_hd__decap_12
XFILLER_95_85 VGND VGND VPWR VPWR sky130_fd_sc_hd__decap_6
XFILLER_64_625 VPWR VGND VPWR VGND sky130_ef_sc_hd__decap_12
XFILLER_63_102 VGND VGND VPWR VPWR sky130_fd_sc_hd__decap_8
XTAP_TAPCELL_ROW_47_812 VGND VPWR sky130_fd_sc_hd__tapvpwrvgnd_1
XTAP_TAPCELL_ROW_47_823 VGND VPWR sky130_fd_sc_hd__tapvpwrvgnd_1
XFILLER_49_699 VGND VGND VPWR VPWR sky130_fd_sc_hd__fill_1
XFILLER_91_422 VGND VGND VPWR VPWR sky130_fd_sc_hd__decap_4
XFILLER_64_669 VGND VGND VPWR VPWR sky130_fd_sc_hd__fill_2
XFILLER_63_113 VPWR VGND VPWR VGND sky130_ef_sc_hd__decap_12
XFILLER_29_390 VGND VGND VPWR VPWR sky130_fd_sc_hd__fill_2
XFILLER_48_187 VGND VGND VPWR VPWR sky130_fd_sc_hd__decap_8
XFILLER_17_574 VPWR VGND VPWR VGND sky130_ef_sc_hd__decap_12
XTAP_TAPCELL_ROW_63_1014 VGND VPWR sky130_fd_sc_hd__tapvpwrvgnd_1
XTAP_TAPCELL_ROW_27_580 VGND VPWR sky130_fd_sc_hd__tapvpwrvgnd_1
XFILLER_32_533 VPWR VGND VPWR VGND sky130_ef_sc_hd__decap_12
X_5520_ net919 net250 _1220_ net366 VGND VGND VPWR VPWR _0070_ sky130_fd_sc_hd__o211a_1
XFILLER_117_159 VGND VGND VPWR VPWR sky130_fd_sc_hd__fill_1
XFILLER_117_137 VGND VGND VPWR VPWR sky130_fd_sc_hd__decap_3
X_5451_ net417 _1179_ VGND VGND VPWR VPWR _0042_ sky130_fd_sc_hd__nor2_1
X_8170_ _3556_ _3557_ _3510_ _3512_ VGND VGND VPWR VPWR _3560_ sky130_fd_sc_hd__a211o_1
X_5382_ _1074_ _1077_ _1112_ VGND VGND VPWR VPWR _1113_ sky130_fd_sc_hd__o21a_1
XTAP_TAPCELL_ROW_74_1143 VGND VPWR sky130_fd_sc_hd__tapvpwrvgnd_1
X_7121_ net446 net339 pe_array\[1\].u_pe.accum_reg\[12\] VGND VGND VPWR VPWR _2586_
+ sky130_fd_sc_hd__a21oi_1
Xfanout218 _3209_ VGND VGND VPWR VPWR net218 sky130_fd_sc_hd__clkbuf_2
XFILLER_101_505 VGND VGND VPWR VPWR sky130_fd_sc_hd__fill_1
Xfanout229 _2203_ VGND VGND VPWR VPWR net229 sky130_fd_sc_hd__buf_2
Xfanout207 net208 VGND VGND VPWR VPWR net207 sky130_fd_sc_hd__buf_8
X_7052_ _2516_ _2517_ _2470_ _2473_ VGND VGND VPWR VPWR _2519_ sky130_fd_sc_hd__o211a_1
XFILLER_113_398 VGND VGND VPWR VPWR sky130_fd_sc_hd__decap_8
X_6003_ _1533_ _1534_ _1535_ VGND VGND VPWR VPWR _1538_ sky130_fd_sc_hd__a21o_1
XFILLER_94_293 VGND VGND VPWR VPWR sky130_fd_sc_hd__decap_6
XFILLER_82_433 VGND VGND VPWR VPWR sky130_fd_sc_hd__decap_6
X_7954_ _3344_ _3347_ _3343_ VGND VGND VPWR VPWR _3349_ sky130_fd_sc_hd__a21oi_1
XFILLER_82_455 VGND VGND VPWR VPWR sky130_fd_sc_hd__decap_4
X_6905_ _2366_ _2374_ VGND VGND VPWR VPWR _2375_ sky130_fd_sc_hd__xnor2_1
X_7885_ _3279_ _3280_ VGND VGND VPWR VPWR _3282_ sky130_fd_sc_hd__xnor2_2
XTAP_TAPCELL_ROW_85_1272 VGND VPWR sky130_fd_sc_hd__tapvpwrvgnd_1
XFILLER_24_15 VGND VGND VPWR VPWR sky130_fd_sc_hd__decap_8
X_6836_ _2247_ _2275_ _2273_ VGND VGND VPWR VPWR _2308_ sky130_fd_sc_hd__a21oi_1
XFILLER_35_393 VGND VGND VPWR VPWR sky130_fd_sc_hd__fill_1
X_6767_ _2238_ _2239_ net495 net337 VGND VGND VPWR VPWR _2241_ sky130_fd_sc_hd__or4bb_1
XFILLER_50_363 VGND VGND VPWR VPWR sky130_fd_sc_hd__fill_1
XFILLER_10_216 VGND VGND VPWR VPWR sky130_fd_sc_hd__decap_3
X_5718_ net514 net353 _1260_ VGND VGND VPWR VPWR _1261_ sky130_fd_sc_hd__nand3_1
X_8506_ _3878_ _3885_ VGND VGND VPWR VPWR _3887_ sky130_fd_sc_hd__xnor2_4
XFILLER_10_249 VGND VGND VPWR VPWR sky130_fd_sc_hd__decap_3
XFILLER_108_115 VPWR VGND VPWR VGND sky130_ef_sc_hd__decap_12
X_6698_ net892 net236 _1553_ net244 VGND VGND VPWR VPWR _0268_ sky130_fd_sc_hd__o2bb2ai_1
X_8437_ _3816_ _3817_ _3818_ VGND VGND VPWR VPWR _3820_ sky130_fd_sc_hd__a21oi_1
X_5649_ net917 net367 VGND VGND VPWR VPWR _0190_ sky130_fd_sc_hd__and2_1
X_8368_ _3750_ _3751_ _3752_ VGND VGND VPWR VPWR _3753_ sky130_fd_sc_hd__and3_1
X_7319_ _2775_ _2776_ _2777_ VGND VGND VPWR VPWR _2779_ sky130_fd_sc_hd__a21oi_1
XFILLER_104_365 VGND VGND VPWR VPWR sky130_fd_sc_hd__decap_4
X_8299_ _3633_ _3646_ _3645_ VGND VGND VPWR VPWR _3686_ sky130_fd_sc_hd__a21bo_1
XFILLER_105_73 VGND VGND VPWR VPWR sky130_fd_sc_hd__fill_1
XFILLER_100_571 VPWR VGND VPWR VGND sky130_ef_sc_hd__decap_12
XFILLER_92_208 VGND VGND VPWR VPWR sky130_fd_sc_hd__fill_1
XFILLER_46_603 VGND VGND VPWR VPWR sky130_fd_sc_hd__decap_8
XFILLER_46_625 VGND VGND VPWR VPWR sky130_fd_sc_hd__fill_1
XFILLER_73_422 VGND VGND VPWR VPWR sky130_fd_sc_hd__decap_3
XFILLER_65_55 VGND VGND VPWR VPWR sky130_fd_sc_hd__fill_1
XFILLER_65_99 VPWR VGND VPWR VGND sky130_ef_sc_hd__decap_12
XFILLER_61_617 VPWR VGND VPWR VGND sky130_ef_sc_hd__decap_12
XFILLER_14_500 VGND VGND VPWR VPWR sky130_fd_sc_hd__decap_3
XFILLER_14_533 VGND VGND VPWR VPWR sky130_fd_sc_hd__fill_1
XTAP_TAPCELL_ROW_52_881 VGND VPWR sky130_fd_sc_hd__tapvpwrvgnd_1
XFILLER_96_525 VGND VGND VPWR VPWR sky130_fd_sc_hd__decap_6
XFILLER_110_357 VGND VGND VPWR VPWR sky130_fd_sc_hd__decap_6
XFILLER_96_569 VPWR VGND VPWR VGND sky130_ef_sc_hd__decap_12
XFILLER_110_379 VGND VGND VPWR VPWR sky130_fd_sc_hd__decap_4
XFILLER_76_260 VGND VGND VPWR VPWR sky130_fd_sc_hd__decap_8
Xinput7 pixel_in[6] VGND VGND VPWR VPWR net7 sky130_fd_sc_hd__buf_1
XFILLER_37_614 VGND VGND VPWR VPWR sky130_fd_sc_hd__fill_2
XTAP_TAPCELL_ROW_108_1548 VGND VPWR sky130_fd_sc_hd__tapvpwrvgnd_1
XFILLER_64_433 VGND VGND VPWR VPWR sky130_fd_sc_hd__decap_4
XFILLER_37_636 VGND VGND VPWR VPWR sky130_fd_sc_hd__fill_1
XFILLER_64_477 VGND VGND VPWR VPWR sky130_fd_sc_hd__fill_1
X_4951_ _0692_ _0693_ _0654_ _0655_ VGND VGND VPWR VPWR _0696_ sky130_fd_sc_hd__a211o_1
XFILLER_17_393 VPWR VGND VPWR VGND sky130_ef_sc_hd__decap_12
X_4882_ _0562_ _0564_ _0626_ _0628_ VGND VGND VPWR VPWR _0629_ sky130_fd_sc_hd__a211o_2
X_7670_ _3116_ _3117_ VGND VGND VPWR VPWR _3118_ sky130_fd_sc_hd__or2_1
X_6621_ net201 _2136_ VGND VGND VPWR VPWR _2137_ sky130_fd_sc_hd__and2_1
XFILLER_20_525 VGND VGND VPWR VPWR sky130_fd_sc_hd__decap_3
XFILLER_32_396 VGND VGND VPWR VPWR sky130_fd_sc_hd__fill_2
X_6552_ _2068_ _2069_ VGND VGND VPWR VPWR _2070_ sky130_fd_sc_hd__and2_1
X_6483_ _2003_ _2002_ VGND VGND VPWR VPWR _2004_ sky130_fd_sc_hd__and2b_1
X_9271_ clknet_leaf_3_clk _0383_ VGND VGND VPWR VPWR pe_array\[2\].u_pe.accum_reg\[13\]
+ sky130_fd_sc_hd__dfxtp_1
X_5503_ _0843_ net247 VGND VGND VPWR VPWR _1212_ sky130_fd_sc_hd__nand2_2
XFILLER_106_619 VGND VGND VPWR VPWR sky130_fd_sc_hd__decap_4
X_8222_ _3544_ _3547_ _3610_ _3608_ VGND VGND VPWR VPWR _3611_ sky130_fd_sc_hd__a211o_4
X_5434_ net743 _1162_ VGND VGND VPWR VPWR _1163_ sky130_fd_sc_hd__xnor2_1
XFILLER_99_330 VGND VGND VPWR VPWR sky130_fd_sc_hd__decap_6
X_8153_ _3539_ _3542_ VGND VGND VPWR VPWR _3543_ sky130_fd_sc_hd__xnor2_1
XFILLER_87_503 VGND VGND VPWR VPWR sky130_fd_sc_hd__fill_1
X_5365_ _1091_ _1094_ _1095_ _1086_ VGND VGND VPWR VPWR _1096_ sky130_fd_sc_hd__o211a_1
X_7104_ _2567_ _2568_ VGND VGND VPWR VPWR _2570_ sky130_fd_sc_hd__or2_1
XFILLER_99_385 VGND VGND VPWR VPWR sky130_fd_sc_hd__fill_2
X_8084_ _3473_ _3474_ _3462_ VGND VGND VPWR VPWR _3476_ sky130_fd_sc_hd__a21o_1
X_5296_ net179 _1003_ _1001_ VGND VGND VPWR VPWR _1030_ sky130_fd_sc_hd__a21oi_1
XFILLER_101_357 VGND VGND VPWR VPWR sky130_fd_sc_hd__decap_3
XFILLER_87_558 VGND VGND VPWR VPWR sky130_fd_sc_hd__fill_2
XFILLER_19_15 VPWR VGND VPWR VGND sky130_ef_sc_hd__decap_12
X_7035_ net519 _2500_ VGND VGND VPWR VPWR _2502_ sky130_fd_sc_hd__xnor2_2
XTAP_TAPCELL_ROW_87_1301 VGND VPWR sky130_fd_sc_hd__tapvpwrvgnd_1
XFILLER_74_219 VGND VGND VPWR VPWR sky130_fd_sc_hd__fill_1
XFILLER_67_293 VPWR VGND VPWR VGND sky130_ef_sc_hd__decap_12
XFILLER_27_113 VGND VGND VPWR VPWR sky130_fd_sc_hd__fill_1
X_8986_ clknet_leaf_30_clk _0098_ VGND VGND VPWR VPWR net53 sky130_fd_sc_hd__dfxtp_1
XFILLER_55_466 VGND VGND VPWR VPWR sky130_fd_sc_hd__decap_4
XTAP_TAPCELL_ROW_2_278 VGND VPWR sky130_fd_sc_hd__tapvpwrvgnd_1
XFILLER_43_617 VGND VGND VPWR VPWR sky130_fd_sc_hd__fill_1
XFILLER_82_263 VGND VGND VPWR VPWR sky130_fd_sc_hd__fill_2
X_7937_ _3329_ _3330_ _3292_ _3293_ VGND VGND VPWR VPWR _3332_ sky130_fd_sc_hd__a211o_1
XFILLER_36_680 VGND VGND VPWR VPWR sky130_fd_sc_hd__decap_4
X_7868_ net504 net318 pe_array\[2\].u_pe.accum_reg\[4\] VGND VGND VPWR VPWR _3265_
+ sky130_fd_sc_hd__a21oi_1
XFILLER_51_650 VGND VGND VPWR VPWR sky130_fd_sc_hd__decap_4
X_6819_ _2287_ _2290_ VGND VGND VPWR VPWR _2291_ sky130_fd_sc_hd__xnor2_1
XFILLER_11_503 VGND VGND VPWR VPWR sky130_fd_sc_hd__fill_1
XFILLER_23_352 VGND VGND VPWR VPWR sky130_fd_sc_hd__fill_2
XFILLER_50_160 VPWR VGND VPWR VGND sky130_ef_sc_hd__decap_12
X_7799_ net17 _3206_ _3207_ net294 VGND VGND VPWR VPWR _0362_ sky130_fd_sc_hd__a22o_1
XFILLER_11_558 VGND VGND VPWR VPWR sky130_fd_sc_hd__fill_2
XTAP_TAPCELL_ROW_98_1430 VGND VPWR sky130_fd_sc_hd__tapvpwrvgnd_1
XFILLER_51_57 VPWR VGND VPWR VGND sky130_ef_sc_hd__decap_12
XFILLER_109_446 VGND VGND VPWR VPWR sky130_fd_sc_hd__fill_2
XFILLER_117_490 VPWR VGND VPWR VGND sky130_ef_sc_hd__decap_12
XFILLER_78_503 VGND VGND VPWR VPWR sky130_fd_sc_hd__fill_2
XFILLER_4_3 VPWR VGND VPWR VGND sky130_ef_sc_hd__decap_12
XFILLER_104_173 VGND VGND VPWR VPWR sky130_fd_sc_hd__fill_1
XFILLER_2_289 VPWR VGND VPWR VGND sky130_ef_sc_hd__decap_12
XFILLER_116_83 VGND VGND VPWR VPWR sky130_fd_sc_hd__fill_1
XFILLER_104_195 VGND VGND VPWR VPWR sky130_fd_sc_hd__fill_1
XFILLER_78_547 VGND VGND VPWR VPWR sky130_fd_sc_hd__decap_3
XFILLER_93_517 VPWR VGND VPWR VGND sky130_ef_sc_hd__decap_12
XFILLER_19_603 VPWR VGND VPWR VGND sky130_ef_sc_hd__decap_12
XFILLER_73_230 VGND VGND VPWR VPWR sky130_fd_sc_hd__decap_4
XTAP_TAPCELL_ROW_57_940 VGND VPWR sky130_fd_sc_hd__tapvpwrvgnd_1
XFILLER_92_97 VGND VGND VPWR VPWR sky130_fd_sc_hd__decap_3
XFILLER_61_447 VGND VGND VPWR VPWR sky130_fd_sc_hd__fill_1
XFILLER_14_330 VPWR VGND VPWR VGND sky130_ef_sc_hd__decap_12
XFILLER_42_661 VGND VGND VPWR VPWR sky130_fd_sc_hd__decap_6
XTAP_TAPCELL_ROW_103_1489 VGND VPWR sky130_fd_sc_hd__tapvpwrvgnd_1
XFILLER_115_449 VGND VGND VPWR VPWR sky130_fd_sc_hd__decap_4
XTAP_TAPCELL_ROW_71_1102 VGND VPWR sky130_fd_sc_hd__tapvpwrvgnd_1
XFILLER_96_300 VGND VGND VPWR VPWR sky130_fd_sc_hd__fill_1
XFILLER_69_503 VGND VGND VPWR VPWR sky130_fd_sc_hd__fill_1
X_5150_ net178 _0861_ _0860_ VGND VGND VPWR VPWR _0889_ sky130_fd_sc_hd__a21oi_1
XFILLER_37_3 VPWR VGND VPWR VGND sky130_ef_sc_hd__decap_12
XFILLER_69_558 VGND VGND VPWR VPWR sky130_fd_sc_hd__fill_2
X_5081_ _0819_ _0818_ _0786_ _0788_ VGND VGND VPWR VPWR _0822_ sky130_fd_sc_hd__a211o_1
XFILLER_37_422 VPWR VGND VPWR VGND sky130_ef_sc_hd__decap_12
X_8840_ net216 _3448_ VGND VGND VPWR VPWR _4201_ sky130_fd_sc_hd__nand2_1
XFILLER_64_241 VGND VGND VPWR VPWR sky130_fd_sc_hd__fill_1
X_8771_ _4108_ _4110_ _4141_ VGND VGND VPWR VPWR _4143_ sky130_fd_sc_hd__nor3_1
XTAP_TAPCELL_ROW_69_1086 VGND VPWR sky130_fd_sc_hd__tapvpwrvgnd_1
X_5983_ _1511_ _1516_ VGND VGND VPWR VPWR _1518_ sky130_fd_sc_hd__xnor2_1
XFILLER_37_488 VGND VGND VPWR VPWR sky130_fd_sc_hd__decap_3
X_4934_ net397 pe_array\[3\].u_pe.accum_reg\[13\] net255 _0679_ VGND VGND VPWR VPWR
+ _0680_ sky130_fd_sc_hd__o2bb2a_1
X_7722_ _3143_ _3144_ net167 VGND VGND VPWR VPWR _3168_ sky130_fd_sc_hd__mux2_1
XTAP_TAPCELL_ROW_82_1242 VGND VPWR sky130_fd_sc_hd__tapvpwrvgnd_1
XTAP_TAPCELL_ROW_35_678 VGND VPWR sky130_fd_sc_hd__tapvpwrvgnd_1
X_4865_ net285 _0610_ _0611_ VGND VGND VPWR VPWR _0612_ sky130_fd_sc_hd__nor3_1
XFILLER_32_193 VGND VGND VPWR VPWR sky130_fd_sc_hd__decap_3
X_7653_ _3075_ _3072_ _3101_ VGND VGND VPWR VPWR _3102_ sky130_fd_sc_hd__a21oi_4
X_6604_ _2119_ _2120_ VGND VGND VPWR VPWR _2121_ sky130_fd_sc_hd__nor2_1
X_7584_ _3034_ _3033_ VGND VGND VPWR VPWR _3035_ sky130_fd_sc_hd__and2b_1
X_4796_ _0502_ _0544_ _0543_ VGND VGND VPWR VPWR _0545_ sky130_fd_sc_hd__and3_4
X_6535_ _2052_ _2053_ VGND VGND VPWR VPWR _2054_ sky130_fd_sc_hd__nor2_1
X_9254_ clknet_leaf_14_clk _0366_ VGND VGND VPWR VPWR pe_array\[2\].u_pe.tap_count\[0\]
+ sky130_fd_sc_hd__dfxtp_1
X_6466_ net456 net359 pe_array\[0\].u_pe.accum_reg\[24\] VGND VGND VPWR VPWR _1987_
+ sky130_fd_sc_hd__a21oi_1
X_8205_ net259 _3592_ _3593_ VGND VGND VPWR VPWR _3594_ sky130_fd_sc_hd__nor3_1
Xoutput141 net141 VGND VGND VPWR VPWR result_data[92] sky130_fd_sc_hd__buf_2
X_6397_ net413 pe_array\[0\].u_pe.accum_reg\[21\] net240 _1920_ VGND VGND VPWR VPWR
+ _1921_ sky130_fd_sc_hd__o2bb2a_1
Xoutput130 net130 VGND VGND VPWR VPWR result_data[82] sky130_fd_sc_hd__buf_2
X_9185_ clknet_leaf_35_clk _0297_ VGND VGND VPWR VPWR pe_array\[1\].u_pe.accum_reg\[3\]
+ sky130_fd_sc_hd__dfxtp_1
X_5417_ _1146_ _1145_ VGND VGND VPWR VPWR _1147_ sky130_fd_sc_hd__and2b_1
XTAP_TAPCELL_ROW_93_1371 VGND VPWR sky130_fd_sc_hd__tapvpwrvgnd_1
X_8136_ _3524_ _3525_ _3457_ _3460_ VGND VGND VPWR VPWR _3527_ sky130_fd_sc_hd__a211o_1
XTAP_TAPCELL_ROW_7_337 VGND VPWR sky130_fd_sc_hd__tapvpwrvgnd_1
X_5348_ _1079_ _1078_ VGND VGND VPWR VPWR _1080_ sky130_fd_sc_hd__and2b_1
XFILLER_101_110 VGND VGND VPWR VPWR sky130_fd_sc_hd__fill_2
X_8067_ _3407_ _3409_ _3408_ VGND VGND VPWR VPWR _3459_ sky130_fd_sc_hd__o21ba_1
XFILLER_75_517 VGND VGND VPWR VPWR sky130_fd_sc_hd__fill_1
X_5279_ pe_array\[3\].u_pe.accum_reg\[25\] net301 net437 VGND VGND VPWR VPWR _1013_
+ sky130_fd_sc_hd__and3_1
X_7018_ net406 pe_array\[1\].u_pe.accum_reg\[9\] net231 _2485_ VGND VGND VPWR VPWR
+ _2486_ sky130_fd_sc_hd__o2bb2a_1
XFILLER_101_176 VPWR VGND VPWR VGND sky130_ef_sc_hd__decap_12
XFILLER_83_561 VGND VGND VPWR VPWR sky130_fd_sc_hd__fill_1
X_8969_ clknet_leaf_0_clk _0081_ VGND VGND VPWR VPWR pe_array\[1\].u_pe.weight_in\[4\]
+ sky130_fd_sc_hd__dfxtp_1
XFILLER_102_85 VPWR VGND VPWR VGND sky130_ef_sc_hd__decap_12
XFILLER_62_89 VGND VGND VPWR VPWR sky130_fd_sc_hd__decap_6
XFILLER_11_322 VGND VGND VPWR VPWR sky130_fd_sc_hd__fill_1
XFILLER_109_221 VGND VGND VPWR VPWR sky130_fd_sc_hd__decap_3
XPHY_EDGE_ROW_12_Left_130 VGND VGND VPWR VPWR sky130_fd_sc_hd__decap_3
XFILLER_7_337 VPWR VGND VPWR VGND sky130_ef_sc_hd__decap_12
XFILLER_112_419 VGND VGND VPWR VPWR sky130_fd_sc_hd__fill_1
Xclone114 net438 VGND VGND VPWR VPWR net629 sky130_fd_sc_hd__clkbuf_1
Xfanout390 net391 VGND VGND VPWR VPWR net390 sky130_fd_sc_hd__buf_2
XFILLER_59_591 VGND VGND VPWR VPWR sky130_fd_sc_hd__fill_2
XFILLER_81_509 VPWR VGND VPWR VGND sky130_ef_sc_hd__decap_12
Xclone169 net261 VGND VGND VPWR VPWR net684 sky130_fd_sc_hd__clkbuf_1
XFILLER_19_444 VGND VGND VPWR VPWR sky130_fd_sc_hd__decap_4
XFILLER_46_230 VGND VGND VPWR VPWR sky130_fd_sc_hd__decap_8
XTAP_TAPCELL_ROW_105_1518 VGND VPWR sky130_fd_sc_hd__tapvpwrvgnd_1
XFILLER_19_499 VGND VGND VPWR VPWR sky130_fd_sc_hd__decap_4
XFILLER_34_458 VGND VGND VPWR VPWR sky130_fd_sc_hd__fill_1
XFILLER_15_661 VGND VGND VPWR VPWR sky130_fd_sc_hd__decap_3
XTAP_TAPCELL_ROW_32_637 VGND VPWR sky130_fd_sc_hd__tapvpwrvgnd_1
XTAP_TAPCELL_ROW_60_979 VGND VPWR sky130_fd_sc_hd__tapvpwrvgnd_1
XTAP_TAPCELL_ROW_60_968 VGND VPWR sky130_fd_sc_hd__tapvpwrvgnd_1
XFILLER_14_193 VGND VGND VPWR VPWR sky130_fd_sc_hd__decap_3
XFILLER_30_642 VGND VGND VPWR VPWR sky130_fd_sc_hd__fill_2
X_4650_ _4409_ _4410_ _4403_ VGND VGND VPWR VPWR _4412_ sky130_fd_sc_hd__a21o_1
Xinput21 weight_wr VGND VGND VPWR VPWR net21 sky130_fd_sc_hd__clkbuf_2
Xinput10 valid_in VGND VGND VPWR VPWR net10 sky130_fd_sc_hd__clkbuf_2
X_6320_ _1844_ _1843_ net280 VGND VGND VPWR VPWR _1846_ sky130_fd_sc_hd__or3_4
XTAP_TAPCELL_ROW_12_394 VGND VPWR sky130_fd_sc_hd__tapvpwrvgnd_1
X_4581_ _4342_ _4343_ _4326_ VGND VGND VPWR VPWR _4345_ sky130_fd_sc_hd__and3b_1
XTAP_TAPCELL_ROW_116_1647 VGND VPWR sky130_fd_sc_hd__tapvpwrvgnd_1
XFILLER_115_246 VGND VGND VPWR VPWR sky130_fd_sc_hd__decap_8
X_6251_ net411 pe_array\[0\].u_pe.accum_reg\[16\] net240 _1779_ VGND VGND VPWR VPWR
+ _1780_ sky130_fd_sc_hd__o2bb2a_2
X_6182_ _1673_ _1674_ _1670_ VGND VGND VPWR VPWR _1713_ sky130_fd_sc_hd__o21ai_2
X_5202_ net186 _0912_ _0911_ VGND VGND VPWR VPWR _0939_ sky130_fd_sc_hd__a21oi_1
X_5133_ net295 net433 pe_array\[3\].u_pe.accum_reg\[20\] VGND VGND VPWR VPWR _0872_
+ sky130_fd_sc_hd__a21oi_1
XFILLER_111_441 VGND VGND VPWR VPWR sky130_fd_sc_hd__decap_6
XFILLER_97_664 VGND VGND VPWR VPWR sky130_fd_sc_hd__decap_8
XTAP_TAPCELL_ROW_4_307 VGND VPWR sky130_fd_sc_hd__tapvpwrvgnd_1
XFILLER_97_697 VGND VGND VPWR VPWR sky130_fd_sc_hd__decap_3
XFILLER_69_399 VGND VGND VPWR VPWR sky130_fd_sc_hd__fill_1
XFILLER_29_219 VGND VGND VPWR VPWR sky130_fd_sc_hd__decap_4
X_5064_ net180 _0767_ _0766_ VGND VGND VPWR VPWR _0806_ sky130_fd_sc_hd__a21bo_1
X_8823_ _4192_ net421 VGND VGND VPWR VPWR _0401_ sky130_fd_sc_hd__nor2_1
XFILLER_65_561 VGND VGND VPWR VPWR sky130_fd_sc_hd__decap_6
XFILLER_52_244 VGND VGND VPWR VPWR sky130_fd_sc_hd__fill_1
XFILLER_16_27 VGND VGND VPWR VPWR sky130_fd_sc_hd__fill_1
XFILLER_25_447 VGND VGND VPWR VPWR sky130_fd_sc_hd__fill_1
X_8754_ pe_array\[2\].u_pe.accum_reg\[29\] _3508_ VGND VGND VPWR VPWR _4126_ sky130_fd_sc_hd__nor2_1
XFILLER_80_586 VGND VGND VPWR VPWR sky130_fd_sc_hd__fill_2
X_5966_ _1500_ _1499_ _1454_ _1456_ VGND VGND VPWR VPWR _1502_ sky130_fd_sc_hd__a211o_4
XFILLER_40_417 VGND VGND VPWR VPWR sky130_fd_sc_hd__decap_3
X_8685_ _4034_ _4032_ _4058_ VGND VGND VPWR VPWR _4060_ sky130_fd_sc_hd__and3_1
X_5897_ net473 net467 net353 net350 VGND VGND VPWR VPWR _1434_ sky130_fd_sc_hd__and4_1
X_7705_ _3121_ _3124_ _3150_ VGND VGND VPWR VPWR _3152_ sky130_fd_sc_hd__nor3_1
X_4917_ net745 _0617_ _0615_ VGND VGND VPWR VPWR _0663_ sky130_fd_sc_hd__a21o_1
X_4848_ net397 pe_array\[3\].u_pe.accum_reg\[11\] net255 _0595_ VGND VGND VPWR VPWR
+ _0596_ sky130_fd_sc_hd__o2bb2a_1
X_7636_ net197 _3083_ VGND VGND VPWR VPWR _3085_ sky130_fd_sc_hd__xnor2_1
X_9306_ clknet_leaf_4_clk _0418_ VGND VGND VPWR VPWR pe_accum\[2\]\[16\] sky130_fd_sc_hd__dfxtp_1
XFILLER_20_185 VGND VGND VPWR VPWR sky130_fd_sc_hd__decap_8
X_4779_ _0526_ _0525_ _0484_ _0485_ VGND VGND VPWR VPWR _0528_ sky130_fd_sc_hd__a211o_1
X_7567_ pe_array\[1\].u_pe.accum_reg\[26\] net550 net342 VGND VGND VPWR VPWR _3018_
+ sky130_fd_sc_hd__and3_1
X_6518_ _2036_ _2037_ VGND VGND VPWR VPWR _2038_ sky130_fd_sc_hd__xnor2_1
XFILLER_106_213 VGND VGND VPWR VPWR sky130_fd_sc_hd__fill_1
X_7498_ _2951_ _2950_ VGND VGND VPWR VPWR _2952_ sky130_fd_sc_hd__and2b_1
X_6449_ _1716_ _1938_ _1937_ VGND VGND VPWR VPWR _1971_ sky130_fd_sc_hd__a21oi_1
X_9237_ clknet_leaf_45_clk _0349_ VGND VGND VPWR VPWR pe_accum\[1\]\[23\] sky130_fd_sc_hd__dfxtp_1
X_9168_ clknet_leaf_26_clk _0280_ VGND VGND VPWR VPWR pe_accum\[0\]\[22\] sky130_fd_sc_hd__dfxtp_1
XFILLER_88_653 VGND VGND VPWR VPWR sky130_fd_sc_hd__fill_1
XFILLER_88_642 VGND VGND VPWR VPWR sky130_fd_sc_hd__fill_2
X_8119_ pe_array\[2\].u_pe.accum_reg\[10\] net443 net317 VGND VGND VPWR VPWR _3510_
+ sky130_fd_sc_hd__and3_4
XFILLER_0_546 VPWR VGND VPWR VGND sky130_ef_sc_hd__decap_12
XFILLER_75_303 VGND VGND VPWR VPWR sky130_fd_sc_hd__decap_6
X_9099_ clknet_leaf_59_clk _0211_ VGND VGND VPWR VPWR net50 sky130_fd_sc_hd__dfxtp_1
XFILLER_102_496 VGND VGND VPWR VPWR sky130_fd_sc_hd__decap_3
XFILLER_113_51 VGND VGND VPWR VPWR sky130_fd_sc_hd__decap_4
XFILLER_83_391 VGND VGND VPWR VPWR sky130_fd_sc_hd__fill_1
XFILLER_73_55 VGND VGND VPWR VPWR sky130_fd_sc_hd__fill_1
XFILLER_73_33 VGND VGND VPWR VPWR sky130_fd_sc_hd__fill_2
XFILLER_43_233 VGND VGND VPWR VPWR sky130_fd_sc_hd__decap_3
XFILLER_71_575 VPWR VGND VPWR VGND sky130_ef_sc_hd__decap_12
XFILLER_12_631 VGND VGND VPWR VPWR sky130_fd_sc_hd__decap_8
XFILLER_31_428 VGND VGND VPWR VPWR sky130_fd_sc_hd__decap_3
XTAP_TAPCELL_ROW_100_1459 VGND VPWR sky130_fd_sc_hd__tapvpwrvgnd_1
XTAP_TAPCELL_ROW_100_1448 VGND VPWR sky130_fd_sc_hd__tapvpwrvgnd_1
XFILLER_8_657 VPWR VGND VPWR VGND sky130_ef_sc_hd__decap_12
XFILLER_7_134 VPWR VGND VPWR VGND sky130_ef_sc_hd__decap_12
XTAP_TAPCELL_ROW_111_1588 VGND VPWR sky130_fd_sc_hd__tapvpwrvgnd_1
XFILLER_94_601 VGND VGND VPWR VPWR sky130_fd_sc_hd__decap_6
XFILLER_79_653 VPWR VGND VPWR VGND sky130_ef_sc_hd__decap_12
XFILLER_66_303 VGND VGND VPWR VPWR sky130_fd_sc_hd__decap_4
XFILLER_39_528 VGND VGND VPWR VPWR sky130_fd_sc_hd__fill_2
XFILLER_47_561 VPWR VGND VPWR VGND sky130_ef_sc_hd__decap_12
XTAP_TAPCELL_ROW_66_1045 VGND VPWR sky130_fd_sc_hd__tapvpwrvgnd_1
XFILLER_62_531 VGND VGND VPWR VPWR sky130_fd_sc_hd__fill_1
X_5820_ pe_array\[0\].u_pe.accum_reg\[6\] net467 net358 VGND VGND VPWR VPWR _1359_
+ sky130_fd_sc_hd__and3_1
XTAP_TAPCELL_ROW_17_453 VGND VPWR sky130_fd_sc_hd__tapvpwrvgnd_1
X_5751_ _1290_ _1291_ VGND VGND VPWR VPWR _1292_ sky130_fd_sc_hd__nor2_1
XTAP_TAPCELL_ROW_45_795 VGND VPWR sky130_fd_sc_hd__tapvpwrvgnd_1
X_8470_ _3824_ _3823_ net154 VGND VGND VPWR VPWR _3852_ sky130_fd_sc_hd__a21oi_4
X_4702_ _0448_ _0449_ _0450_ VGND VGND VPWR VPWR _0453_ sky130_fd_sc_hd__a21o_1
X_5682_ net20 _1230_ _1231_ net1036 VGND VGND VPWR VPWR _0221_ sky130_fd_sc_hd__a22o_1
X_7421_ _2872_ _2877_ VGND VGND VPWR VPWR _2878_ sky130_fd_sc_hd__xnor2_2
X_4633_ _4356_ _4394_ VGND VGND VPWR VPWR _4395_ sky130_fd_sc_hd__xnor2_1
X_7352_ net168 _2809_ _2810_ VGND VGND VPWR VPWR _2811_ sky130_fd_sc_hd__nand3_1
X_4564_ net307 net305 net477 net472 VGND VGND VPWR VPWR _4328_ sky130_fd_sc_hd__and4_1
X_6303_ _1827_ _1828_ net171 VGND VGND VPWR VPWR _1830_ sky130_fd_sc_hd__a21o_1
XTAP_TAPCELL_ROW_77_1174 VGND VPWR sky130_fd_sc_hd__tapvpwrvgnd_1
X_7283_ net165 _2742_ _2743_ VGND VGND VPWR VPWR _2744_ sky130_fd_sc_hd__or3_4
X_6234_ _1762_ _1761_ _1760_ VGND VGND VPWR VPWR _1763_ sky130_fd_sc_hd__and3_1
X_9022_ clknet_leaf_45_clk _0134_ VGND VGND VPWR VPWR net92 sky130_fd_sc_hd__dfxtp_1
X_4495_ pe_array\[3\].u_pe.accum_reg\[2\] net509 net302 VGND VGND VPWR VPWR _4262_
+ sky130_fd_sc_hd__and3_1
XTAP_TAPCELL_ROW_90_1330 VGND VPWR sky130_fd_sc_hd__tapvpwrvgnd_1
X_6165_ net200 _1656_ _1654_ VGND VGND VPWR VPWR _1696_ sky130_fd_sc_hd__a21o_1
XFILLER_97_472 VGND VGND VPWR VPWR sky130_fd_sc_hd__decap_4
X_6096_ _1563_ _1565_ _1626_ _1628_ VGND VGND VPWR VPWR _1629_ sky130_fd_sc_hd__a211o_4
XFILLER_69_163 VGND VGND VPWR VPWR sky130_fd_sc_hd__decap_4
XFILLER_57_314 VGND VGND VPWR VPWR sky130_fd_sc_hd__fill_1
X_5116_ _0852_ _0853_ net631 VGND VGND VPWR VPWR _0856_ sky130_fd_sc_hd__a21oi_1
XFILLER_27_26 VPWR VGND VPWR VGND sky130_ef_sc_hd__decap_12
X_5047_ net283 _0786_ _0787_ VGND VGND VPWR VPWR _0789_ sky130_fd_sc_hd__or3_1
XFILLER_25_200 VGND VGND VPWR VPWR sky130_fd_sc_hd__decap_4
XFILLER_25_211 VGND VGND VPWR VPWR sky130_fd_sc_hd__fill_1
X_8806_ _4176_ _4157_ VGND VGND VPWR VPWR _4177_ sky130_fd_sc_hd__xnor2_2
XFILLER_25_266 VPWR VGND VPWR VGND sky130_ef_sc_hd__decap_12
X_6998_ _2464_ _2463_ _2414_ _2416_ VGND VGND VPWR VPWR _2466_ sky130_fd_sc_hd__a211o_1
X_8737_ net163 _4109_ VGND VGND VPWR VPWR _4110_ sky130_fd_sc_hd__nor2_1
X_5949_ net274 _1482_ _1483_ VGND VGND VPWR VPWR _1485_ sky130_fd_sc_hd__or3_4
XFILLER_13_417 VPWR VGND VPWR VGND sky130_ef_sc_hd__decap_12
XFILLER_40_269 VGND VGND VPWR VPWR sky130_fd_sc_hd__decap_3
XFILLER_43_69 VPWR VGND VPWR VGND sky130_ef_sc_hd__decap_12
X_8668_ _4041_ _4042_ VGND VGND VPWR VPWR _4043_ sky130_fd_sc_hd__xor2_1
XFILLER_21_461 VGND VGND VPWR VPWR sky130_fd_sc_hd__decap_4
X_8599_ _3878_ _3972_ _3943_ _3913_ VGND VGND VPWR VPWR _3976_ sky130_fd_sc_hd__or4_4
X_7619_ net406 pe_array\[1\].u_pe.accum_reg\[27\] net231 _3068_ VGND VGND VPWR VPWR
+ _3069_ sky130_fd_sc_hd__o2bb2a_4
XFILLER_104_3 VPWR VGND VPWR VGND sky130_ef_sc_hd__decap_12
XFILLER_107_577 VGND VGND VPWR VPWR sky130_fd_sc_hd__decap_8
XFILLER_88_472 VGND VGND VPWR VPWR sky130_fd_sc_hd__decap_4
XFILLER_75_100 VPWR VGND VPWR VGND sky130_ef_sc_hd__decap_12
XFILLER_68_99 VPWR VGND VPWR VGND sky130_ef_sc_hd__decap_12
XFILLER_0_365 VGND VGND VPWR VPWR sky130_fd_sc_hd__fill_2
XFILLER_76_645 VPWR VGND VPWR VGND sky130_ef_sc_hd__decap_12
XFILLER_48_336 VPWR VGND VPWR VGND sky130_ef_sc_hd__decap_12
XFILLER_91_615 VGND VGND VPWR VPWR sky130_fd_sc_hd__fill_1
XFILLER_75_188 VGND VGND VPWR VPWR sky130_fd_sc_hd__fill_2
XFILLER_63_328 VGND VGND VPWR VPWR sky130_fd_sc_hd__fill_1
XFILLER_29_561 VPWR VGND VPWR VGND sky130_ef_sc_hd__decap_12
XFILLER_71_372 VPWR VGND VPWR VGND sky130_ef_sc_hd__decap_12
XFILLER_31_225 VGND VGND VPWR VPWR sky130_fd_sc_hd__fill_1
XTAP_TAPCELL_ROW_14_423 VGND VPWR sky130_fd_sc_hd__tapvpwrvgnd_1
XTAP_TAPCELL_ROW_42_754 VGND VPWR sky130_fd_sc_hd__tapvpwrvgnd_1
XFILLER_8_421 VPWR VGND VPWR VGND sky130_ef_sc_hd__decap_12
XTAP_TAPCELL_ROW_113_1606 VGND VPWR sky130_fd_sc_hd__tapvpwrvgnd_1
XFILLER_4_693 VGND VGND VPWR VPWR sky130_fd_sc_hd__decap_6
XFILLER_79_461 VPWR VGND VPWR VGND sky130_ef_sc_hd__decap_12
XFILLER_79_494 VGND VGND VPWR VPWR sky130_fd_sc_hd__decap_3
XFILLER_66_111 VPWR VGND VPWR VGND sky130_ef_sc_hd__decap_12
XFILLER_94_486 VGND VGND VPWR VPWR sky130_fd_sc_hd__fill_2
XFILLER_94_475 VGND VGND VPWR VPWR sky130_fd_sc_hd__fill_1
XFILLER_82_637 VGND VGND VPWR VPWR sky130_fd_sc_hd__decap_6
X_7970_ _3342_ _3350_ _3341_ VGND VGND VPWR VPWR _3364_ sky130_fd_sc_hd__a21bo_1
X_6921_ _2351_ _2388_ _2349_ _2348_ VGND VGND VPWR VPWR _2391_ sky130_fd_sc_hd__or4bb_4
X_6852_ _2317_ _2321_ VGND VGND VPWR VPWR _2323_ sky130_fd_sc_hd__xnor2_1
X_5803_ net413 pe_array\[0\].u_pe.accum_reg\[5\] net238 _1342_ VGND VGND VPWR VPWR
+ _1343_ sky130_fd_sc_hd__o2bb2a_1
XFILLER_62_383 VPWR VGND VPWR VGND sky130_ef_sc_hd__decap_12
X_8522_ net162 _3900_ net599 VGND VGND VPWR VPWR _3902_ sky130_fd_sc_hd__or3_4
X_6783_ net412 pe_array\[1\].u_pe.accum_reg\[3\] net231 _2256_ VGND VGND VPWR VPWR
+ _2257_ sky130_fd_sc_hd__o2bb2a_1
X_5734_ net505 net353 net351 net514 VGND VGND VPWR VPWR _1276_ sky130_fd_sc_hd__a22oi_1
X_8453_ net188 _3832_ _3834_ VGND VGND VPWR VPWR _3835_ sky130_fd_sc_hd__or3b_1
XTAP_TAPCELL_ROW_79_1203 VGND VPWR sky130_fd_sc_hd__tapvpwrvgnd_1
X_5665_ net982 net365 VGND VGND VPWR VPWR _0206_ sky130_fd_sc_hd__and2_1
XFILLER_30_280 VGND VGND VPWR VPWR sky130_fd_sc_hd__fill_1
X_8384_ net401 pe_array\[2\].u_pe.accum_reg\[16\] net217 _3768_ VGND VGND VPWR VPWR
+ _3769_ sky130_fd_sc_hd__o2bb2a_4
X_7404_ _2860_ _2859_ VGND VGND VPWR VPWR _2861_ sky130_fd_sc_hd__and2b_1
X_4616_ _4361_ _4377_ _4378_ VGND VGND VPWR VPWR _4379_ sky130_fd_sc_hd__nand3_4
XPHY_EDGE_ROW_111_Right_111 VGND VGND VPWR VPWR sky130_fd_sc_hd__decap_3
Xhold410 pe_accum\[2\]\[20\] VGND VGND VPWR VPWR net925 sky130_fd_sc_hd__dlygate4sd3_1
X_7335_ net447 net340 pe_array\[1\].u_pe.accum_reg\[18\] VGND VGND VPWR VPWR _2794_
+ sky130_fd_sc_hd__a21oi_1
X_5596_ net995 net373 VGND VGND VPWR VPWR _0137_ sky130_fd_sc_hd__and2_1
Xhold421 pe_accum\[2\]\[29\] VGND VGND VPWR VPWR net936 sky130_fd_sc_hd__dlygate4sd3_1
Xhold454 pe_accum\[2\]\[22\] VGND VGND VPWR VPWR net969 sky130_fd_sc_hd__dlygate4sd3_1
Xhold432 pe_accum\[3\]\[18\] VGND VGND VPWR VPWR net947 sky130_fd_sc_hd__dlygate4sd3_1
Xhold443 pe_accum\[1\]\[23\] VGND VGND VPWR VPWR net958 sky130_fd_sc_hd__dlygate4sd3_1
X_4547_ _4262_ _4280_ _4281_ _4287_ VGND VGND VPWR VPWR _4312_ sky130_fd_sc_hd__a31o_1
Xhold487 pe_accum\[2\]\[31\] VGND VGND VPWR VPWR net1002 sky130_fd_sc_hd__dlygate4sd3_1
XFILLER_89_225 VPWR VGND VPWR VGND sky130_ef_sc_hd__decap_12
Xhold476 pe_accum\[3\]\[25\] VGND VGND VPWR VPWR net991 sky130_fd_sc_hd__dlygate4sd3_1
XFILLER_1_129 VGND VGND VPWR VPWR sky130_fd_sc_hd__fill_2
Xhold465 pe_accum\[3\]\[21\] VGND VGND VPWR VPWR net980 sky130_fd_sc_hd__dlygate4sd3_1
X_4478_ _4247_ _4248_ VGND VGND VPWR VPWR _0010_ sky130_fd_sc_hd__nor2_1
X_7266_ _2694_ _2692_ _2689_ VGND VGND VPWR VPWR _2728_ sky130_fd_sc_hd__o21ai_2
X_9005_ clknet_leaf_22_clk _0117_ VGND VGND VPWR VPWR net74 sky130_fd_sc_hd__dfxtp_1
XFILLER_89_258 VGND VGND VPWR VPWR sky130_fd_sc_hd__decap_8
XFILLER_77_409 VGND VGND VPWR VPWR sky130_fd_sc_hd__fill_1
X_6217_ _1711_ _1742_ VGND VGND VPWR VPWR _1746_ sky130_fd_sc_hd__and2_1
X_7197_ _2659_ VGND VGND VPWR VPWR _2660_ sky130_fd_sc_hd__inv_2
Xhold498 pe_array\[3\].u_pe.tap_count\[1\] VGND VGND VPWR VPWR net1013 sky130_fd_sc_hd__dlygate4sd3_1
X_6148_ net455 _4232_ _1641_ _1640_ VGND VGND VPWR VPWR _1679_ sky130_fd_sc_hd__o22a_4
XFILLER_58_634 VGND VGND VPWR VPWR sky130_fd_sc_hd__decap_8
XFILLER_58_645 VPWR VGND VPWR VGND sky130_ef_sc_hd__decap_12
X_6079_ net277 _1610_ _1611_ VGND VGND VPWR VPWR _1612_ sky130_fd_sc_hd__nor3_1
XFILLER_72_103 VGND VGND VPWR VPWR sky130_fd_sc_hd__decap_8
XFILLER_57_177 VGND VGND VPWR VPWR sky130_fd_sc_hd__fill_2
XFILLER_73_648 VGND VGND VPWR VPWR sky130_fd_sc_hd__fill_1
XFILLER_13_225 VGND VGND VPWR VPWR sky130_fd_sc_hd__decap_8
XFILLER_26_586 VGND VGND VPWR VPWR sky130_fd_sc_hd__fill_2
XFILLER_110_41 VPWR VGND VPWR VGND sky130_ef_sc_hd__decap_12
XFILLER_41_545 VGND VGND VPWR VPWR sky130_fd_sc_hd__decap_4
XFILLER_110_85 VGND VGND VPWR VPWR sky130_fd_sc_hd__decap_8
XFILLER_5_479 VGND VGND VPWR VPWR sky130_fd_sc_hd__fill_1
XFILLER_107_374 VGND VGND VPWR VPWR sky130_fd_sc_hd__decap_3
XFILLER_79_65 VGND VGND VPWR VPWR sky130_fd_sc_hd__fill_1
XFILLER_1_641 VPWR VGND VPWR VGND sky130_ef_sc_hd__decap_12
XFILLER_110_539 VPWR VGND VPWR VGND sky130_ef_sc_hd__decap_12
XFILLER_110_528 VGND VGND VPWR VPWR sky130_fd_sc_hd__decap_4
XFILLER_0_162 VGND VGND VPWR VPWR sky130_fd_sc_hd__fill_2
XFILLER_1_685 VPWR VGND VPWR VGND sky130_ef_sc_hd__decap_12
XTAP_TAPCELL_ROW_47_813 VGND VPWR sky130_fd_sc_hd__tapvpwrvgnd_1
XFILLER_49_689 VGND VGND VPWR VPWR sky130_fd_sc_hd__fill_2
XFILLER_76_497 VGND VGND VPWR VPWR sky130_fd_sc_hd__decap_4
XFILLER_64_637 VGND VGND VPWR VPWR sky130_fd_sc_hd__decap_6
XFILLER_63_125 VGND VGND VPWR VPWR sky130_fd_sc_hd__decap_8
XFILLER_17_520 VGND VGND VPWR VPWR sky130_fd_sc_hd__fill_1
XFILLER_91_456 VPWR VGND VPWR VGND sky130_ef_sc_hd__decap_12
XTAP_TAPCELL_ROW_63_1015 VGND VPWR sky130_fd_sc_hd__tapvpwrvgnd_1
XTAP_TAPCELL_ROW_63_1004 VGND VPWR sky130_fd_sc_hd__tapvpwrvgnd_1
XFILLER_17_586 VPWR VGND VPWR VGND sky130_ef_sc_hd__decap_12
XFILLER_44_372 VGND VGND VPWR VPWR sky130_fd_sc_hd__decap_4
XTAP_TAPCELL_ROW_27_581 VGND VPWR sky130_fd_sc_hd__tapvpwrvgnd_1
XFILLER_32_545 VGND VGND VPWR VPWR sky130_fd_sc_hd__decap_4
XPHY_EDGE_ROW_4_Left_122 VGND VGND VPWR VPWR sky130_fd_sc_hd__decap_3
X_5450_ net400 pe_array\[3\].u_pe.accum_reg\[30\] net258 _1178_ VGND VGND VPWR VPWR
+ _1179_ sky130_fd_sc_hd__o2bb2a_4
XFILLER_67_3 VPWR VGND VPWR VGND sky130_ef_sc_hd__decap_12
XFILLER_99_512 VGND VGND VPWR VPWR sky130_fd_sc_hd__decap_8
X_5381_ net748 _1110_ VGND VGND VPWR VPWR _1112_ sky130_fd_sc_hd__xnor2_1
XTAP_TAPCELL_ROW_74_1144 VGND VPWR sky130_fd_sc_hd__tapvpwrvgnd_1
XFILLER_5_73 VGND VGND VPWR VPWR sky130_fd_sc_hd__decap_6
XFILLER_5_51 VGND VGND VPWR VPWR sky130_fd_sc_hd__decap_4
X_7120_ _2574_ _2583_ VGND VGND VPWR VPWR _2585_ sky130_fd_sc_hd__xnor2_1
Xfanout219 _3209_ VGND VGND VPWR VPWR net219 sky130_fd_sc_hd__buf_2
XFILLER_4_490 VGND VGND VPWR VPWR sky130_fd_sc_hd__fill_2
Xfanout208 _0567_ VGND VGND VPWR VPWR net208 sky130_fd_sc_hd__buf_8
X_7051_ _2470_ _2473_ _2517_ _2516_ VGND VGND VPWR VPWR _2518_ sky130_fd_sc_hd__a211oi_4
X_6002_ _1536_ VGND VGND VPWR VPWR _1537_ sky130_fd_sc_hd__inv_2
X_7953_ _3343_ _3344_ _3347_ VGND VGND VPWR VPWR _3348_ sky130_fd_sc_hd__and3_1
XFILLER_54_147 VPWR VGND VPWR VGND sky130_ef_sc_hd__decap_12
XFILLER_42_309 VGND VGND VPWR VPWR sky130_fd_sc_hd__decap_8
X_6904_ _2371_ _2372_ VGND VGND VPWR VPWR _2374_ sky130_fd_sc_hd__xor2_1
X_7884_ _3280_ _3279_ VGND VGND VPWR VPWR _3281_ sky130_fd_sc_hd__nand2b_1
XTAP_TAPCELL_ROW_85_1273 VGND VPWR sky130_fd_sc_hd__tapvpwrvgnd_1
XFILLER_23_501 VGND VGND VPWR VPWR sky130_fd_sc_hd__decap_3
XFILLER_23_512 VPWR VGND VPWR VGND sky130_ef_sc_hd__decap_12
XPHY_EDGE_ROW_59_Left_177 VGND VGND VPWR VPWR sky130_fd_sc_hd__decap_3
X_6835_ _2305_ _2306_ VGND VGND VPWR VPWR _2307_ sky130_fd_sc_hd__nor2_1
XFILLER_24_27 VGND VGND VPWR VPWR sky130_fd_sc_hd__fill_1
X_6766_ _2238_ _2239_ net495 net337 VGND VGND VPWR VPWR _2240_ sky130_fd_sc_hd__and4bb_1
X_5717_ _1257_ _1258_ VGND VGND VPWR VPWR _1260_ sky130_fd_sc_hd__xnor2_1
X_8505_ _3884_ _3882_ _3878_ VGND VGND VPWR VPWR _3886_ sky130_fd_sc_hd__o21bai_4
XFILLER_109_617 VPWR VGND VPWR VGND sky130_ef_sc_hd__decap_12
X_6697_ net243 _1508_ net235 net1010 VGND VGND VPWR VPWR _0267_ sky130_fd_sc_hd__a2bb2o_1
XFILLER_108_127 VPWR VGND VPWR VGND sky130_ef_sc_hd__decap_12
X_8436_ _3816_ _3817_ _3818_ VGND VGND VPWR VPWR _3819_ sky130_fd_sc_hd__and3_1
X_5648_ net934 net367 VGND VGND VPWR VPWR _0189_ sky130_fd_sc_hd__and2_1
XFILLER_40_37 VPWR VGND VPWR VGND sky130_ef_sc_hd__decap_12
X_8367_ _3702_ _3720_ _3719_ VGND VGND VPWR VPWR _3752_ sky130_fd_sc_hd__o21bai_1
X_5579_ net911 net390 VGND VGND VPWR VPWR _0120_ sky130_fd_sc_hd__and2_1
XFILLER_104_322 VPWR VGND VPWR VGND sky130_ef_sc_hd__decap_12
X_8298_ _3682_ _3683_ _3670_ VGND VGND VPWR VPWR _3685_ sky130_fd_sc_hd__a21o_1
XPHY_EDGE_ROW_68_Left_186 VGND VGND VPWR VPWR sky130_fd_sc_hd__decap_3
X_7318_ _2776_ _2775_ _2777_ VGND VGND VPWR VPWR _2778_ sky130_fd_sc_hd__and3_1
X_7249_ _2708_ _2709_ net195 VGND VGND VPWR VPWR _2711_ sky130_fd_sc_hd__a21o_1
XFILLER_49_57 VPWR VGND VPWR VGND sky130_ef_sc_hd__decap_12
XFILLER_100_550 VPWR VGND VPWR VGND sky130_ef_sc_hd__decap_12
XFILLER_58_475 VGND VGND VPWR VPWR sky130_fd_sc_hd__fill_1
XFILLER_18_317 VPWR VGND VPWR VGND sky130_ef_sc_hd__decap_12
XFILLER_105_96 VPWR VGND VPWR VGND sky130_ef_sc_hd__decap_12
XFILLER_100_583 VGND VGND VPWR VPWR sky130_fd_sc_hd__decap_4
XFILLER_65_78 VGND VGND VPWR VPWR sky130_fd_sc_hd__decap_4
XFILLER_45_169 VGND VGND VPWR VPWR sky130_fd_sc_hd__decap_4
XFILLER_81_11 VGND VGND VPWR VPWR sky130_fd_sc_hd__decap_8
XPHY_EDGE_ROW_77_Left_195 VGND VGND VPWR VPWR sky130_fd_sc_hd__decap_3
XFILLER_61_629 VPWR VGND VPWR VGND sky130_ef_sc_hd__decap_12
XFILLER_60_117 VGND VGND VPWR VPWR sky130_fd_sc_hd__fill_2
XFILLER_26_383 VPWR VGND VPWR VGND sky130_ef_sc_hd__decap_12
XFILLER_81_55 VGND VGND VPWR VPWR sky130_fd_sc_hd__fill_1
XFILLER_14_589 VPWR VGND VPWR VGND sky130_ef_sc_hd__decap_12
XTAP_TAPCELL_ROW_24_540 VGND VPWR sky130_fd_sc_hd__tapvpwrvgnd_1
XTAP_TAPCELL_ROW_52_882 VGND VPWR sky130_fd_sc_hd__tapvpwrvgnd_1
XFILLER_5_221 VGND VGND VPWR VPWR sky130_fd_sc_hd__decap_3
XFILLER_115_609 VGND VGND VPWR VPWR sky130_fd_sc_hd__decap_6
XFILLER_68_239 VGND VGND VPWR VPWR sky130_fd_sc_hd__decap_3
Xinput8 pixel_in[7] VGND VGND VPWR VPWR net8 sky130_fd_sc_hd__buf_8
XFILLER_39_90 VGND VGND VPWR VPWR sky130_fd_sc_hd__decap_3
XFILLER_49_486 VGND VGND VPWR VPWR sky130_fd_sc_hd__decap_8
XTAP_TAPCELL_ROW_108_1549 VGND VPWR sky130_fd_sc_hd__tapvpwrvgnd_1
XFILLER_91_297 VGND VGND VPWR VPWR sky130_fd_sc_hd__fill_2
XFILLER_17_361 VPWR VGND VPWR VGND sky130_ef_sc_hd__decap_12
X_4950_ _0654_ _0655_ _0692_ _0693_ VGND VGND VPWR VPWR _0695_ sky130_fd_sc_hd__o211ai_1
XFILLER_51_139 VGND VGND VPWR VPWR sky130_fd_sc_hd__fill_1
X_4881_ _0623_ _0625_ _0580_ _0583_ VGND VGND VPWR VPWR _0628_ sky130_fd_sc_hd__o211a_1
X_6620_ _2133_ _2134_ VGND VGND VPWR VPWR _2136_ sky130_fd_sc_hd__xnor2_1
X_6551_ net276 _2041_ _2040_ VGND VGND VPWR VPWR _2069_ sky130_fd_sc_hd__o21bai_1
X_5502_ net965 net246 _1211_ net363 VGND VGND VPWR VPWR _0061_ sky130_fd_sc_hd__o211a_1
X_6482_ _1964_ _1965_ _1967_ _1969_ VGND VGND VPWR VPWR _2003_ sky130_fd_sc_hd__o31a_1
X_9270_ clknet_leaf_3_clk _0382_ VGND VGND VPWR VPWR pe_array\[2\].u_pe.accum_reg\[12\]
+ sky130_fd_sc_hd__dfxtp_1
XFILLER_105_108 VGND VGND VPWR VPWR sky130_fd_sc_hd__decap_4
X_8221_ _3607_ _3605_ _3563_ _3566_ VGND VGND VPWR VPWR _3610_ sky130_fd_sc_hd__o211a_1
X_5433_ _1160_ _1161_ VGND VGND VPWR VPWR _1162_ sky130_fd_sc_hd__nand2_1
X_8152_ _3540_ _3541_ VGND VGND VPWR VPWR _3542_ sky130_fd_sc_hd__or2_1
XFILLER_10_29 VPWR VGND VPWR VGND sky130_ef_sc_hd__decap_12
X_5364_ _1057_ _1085_ _1059_ VGND VGND VPWR VPWR _1095_ sky130_fd_sc_hd__o21ai_1
X_7103_ _2522_ _2566_ VGND VGND VPWR VPWR _2569_ sky130_fd_sc_hd__nand2_1
X_8083_ _3462_ _3473_ _3474_ VGND VGND VPWR VPWR _3475_ sky130_fd_sc_hd__nand3_2
X_5295_ net181 _1028_ VGND VGND VPWR VPWR _1029_ sky130_fd_sc_hd__xor2_1
XFILLER_19_27 VGND VGND VPWR VPWR sky130_fd_sc_hd__decap_8
X_7034_ net452 net330 VGND VGND VPWR VPWR _2501_ sky130_fd_sc_hd__nand2_1
XTAP_TAPCELL_ROW_87_1302 VGND VPWR sky130_fd_sc_hd__tapvpwrvgnd_1
XFILLER_27_103 VGND VGND VPWR VPWR sky130_fd_sc_hd__fill_1
X_8985_ clknet_leaf_29_clk _0097_ VGND VGND VPWR VPWR net44 sky130_fd_sc_hd__dfxtp_1
XTAP_TAPCELL_ROW_2_279 VGND VPWR sky130_fd_sc_hd__tapvpwrvgnd_1
XFILLER_82_286 VGND VGND VPWR VPWR sky130_fd_sc_hd__fill_1
X_7936_ _3292_ _3293_ _3329_ _3330_ VGND VGND VPWR VPWR _3331_ sky130_fd_sc_hd__o211ai_2
XFILLER_27_169 VGND VGND VPWR VPWR sky130_fd_sc_hd__fill_1
X_7867_ net422 _3264_ VGND VGND VPWR VPWR _0373_ sky130_fd_sc_hd__nor2_1
X_6818_ _2288_ _2289_ VGND VGND VPWR VPWR _2290_ sky130_fd_sc_hd__nor2_1
XFILLER_51_695 VGND VGND VPWR VPWR sky130_fd_sc_hd__fill_1
X_7798_ net16 _3206_ _3207_ net299 VGND VGND VPWR VPWR _0361_ sky130_fd_sc_hd__a22o_1
XTAP_TAPCELL_ROW_21_510 VGND VPWR sky130_fd_sc_hd__tapvpwrvgnd_1
XFILLER_50_172 VGND VGND VPWR VPWR sky130_fd_sc_hd__fill_2
XFILLER_50_194 VGND VGND VPWR VPWR sky130_fd_sc_hd__fill_2
XTAP_TAPCELL_ROW_98_1431 VGND VPWR sky130_fd_sc_hd__tapvpwrvgnd_1
X_6749_ pe_array\[1\].u_pe.accum_reg\[2\] net499 net342 VGND VGND VPWR VPWR _2224_
+ sky130_fd_sc_hd__and3_1
XFILLER_51_69 VPWR VGND VPWR VGND sky130_ef_sc_hd__decap_12
X_8419_ _3798_ _3799_ net263 VGND VGND VPWR VPWR _3802_ sky130_fd_sc_hd__o21ai_1
XFILLER_104_141 VPWR VGND VPWR VGND sky130_ef_sc_hd__decap_12
XFILLER_78_537 VGND VGND VPWR VPWR sky130_fd_sc_hd__fill_1
XFILLER_76_11 VGND VGND VPWR VPWR sky130_fd_sc_hd__fill_1
XFILLER_93_529 VGND VGND VPWR VPWR sky130_fd_sc_hd__decap_4
XFILLER_19_615 VGND VGND VPWR VPWR sky130_fd_sc_hd__fill_1
XPHY_EDGE_ROW_85_Left_203 VGND VGND VPWR VPWR sky130_fd_sc_hd__decap_3
XTAP_TAPCELL_ROW_57_941 VGND VPWR sky130_fd_sc_hd__tapvpwrvgnd_1
XFILLER_73_275 VGND VGND VPWR VPWR sky130_fd_sc_hd__decap_4
XFILLER_14_342 VPWR VGND VPWR VGND sky130_ef_sc_hd__decap_12
XFILLER_25_81 VGND VGND VPWR VPWR sky130_fd_sc_hd__fill_1
XPHY_EDGE_ROW_94_Left_212 VGND VGND VPWR VPWR sky130_fd_sc_hd__decap_3
XFILLER_6_563 VGND VGND VPWR VPWR sky130_fd_sc_hd__decap_3
XTAP_TAPCELL_ROW_71_1103 VGND VPWR sky130_fd_sc_hd__tapvpwrvgnd_1
XFILLER_96_312 VPWR VGND VPWR VGND sky130_ef_sc_hd__decap_12
XFILLER_69_515 VGND VGND VPWR VPWR sky130_fd_sc_hd__fill_1
X_5080_ _0786_ _0788_ _0818_ _0819_ VGND VGND VPWR VPWR _0821_ sky130_fd_sc_hd__o211ai_1
XFILLER_2_41 VPWR VGND VPWR VGND sky130_ef_sc_hd__decap_12
XFILLER_2_85 VGND VGND VPWR VPWR sky130_fd_sc_hd__decap_8
XFILLER_37_434 VGND VGND VPWR VPWR sky130_fd_sc_hd__decap_8
XFILLER_49_261 VPWR VGND VPWR VGND sky130_ef_sc_hd__decap_12
XFILLER_92_551 VGND VGND VPWR VPWR sky130_fd_sc_hd__fill_2
X_8770_ _4108_ _4110_ _4141_ VGND VGND VPWR VPWR _4142_ sky130_fd_sc_hd__o21a_1
XTAP_TAPCELL_ROW_69_1087 VGND VPWR sky130_fd_sc_hd__tapvpwrvgnd_1
XTAP_TAPCELL_ROW_69_1076 VGND VPWR sky130_fd_sc_hd__tapvpwrvgnd_1
X_5982_ _1511_ _1516_ VGND VGND VPWR VPWR _1517_ sky130_fd_sc_hd__nand2b_1
XFILLER_64_253 VGND VGND VPWR VPWR sky130_fd_sc_hd__fill_1
XTAP_TAPCELL_ROW_82_1232 VGND VPWR sky130_fd_sc_hd__tapvpwrvgnd_1
X_7721_ net170 _3166_ VGND VGND VPWR VPWR _3167_ sky130_fd_sc_hd__xnor2_1
X_4933_ _0676_ _0678_ VGND VGND VPWR VPWR _0679_ sky130_fd_sc_hd__xnor2_1
XTAP_TAPCELL_ROW_82_1243 VGND VPWR sky130_fd_sc_hd__tapvpwrvgnd_1
XTAP_TAPCELL_ROW_35_668 VGND VPWR sky130_fd_sc_hd__tapvpwrvgnd_1
XTAP_TAPCELL_ROW_35_679 VGND VPWR sky130_fd_sc_hd__tapvpwrvgnd_1
XFILLER_60_470 VGND VGND VPWR VPWR sky130_fd_sc_hd__decap_6
X_4864_ pe_array\[3\].u_pe.accum_reg\[12\] net297 net436 VGND VGND VPWR VPWR _0611_
+ sky130_fd_sc_hd__and3_1
XFILLER_32_161 VGND VGND VPWR VPWR sky130_fd_sc_hd__decap_3
X_7652_ _3099_ _3100_ VGND VGND VPWR VPWR _3101_ sky130_fd_sc_hd__or2_1
X_6603_ _2117_ _2118_ VGND VGND VPWR VPWR _2120_ sky130_fd_sc_hd__and2b_1
X_7583_ net170 _3007_ _3005_ VGND VGND VPWR VPWR _3034_ sky130_fd_sc_hd__a21oi_1
X_4795_ _0540_ _0541_ _0496_ _0498_ VGND VGND VPWR VPWR _0544_ sky130_fd_sc_hd__a211o_1
X_6534_ _2021_ _2023_ _2051_ VGND VGND VPWR VPWR _2053_ sky130_fd_sc_hd__nor3_1
X_6465_ pe_array\[0\].u_pe.accum_reg\[24\] net456 net359 VGND VGND VPWR VPWR _1986_
+ sky130_fd_sc_hd__and3_1
X_9253_ clknet_leaf_0_clk _0365_ VGND VGND VPWR VPWR pe_array\[3\].u_pe.weight_in\[7\]
+ sky130_fd_sc_hd__dfxtp_2
X_8204_ net439 net313 pe_array\[2\].u_pe.accum_reg\[12\] VGND VGND VPWR VPWR _3593_
+ sky130_fd_sc_hd__a21oi_1
X_5416_ net182 _1115_ _1113_ VGND VGND VPWR VPWR _1146_ sky130_fd_sc_hd__a21oi_1
Xoutput142 net142 VGND VGND VPWR VPWR result_data[93] sky130_fd_sc_hd__buf_2
X_6396_ _1918_ _1919_ VGND VGND VPWR VPWR _1920_ sky130_fd_sc_hd__xnor2_1
Xoutput131 net131 VGND VGND VPWR VPWR result_data[83] sky130_fd_sc_hd__buf_2
Xoutput120 net120 VGND VGND VPWR VPWR result_data[73] sky130_fd_sc_hd__buf_2
X_9184_ clknet_leaf_35_clk _0296_ VGND VGND VPWR VPWR pe_array\[1\].u_pe.accum_reg\[2\]
+ sky130_fd_sc_hd__dfxtp_1
XFILLER_102_601 VGND VGND VPWR VPWR sky130_fd_sc_hd__decap_8
XTAP_TAPCELL_ROW_93_1372 VGND VPWR sky130_fd_sc_hd__tapvpwrvgnd_1
X_8135_ _3457_ _3460_ _3524_ _3525_ VGND VGND VPWR VPWR _3526_ sky130_fd_sc_hd__o211ai_2
XTAP_TAPCELL_ROW_7_338 VGND VPWR sky130_fd_sc_hd__tapvpwrvgnd_1
X_5347_ _1047_ _1048_ _1050_ VGND VGND VPWR VPWR _1079_ sky130_fd_sc_hd__o21a_1
XFILLER_114_483 VPWR VGND VPWR VGND sky130_ef_sc_hd__decap_12
XFILLER_102_634 VGND VGND VPWR VPWR sky130_fd_sc_hd__decap_8
XFILLER_102_623 VGND VGND VPWR VPWR sky130_fd_sc_hd__decap_6
XFILLER_99_183 VPWR VGND VPWR VGND sky130_ef_sc_hd__decap_12
XFILLER_87_334 VGND VGND VPWR VPWR sky130_fd_sc_hd__fill_2
X_8066_ _3451_ _3456_ VGND VGND VPWR VPWR _3458_ sky130_fd_sc_hd__xnor2_1
X_5278_ net415 _1012_ VGND VGND VPWR VPWR _0036_ sky130_fd_sc_hd__nor2_1
XFILLER_87_356 VPWR VGND VPWR VGND sky130_ef_sc_hd__decap_12
X_7017_ _2442_ _2484_ VGND VGND VPWR VPWR _2485_ sky130_fd_sc_hd__xnor2_1
XFILLER_101_199 VGND VGND VPWR VPWR sky130_fd_sc_hd__fill_1
XFILLER_101_188 VGND VGND VPWR VPWR sky130_fd_sc_hd__fill_2
XFILLER_28_401 VGND VGND VPWR VPWR sky130_fd_sc_hd__decap_6
XFILLER_55_242 VPWR VGND VPWR VGND sky130_ef_sc_hd__decap_12
XFILLER_28_434 VGND VGND VPWR VPWR sky130_fd_sc_hd__decap_3
XFILLER_28_445 VGND VGND VPWR VPWR sky130_fd_sc_hd__decap_3
XFILLER_55_275 VGND VGND VPWR VPWR sky130_fd_sc_hd__fill_1
XTAP_TAPCELL_ROW_54_900 VGND VPWR sky130_fd_sc_hd__tapvpwrvgnd_1
X_8968_ clknet_leaf_54_clk _0080_ VGND VGND VPWR VPWR pe_array\[1\].u_pe.weight_in\[3\]
+ sky130_fd_sc_hd__dfxtp_1
X_7919_ _3313_ _3314_ VGND VGND VPWR VPWR _3315_ sky130_fd_sc_hd__nand2_1
XFILLER_102_97 VGND VGND VPWR VPWR sky130_fd_sc_hd__decap_8
XFILLER_70_267 VGND VGND VPWR VPWR sky130_fd_sc_hd__fill_1
X_8899_ clknet_leaf_57_clk _0011_ VGND VGND VPWR VPWR pe_array\[3\].u_pe.tap_count\[3\]
+ sky130_fd_sc_hd__dfxtp_1
XFILLER_109_244 VGND VGND VPWR VPWR sky130_fd_sc_hd__decap_8
XFILLER_7_349 VGND VGND VPWR VPWR sky130_fd_sc_hd__decap_8
XFILLER_3_555 VGND VGND VPWR VPWR sky130_fd_sc_hd__fill_1
XFILLER_105_461 VPWR VGND VPWR VGND sky130_ef_sc_hd__decap_12
XFILLER_87_76 VGND VGND VPWR VPWR sky130_fd_sc_hd__fill_1
XFILLER_78_356 VGND VGND VPWR VPWR sky130_fd_sc_hd__fill_1
Xfanout380 net381 VGND VGND VPWR VPWR net380 sky130_fd_sc_hd__clkbuf_2
Xfanout391 net396 VGND VGND VPWR VPWR net391 sky130_fd_sc_hd__clkbuf_2
XFILLER_19_423 VGND VGND VPWR VPWR sky130_fd_sc_hd__decap_8
Xclone115 _0482_ VGND VGND VPWR VPWR net630 sky130_fd_sc_hd__clkbuf_1
XTAP_TAPCELL_ROW_105_1519 VGND VPWR sky130_fd_sc_hd__tapvpwrvgnd_1
XTAP_TAPCELL_ROW_105_1508 VGND VPWR sky130_fd_sc_hd__tapvpwrvgnd_1
XFILLER_46_253 VGND VGND VPWR VPWR sky130_fd_sc_hd__decap_6
XFILLER_61_212 VGND VGND VPWR VPWR sky130_fd_sc_hd__decap_4
XFILLER_15_695 VGND VGND VPWR VPWR sky130_fd_sc_hd__fill_1
XTAP_TAPCELL_ROW_32_638 VGND VPWR sky130_fd_sc_hd__tapvpwrvgnd_1
XTAP_TAPCELL_ROW_60_969 VGND VPWR sky130_fd_sc_hd__tapvpwrvgnd_1
Xinput11 weight_addr[0] VGND VGND VPWR VPWR net11 sky130_fd_sc_hd__buf_2
X_4580_ _4342_ _4343_ VGND VGND VPWR VPWR _4344_ sky130_fd_sc_hd__and2b_1
XTAP_TAPCELL_ROW_12_395 VGND VPWR sky130_fd_sc_hd__tapvpwrvgnd_1
XTAP_TAPCELL_ROW_116_1648 VGND VPWR sky130_fd_sc_hd__tapvpwrvgnd_1
XFILLER_115_225 VGND VGND VPWR VPWR sky130_fd_sc_hd__decap_4
X_6250_ _1751_ _1777_ VGND VGND VPWR VPWR _1779_ sky130_fd_sc_hd__xor2_1
X_6181_ _1634_ _1670_ _1671_ VGND VGND VPWR VPWR _1712_ sky130_fd_sc_hd__a21oi_1
XFILLER_69_301 VGND VGND VPWR VPWR sky130_fd_sc_hd__fill_1
X_5201_ net183 _0937_ VGND VGND VPWR VPWR _0938_ sky130_fd_sc_hd__xnor2_1
X_5132_ net414 _0871_ VGND VGND VPWR VPWR _0031_ sky130_fd_sc_hd__nor2_1
XFILLER_84_304 VGND VGND VPWR VPWR sky130_fd_sc_hd__decap_4
XFILLER_96_197 VPWR VGND VPWR VGND sky130_ef_sc_hd__decap_12
X_5063_ _0802_ _0803_ net179 VGND VGND VPWR VPWR _0805_ sky130_fd_sc_hd__a21o_1
XFILLER_84_359 VGND VGND VPWR VPWR sky130_fd_sc_hd__decap_4
X_8822_ pe_array\[2\].u_pe.accum_reg\[31\] net403 net220 _4191_ VGND VGND VPWR VPWR
+ _4192_ sky130_fd_sc_hd__o2bb2a_4
XFILLER_37_253 VPWR VGND VPWR VGND sky130_ef_sc_hd__decap_12
X_8753_ net421 _4125_ VGND VGND VPWR VPWR _0398_ sky130_fd_sc_hd__nor2_1
X_5965_ _1454_ _1456_ _1499_ _1500_ VGND VGND VPWR VPWR _1501_ sky130_fd_sc_hd__o211ai_4
X_8684_ _4034_ _4032_ _4058_ VGND VGND VPWR VPWR _4059_ sky130_fd_sc_hd__a21oi_2
X_5896_ net467 net353 net350 net473 VGND VGND VPWR VPWR _1433_ sky130_fd_sc_hd__a22oi_1
X_7704_ _3121_ _3124_ _3150_ VGND VGND VPWR VPWR _3151_ sky130_fd_sc_hd__o21a_1
X_4916_ _0659_ _0660_ net206 VGND VGND VPWR VPWR _0662_ sky130_fd_sc_hd__a21o_1
XFILLER_40_429 VGND VGND VPWR VPWR sky130_fd_sc_hd__fill_2
X_4847_ _0593_ _0594_ VGND VGND VPWR VPWR _0595_ sky130_fd_sc_hd__xnor2_1
X_7635_ net649 _3083_ VGND VGND VPWR VPWR _3084_ sky130_fd_sc_hd__nor2_1
X_9305_ clknet_leaf_4_clk _0417_ VGND VGND VPWR VPWR pe_accum\[2\]\[15\] sky130_fd_sc_hd__dfxtp_1
XFILLER_20_197 VGND VGND VPWR VPWR sky130_fd_sc_hd__decap_8
X_4778_ _0484_ _0485_ net646 _0526_ VGND VGND VPWR VPWR _0527_ sky130_fd_sc_hd__o211ai_2
X_7566_ _3017_ net424 VGND VGND VPWR VPWR _0319_ sky130_fd_sc_hd__nor2_1
X_6517_ _1985_ _2009_ _2007_ VGND VGND VPWR VPWR _2037_ sky130_fd_sc_hd__a21oi_1
X_7497_ net168 _2920_ _2919_ VGND VGND VPWR VPWR _2951_ sky130_fd_sc_hd__a21oi_1
X_6448_ net158 _1968_ VGND VGND VPWR VPWR _1970_ sky130_fd_sc_hd__xnor2_1
X_9236_ clknet_leaf_45_clk _0348_ VGND VGND VPWR VPWR pe_accum\[1\]\[22\] sky130_fd_sc_hd__dfxtp_1
X_9167_ clknet_leaf_26_clk _0279_ VGND VGND VPWR VPWR pe_accum\[0\]\[21\] sky130_fd_sc_hd__dfxtp_1
X_6379_ _1872_ _1873_ _1901_ _1902_ VGND VGND VPWR VPWR _1903_ sky130_fd_sc_hd__o211ai_1
X_8118_ net444 net318 VGND VGND VPWR VPWR _3509_ sky130_fd_sc_hd__nand2_1
XFILLER_88_621 VGND VGND VPWR VPWR sky130_fd_sc_hd__decap_6
XFILLER_0_525 VGND VGND VPWR VPWR sky130_fd_sc_hd__decap_6
X_9098_ clknet_leaf_59_clk _0210_ VGND VGND VPWR VPWR net49 sky130_fd_sc_hd__dfxtp_1
XFILLER_0_558 VGND VGND VPWR VPWR sky130_fd_sc_hd__fill_2
XFILLER_102_475 VGND VGND VPWR VPWR sky130_fd_sc_hd__fill_1
X_8049_ _3392_ _3394_ _3440_ _3441_ VGND VGND VPWR VPWR _3442_ sky130_fd_sc_hd__a211oi_2
XFILLER_57_57 VPWR VGND VPWR VGND sky130_ef_sc_hd__decap_12
XFILLER_28_253 VPWR VGND VPWR VGND sky130_ef_sc_hd__decap_12
XFILLER_43_201 VGND VGND VPWR VPWR sky130_fd_sc_hd__decap_4
XFILLER_83_370 VGND VGND VPWR VPWR sky130_fd_sc_hd__fill_2
XFILLER_43_223 VGND VGND VPWR VPWR sky130_fd_sc_hd__fill_1
XFILLER_73_89 VGND VGND VPWR VPWR sky130_fd_sc_hd__decap_6
XFILLER_71_587 VGND VGND VPWR VPWR sky130_fd_sc_hd__decap_6
XTAP_TAPCELL_ROW_100_1449 VGND VPWR sky130_fd_sc_hd__tapvpwrvgnd_1
XFILLER_7_113 VGND VGND VPWR VPWR sky130_fd_sc_hd__fill_1
XFILLER_11_175 VGND VGND VPWR VPWR sky130_fd_sc_hd__fill_1
XFILLER_8_669 VPWR VGND VPWR VGND sky130_ef_sc_hd__decap_12
XFILLER_7_146 VPWR VGND VPWR VGND sky130_ef_sc_hd__decap_12
XFILLER_22_82 VGND VGND VPWR VPWR sky130_fd_sc_hd__fill_2
XFILLER_98_42 VGND VGND VPWR VPWR sky130_fd_sc_hd__decap_3
XFILLER_3_330 VGND VGND VPWR VPWR sky130_fd_sc_hd__decap_6
XFILLER_98_407 VGND VGND VPWR VPWR sky130_fd_sc_hd__decap_6
XFILLER_79_665 VGND VGND VPWR VPWR sky130_fd_sc_hd__decap_6
XTAP_TAPCELL_ROW_111_1589 VGND VPWR sky130_fd_sc_hd__tapvpwrvgnd_1
XFILLER_94_624 VGND VGND VPWR VPWR sky130_fd_sc_hd__decap_3
XFILLER_93_189 VGND VGND VPWR VPWR sky130_fd_sc_hd__fill_1
XFILLER_93_167 VGND VGND VPWR VPWR sky130_fd_sc_hd__fill_1
XFILLER_47_573 VGND VGND VPWR VPWR sky130_fd_sc_hd__decap_4
XFILLER_62_521 VGND VGND VPWR VPWR sky130_fd_sc_hd__fill_1
XTAP_TAPCELL_ROW_66_1046 VGND VPWR sky130_fd_sc_hd__tapvpwrvgnd_1
XTAP_TAPCELL_ROW_17_454 VGND VPWR sky130_fd_sc_hd__tapvpwrvgnd_1
XFILLER_34_245 VGND VGND VPWR VPWR sky130_fd_sc_hd__fill_1
XFILLER_97_3 VGND VGND VPWR VPWR sky130_fd_sc_hd__decap_6
X_5750_ net512 net348 _1288_ _1289_ VGND VGND VPWR VPWR _1291_ sky130_fd_sc_hd__o2bb2a_1
XTAP_TAPCELL_ROW_45_796 VGND VPWR sky130_fd_sc_hd__tapvpwrvgnd_1
X_5681_ net19 _1230_ _1231_ net309 VGND VGND VPWR VPWR _0220_ sky130_fd_sc_hd__a22o_1
X_4701_ _0451_ VGND VGND VPWR VPWR _0452_ sky130_fd_sc_hd__inv_2
X_7420_ _2875_ _2820_ _2874_ VGND VGND VPWR VPWR _2877_ sky130_fd_sc_hd__o21ba_4
X_4632_ _4392_ _4393_ VGND VGND VPWR VPWR _4394_ sky130_fd_sc_hd__nor2_1
X_7351_ _2806_ _2807_ _2808_ VGND VGND VPWR VPWR _2810_ sky130_fd_sc_hd__a21o_1
X_4563_ net501 net294 VGND VGND VPWR VPWR _4327_ sky130_fd_sc_hd__nand2_1
X_6302_ net171 _1827_ _1828_ VGND VGND VPWR VPWR _1829_ sky130_fd_sc_hd__nand3_1
X_7282_ _2739_ _2740_ _2741_ VGND VGND VPWR VPWR _2743_ sky130_fd_sc_hd__a21oi_1
X_4494_ net427 _4261_ VGND VGND VPWR VPWR _0013_ sky130_fd_sc_hd__nor2_1
XFILLER_116_589 VPWR VGND VPWR VGND sky130_ef_sc_hd__decap_12
X_6233_ _1726_ net200 _1724_ VGND VGND VPWR VPWR _1762_ sky130_fd_sc_hd__a21o_1
XTAP_TAPCELL_ROW_77_1175 VGND VPWR sky130_fd_sc_hd__tapvpwrvgnd_1
XFILLER_6_190 VGND VGND VPWR VPWR sky130_fd_sc_hd__fill_1
X_9021_ clknet_leaf_50_clk _0133_ VGND VGND VPWR VPWR net91 sky130_fd_sc_hd__dfxtp_1
XPHY_EDGE_ROW_31_Left_149 VGND VGND VPWR VPWR sky130_fd_sc_hd__decap_3
XTAP_TAPCELL_ROW_90_1331 VGND VPWR sky130_fd_sc_hd__tapvpwrvgnd_1
X_6164_ _1692_ _1693_ net200 VGND VGND VPWR VPWR _1695_ sky130_fd_sc_hd__a21o_1
XFILLER_84_101 VGND VGND VPWR VPWR sky130_fd_sc_hd__fill_1
X_6095_ _1623_ _1625_ _1580_ _1582_ VGND VGND VPWR VPWR _1628_ sky130_fd_sc_hd__o211a_1
X_5115_ _0852_ _0854_ _0853_ VGND VGND VPWR VPWR _0855_ sky130_fd_sc_hd__and3_1
XFILLER_85_668 VGND VGND VPWR VPWR sky130_fd_sc_hd__decap_4
XFILLER_57_337 VGND VGND VPWR VPWR sky130_fd_sc_hd__fill_1
X_5046_ net282 _0786_ _0787_ VGND VGND VPWR VPWR _0788_ sky130_fd_sc_hd__nor3_1
XFILLER_27_38 VGND VGND VPWR VPWR sky130_fd_sc_hd__fill_1
X_8805_ _4175_ VGND VGND VPWR VPWR _4176_ sky130_fd_sc_hd__inv_2
XFILLER_53_576 VGND VGND VPWR VPWR sky130_fd_sc_hd__fill_2
X_6997_ _2414_ _2416_ net548 _2464_ VGND VGND VPWR VPWR _2465_ sky130_fd_sc_hd__o211ai_2
XPHY_EDGE_ROW_40_Left_158 VGND VGND VPWR VPWR sky130_fd_sc_hd__decap_3
X_8736_ _4106_ _4107_ VGND VGND VPWR VPWR _4109_ sky130_fd_sc_hd__xnor2_1
X_5948_ net274 _1482_ _1483_ VGND VGND VPWR VPWR _1484_ sky130_fd_sc_hd__nor3_1
XFILLER_53_598 VGND VGND VPWR VPWR sky130_fd_sc_hd__fill_1
XFILLER_13_429 VPWR VGND VPWR VGND sky130_ef_sc_hd__decap_12
XFILLER_25_278 VGND VGND VPWR VPWR sky130_fd_sc_hd__fill_2
XFILLER_43_15 VPWR VGND VPWR VGND sky130_ef_sc_hd__decap_12
XFILLER_40_237 VGND VGND VPWR VPWR sky130_fd_sc_hd__decap_4
X_8667_ _4012_ _4014_ VGND VGND VPWR VPWR _4042_ sky130_fd_sc_hd__nand2b_1
X_5879_ _1414_ _1415_ VGND VGND VPWR VPWR _1417_ sky130_fd_sc_hd__and2_1
Xclone58 net265 VGND VGND VPWR VPWR net573 sky130_fd_sc_hd__clkbuf_1
X_8598_ net420 _3975_ VGND VGND VPWR VPWR _0393_ sky130_fd_sc_hd__nor2_1
Xclone36 net273 VGND VGND VPWR VPWR net551 sky130_fd_sc_hd__clkbuf_1
X_7618_ _3066_ _3067_ VGND VGND VPWR VPWR _3068_ sky130_fd_sc_hd__xnor2_2
XFILLER_5_617 VPWR VGND VPWR VGND sky130_ef_sc_hd__decap_12
X_7549_ _2999_ _3000_ VGND VGND VPWR VPWR _3001_ sky130_fd_sc_hd__and2_1
XFILLER_108_41 VPWR VGND VPWR VGND sky130_ef_sc_hd__decap_12
X_9219_ clknet_leaf_39_clk _0331_ VGND VGND VPWR VPWR pe_accum\[1\]\[5\] sky130_fd_sc_hd__dfxtp_1
XFILLER_108_96 VGND VGND VPWR VPWR sky130_fd_sc_hd__decap_3
XFILLER_108_85 VGND VGND VPWR VPWR sky130_fd_sc_hd__fill_1
XFILLER_76_602 VPWR VGND VPWR VGND sky130_ef_sc_hd__decap_12
XFILLER_0_322 VGND VGND VPWR VPWR sky130_fd_sc_hd__decap_6
XFILLER_102_250 VGND VGND VPWR VPWR sky130_fd_sc_hd__fill_2
XFILLER_88_495 VGND VGND VPWR VPWR sky130_fd_sc_hd__fill_2
XFILLER_76_668 VGND VGND VPWR VPWR sky130_fd_sc_hd__decap_6
XFILLER_76_657 VGND VGND VPWR VPWR sky130_fd_sc_hd__decap_3
XFILLER_0_399 VGND VGND VPWR VPWR sky130_fd_sc_hd__decap_3
XFILLER_48_348 VGND VGND VPWR VPWR sky130_fd_sc_hd__decap_4
XFILLER_75_167 VGND VGND VPWR VPWR sky130_fd_sc_hd__fill_1
XFILLER_29_573 VPWR VGND VPWR VGND sky130_ef_sc_hd__decap_12
XFILLER_90_137 VGND VGND VPWR VPWR sky130_fd_sc_hd__decap_3
XFILLER_84_690 VGND VGND VPWR VPWR sky130_fd_sc_hd__decap_8
XFILLER_16_223 VGND VGND VPWR VPWR sky130_fd_sc_hd__decap_8
XFILLER_71_384 VGND VGND VPWR VPWR sky130_fd_sc_hd__fill_1
XTAP_TAPCELL_ROW_14_424 VGND VPWR sky130_fd_sc_hd__tapvpwrvgnd_1
XTAP_TAPCELL_ROW_42_755 VGND VPWR sky130_fd_sc_hd__tapvpwrvgnd_1
XFILLER_8_433 VPWR VGND VPWR VGND sky130_ef_sc_hd__decap_12
XFILLER_33_81 VPWR VGND VPWR VGND sky130_ef_sc_hd__decap_12
XFILLER_117_309 VPWR VGND VPWR VGND sky130_ef_sc_hd__decap_12
XFILLER_8_477 VGND VGND VPWR VPWR sky130_fd_sc_hd__decap_3
XTAP_TAPCELL_ROW_113_1607 VGND VPWR sky130_fd_sc_hd__tapvpwrvgnd_1
XFILLER_113_548 VGND VGND VPWR VPWR sky130_fd_sc_hd__decap_3
XFILLER_98_215 VPWR VGND VPWR VGND sky130_ef_sc_hd__decap_12
XFILLER_100_209 VPWR VGND VPWR VGND sky130_ef_sc_hd__decap_12
XFILLER_79_473 VGND VGND VPWR VPWR sky130_fd_sc_hd__decap_4
XFILLER_66_123 VGND VGND VPWR VPWR sky130_fd_sc_hd__fill_2
XFILLER_12_3 VPWR VGND VPWR VGND sky130_ef_sc_hd__decap_12
XFILLER_54_307 VGND VGND VPWR VPWR sky130_fd_sc_hd__fill_1
XFILLER_81_137 VGND VGND VPWR VPWR sky130_fd_sc_hd__decap_8
XFILLER_54_329 VGND VGND VPWR VPWR sky130_fd_sc_hd__decap_6
X_6920_ _2348_ _2388_ VGND VGND VPWR VPWR _2390_ sky130_fd_sc_hd__nand2_1
X_6851_ _2317_ _2318_ _2320_ VGND VGND VPWR VPWR _2322_ sky130_fd_sc_hd__and3_1
X_5802_ _1309_ _1341_ VGND VGND VPWR VPWR _1342_ sky130_fd_sc_hd__xor2_1
X_8521_ net598 _3897_ _3899_ VGND VGND VPWR VPWR _3901_ sky130_fd_sc_hd__a21oi_2
XFILLER_62_395 VGND VGND VPWR VPWR sky130_fd_sc_hd__decap_3
X_6782_ _2253_ _2255_ VGND VGND VPWR VPWR _2256_ sky130_fd_sc_hd__or2_1
X_5733_ _1273_ _1274_ VGND VGND VPWR VPWR _1275_ sky130_fd_sc_hd__and2b_1
X_8452_ _3830_ _3831_ _3799_ _3800_ VGND VGND VPWR VPWR _3834_ sky130_fd_sc_hd__a211o_1
XTAP_TAPCELL_ROW_79_1204 VGND VPWR sky130_fd_sc_hd__tapvpwrvgnd_1
X_5664_ net977 net365 VGND VGND VPWR VPWR _0205_ sky130_fd_sc_hd__and2_1
XFILLER_108_309 VPWR VGND VPWR VGND sky130_ef_sc_hd__decap_12
X_8383_ _3767_ _3759_ VGND VGND VPWR VPWR _3768_ sky130_fd_sc_hd__xnor2_4
X_7403_ _2828_ _2830_ VGND VGND VPWR VPWR _2860_ sky130_fd_sc_hd__and2_1
X_5595_ net949 net373 VGND VGND VPWR VPWR _0136_ sky130_fd_sc_hd__and2_1
X_4615_ _4375_ _4374_ _4376_ VGND VGND VPWR VPWR _4378_ sky130_fd_sc_hd__a21o_1
Xhold400 pe_accum\[0\]\[28\] VGND VGND VPWR VPWR net915 sky130_fd_sc_hd__dlygate4sd3_1
Xhold411 pe_accum\[0\]\[23\] VGND VGND VPWR VPWR net926 sky130_fd_sc_hd__dlygate4sd3_1
X_7334_ pe_array\[1\].u_pe.accum_reg\[18\] net447 net340 VGND VGND VPWR VPWR _2793_
+ sky130_fd_sc_hd__and3_4
X_4546_ _4308_ _4309_ _4302_ VGND VGND VPWR VPWR _4311_ sky130_fd_sc_hd__a21o_1
Xhold444 pe_accum\[0\]\[7\] VGND VGND VPWR VPWR net959 sky130_fd_sc_hd__dlygate4sd3_1
Xhold422 pe_accum\[2\]\[18\] VGND VGND VPWR VPWR net937 sky130_fd_sc_hd__dlygate4sd3_1
Xhold433 pe_accum\[1\]\[16\] VGND VGND VPWR VPWR net948 sky130_fd_sc_hd__dlygate4sd3_1
Xhold455 pe_accum\[2\]\[26\] VGND VGND VPWR VPWR net970 sky130_fd_sc_hd__dlygate4sd3_1
XFILLER_89_237 VPWR VGND VPWR VGND sky130_ef_sc_hd__decap_12
Xhold466 pe_accum\[1\]\[31\] VGND VGND VPWR VPWR net981 sky130_fd_sc_hd__dlygate4sd3_1
Xhold477 pe_accum\[3\]\[13\] VGND VGND VPWR VPWR net992 sky130_fd_sc_hd__dlygate4sd3_1
X_7265_ _2725_ _2726_ VGND VGND VPWR VPWR _2727_ sky130_fd_sc_hd__nor2_1
X_4477_ net1028 _4246_ net369 VGND VGND VPWR VPWR _4248_ sky130_fd_sc_hd__o21ai_1
X_9004_ clknet_leaf_22_clk _0116_ VGND VGND VPWR VPWR net73 sky130_fd_sc_hd__dfxtp_1
Xhold499 pe_accum\[2\]\[1\] VGND VGND VPWR VPWR net1014 sky130_fd_sc_hd__dlygate4sd3_1
X_6216_ net430 _1745_ VGND VGND VPWR VPWR _0241_ sky130_fd_sc_hd__nor2_1
X_7196_ _2576_ _2627_ _2629_ VGND VGND VPWR VPWR _2659_ sky130_fd_sc_hd__a21o_1
Xhold488 pe_accum\[1\]\[10\] VGND VGND VPWR VPWR net1003 sky130_fd_sc_hd__dlygate4sd3_1
X_6147_ _1600_ _1645_ _1647_ VGND VGND VPWR VPWR _1678_ sky130_fd_sc_hd__a21o_1
XFILLER_38_15 VGND VGND VPWR VPWR sky130_fd_sc_hd__fill_1
XFILLER_97_281 VPWR VGND VPWR VGND sky130_ef_sc_hd__decap_12
XFILLER_58_657 VPWR VGND VPWR VGND sky130_ef_sc_hd__decap_12
X_6078_ net458 net361 pe_array\[0\].u_pe.accum_reg\[12\] VGND VGND VPWR VPWR _1611_
+ sky130_fd_sc_hd__a21oi_1
XFILLER_57_167 VGND VGND VPWR VPWR sky130_fd_sc_hd__fill_1
XFILLER_26_521 VGND VGND VPWR VPWR sky130_fd_sc_hd__decap_8
X_5029_ _0768_ _0769_ _0770_ VGND VGND VPWR VPWR _0772_ sky130_fd_sc_hd__nand3_1
XFILLER_45_329 VGND VGND VPWR VPWR sky130_fd_sc_hd__decap_6
XFILLER_110_53 VPWR VGND VPWR VGND sky130_ef_sc_hd__decap_12
X_8719_ _3983_ _3978_ _4090_ _4091_ VGND VGND VPWR VPWR _4092_ sky130_fd_sc_hd__a211o_4
XFILLER_70_24 VGND VGND VPWR VPWR sky130_fd_sc_hd__decap_4
XFILLER_9_208 VGND VGND VPWR VPWR sky130_fd_sc_hd__decap_8
XFILLER_5_447 VGND VGND VPWR VPWR sky130_fd_sc_hd__fill_1
XFILLER_79_99 VPWR VGND VPWR VGND sky130_ef_sc_hd__decap_12
XFILLER_1_653 VPWR VGND VPWR VGND sky130_ef_sc_hd__decap_12
XFILLER_76_421 VGND VGND VPWR VPWR sky130_fd_sc_hd__decap_8
XFILLER_1_697 VGND VGND VPWR VPWR sky130_fd_sc_hd__decap_3
XFILLER_48_123 VGND VGND VPWR VPWR sky130_fd_sc_hd__decap_8
XFILLER_91_402 VGND VGND VPWR VPWR sky130_fd_sc_hd__decap_4
XFILLER_36_307 VGND VGND VPWR VPWR sky130_fd_sc_hd__fill_1
XTAP_TAPCELL_ROW_47_814 VGND VPWR sky130_fd_sc_hd__tapvpwrvgnd_1
XFILLER_91_468 VPWR VGND VPWR VGND sky130_ef_sc_hd__decap_12
XTAP_TAPCELL_ROW_63_1005 VGND VPWR sky130_fd_sc_hd__tapvpwrvgnd_1
XFILLER_17_598 VGND VGND VPWR VPWR sky130_fd_sc_hd__decap_8
XTAP_TAPCELL_ROW_27_582 VGND VPWR sky130_fd_sc_hd__tapvpwrvgnd_1
XFILLER_8_285 VGND VGND VPWR VPWR sky130_fd_sc_hd__fill_1
XFILLER_99_502 VGND VGND VPWR VPWR sky130_fd_sc_hd__fill_2
X_5380_ net185 _1110_ VGND VGND VPWR VPWR _1111_ sky130_fd_sc_hd__nor2_1
XFILLER_99_524 VGND VGND VPWR VPWR sky130_fd_sc_hd__decap_3
XTAP_TAPCELL_ROW_74_1145 VGND VPWR sky130_fd_sc_hd__tapvpwrvgnd_1
XFILLER_99_557 VGND VGND VPWR VPWR sky130_fd_sc_hd__decap_3
Xfanout209 net211 VGND VGND VPWR VPWR net209 sky130_fd_sc_hd__buf_2
X_7050_ _2513_ _2515_ _2497_ VGND VGND VPWR VPWR _2517_ sky130_fd_sc_hd__a21oi_2
XPHY_EDGE_ROW_105_Left_223 VGND VGND VPWR VPWR sky130_fd_sc_hd__decap_3
X_6001_ _1533_ _1534_ _1535_ VGND VGND VPWR VPWR _1536_ sky130_fd_sc_hd__nand3_1
XFILLER_79_281 VGND VGND VPWR VPWR sky130_fd_sc_hd__fill_1
XFILLER_94_251 VGND VGND VPWR VPWR sky130_fd_sc_hd__fill_1
XFILLER_67_476 VGND VGND VPWR VPWR sky130_fd_sc_hd__decap_4
X_7952_ _4228_ _4237_ _3345_ VGND VGND VPWR VPWR _3347_ sky130_fd_sc_hd__or3_1
XFILLER_54_159 VPWR VGND VPWR VGND sky130_ef_sc_hd__decap_12
X_6903_ _2371_ _2372_ VGND VGND VPWR VPWR _2373_ sky130_fd_sc_hd__nand2_1
X_7883_ _3251_ _3255_ _3250_ VGND VGND VPWR VPWR _3280_ sky130_fd_sc_hd__a21oi_1
XTAP_TAPCELL_ROW_85_1274 VGND VPWR sky130_fd_sc_hd__tapvpwrvgnd_1
XFILLER_23_524 VGND VGND VPWR VPWR sky130_fd_sc_hd__fill_1
XFILLER_35_373 VPWR VGND VPWR VGND sky130_ef_sc_hd__decap_12
X_6834_ _2302_ _2304_ _2286_ VGND VGND VPWR VPWR _2306_ sky130_fd_sc_hd__a21oi_1
XFILLER_50_321 VGND VGND VPWR VPWR sky130_fd_sc_hd__fill_2
XPHY_EDGE_ROW_114_Left_232 VGND VGND VPWR VPWR sky130_fd_sc_hd__decap_3
X_6765_ pe_array\[1\].u_pe.accum_reg\[3\] net489 pe_array\[1\].u_pe.weight_in\[0\]
+ VGND VGND VPWR VPWR _2239_ sky130_fd_sc_hd__and3_1
XFILLER_23_568 VGND VGND VPWR VPWR sky130_fd_sc_hd__decap_8
X_5716_ _1255_ _1256_ _1258_ VGND VGND VPWR VPWR _1259_ sky130_fd_sc_hd__or3_1
X_8504_ _3882_ _3884_ VGND VGND VPWR VPWR _3885_ sky130_fd_sc_hd__nor2_8
XFILLER_109_629 VPWR VGND VPWR VGND sky130_ef_sc_hd__decap_12
XFILLER_109_607 VGND VGND VPWR VPWR sky130_fd_sc_hd__decap_8
X_6696_ net1006 net235 _1463_ net243 VGND VGND VPWR VPWR _0266_ sky130_fd_sc_hd__o2bb2ai_1
X_8435_ net160 _3787_ _3786_ VGND VGND VPWR VPWR _3818_ sky130_fd_sc_hd__a21bo_1
XFILLER_108_139 VGND VGND VPWR VPWR sky130_fd_sc_hd__fill_1
X_5647_ net944 net368 VGND VGND VPWR VPWR _0188_ sky130_fd_sc_hd__and2_1
XFILLER_40_49 VPWR VGND VPWR VGND sky130_ef_sc_hd__decap_12
X_8366_ _3748_ _3749_ net160 VGND VGND VPWR VPWR _3751_ sky130_fd_sc_hd__a21o_1
X_5578_ net903 net390 VGND VGND VPWR VPWR _0119_ sky130_fd_sc_hd__and2_1
XFILLER_117_673 VPWR VGND VPWR VGND sky130_ef_sc_hd__decap_12
X_8297_ _3670_ _3682_ _3683_ VGND VGND VPWR VPWR _3684_ sky130_fd_sc_hd__nand3_1
X_7317_ net195 _2738_ _2736_ VGND VGND VPWR VPWR _2777_ sky130_fd_sc_hd__a21o_1
XFILLER_2_417 VGND VGND VPWR VPWR sky130_fd_sc_hd__decap_3
X_4529_ _4293_ _4294_ VGND VGND VPWR VPWR _4295_ sky130_fd_sc_hd__nor2_4
XFILLER_104_334 VPWR VGND VPWR VGND sky130_ef_sc_hd__decap_12
X_7248_ net193 _2707_ _2709_ VGND VGND VPWR VPWR _2710_ sky130_fd_sc_hd__or3b_4
XFILLER_77_207 VGND VGND VPWR VPWR sky130_fd_sc_hd__fill_1
XFILLER_49_69 VPWR VGND VPWR VGND sky130_ef_sc_hd__decap_12
XFILLER_58_421 VPWR VGND VPWR VGND sky130_ef_sc_hd__decap_12
X_7179_ _2640_ _2639_ _2641_ VGND VGND VPWR VPWR _2643_ sky130_fd_sc_hd__a21o_1
XFILLER_100_562 VGND VGND VPWR VPWR sky130_fd_sc_hd__decap_4
XFILLER_73_435 VGND VGND VPWR VPWR sky130_fd_sc_hd__fill_1
XFILLER_18_329 VPWR VGND VPWR VGND sky130_ef_sc_hd__decap_12
XFILLER_73_457 VGND VGND VPWR VPWR sky130_fd_sc_hd__fill_1
XFILLER_65_68 VGND VGND VPWR VPWR sky130_fd_sc_hd__decap_6
XFILLER_45_148 VGND VGND VPWR VPWR sky130_fd_sc_hd__fill_2
XFILLER_26_373 VGND VGND VPWR VPWR sky130_fd_sc_hd__decap_6
XFILLER_81_45 VGND VGND VPWR VPWR sky130_fd_sc_hd__decap_3
XFILLER_53_181 VGND VGND VPWR VPWR sky130_fd_sc_hd__decap_8
XFILLER_14_546 VGND VGND VPWR VPWR sky130_fd_sc_hd__decap_8
XFILLER_26_395 VGND VGND VPWR VPWR sky130_fd_sc_hd__fill_1
XTAP_TAPCELL_ROW_52_872 VGND VPWR sky130_fd_sc_hd__tapvpwrvgnd_1
XTAP_TAPCELL_ROW_24_541 VGND VPWR sky130_fd_sc_hd__tapvpwrvgnd_1
XTAP_TAPCELL_ROW_52_883 VGND VPWR sky130_fd_sc_hd__tapvpwrvgnd_1
XFILLER_41_387 VGND VGND VPWR VPWR sky130_fd_sc_hd__decap_4
Xrebuffer360 net874 VGND VGND VPWR VPWR net875 sky130_fd_sc_hd__dlygate4sd1_1
XFILLER_30_93 VGND VGND VPWR VPWR sky130_fd_sc_hd__fill_1
XFILLER_1_461 VPWR VGND VPWR VGND sky130_ef_sc_hd__decap_12
XFILLER_64_413 VGND VGND VPWR VPWR sky130_fd_sc_hd__decap_3
Xinput9 rst VGND VGND VPWR VPWR net9 sky130_fd_sc_hd__buf_2
XFILLER_36_159 VGND VGND VPWR VPWR sky130_fd_sc_hd__fill_1
XFILLER_17_373 VPWR VGND VPWR VGND sky130_ef_sc_hd__decap_12
XFILLER_32_321 VGND VGND VPWR VPWR sky130_fd_sc_hd__decap_6
XFILLER_44_170 VPWR VGND VPWR VGND sky130_ef_sc_hd__decap_12
X_4880_ _0580_ _0583_ _0623_ _0625_ VGND VGND VPWR VPWR _0627_ sky130_fd_sc_hd__a211o_1
XFILLER_20_505 VGND VGND VPWR VPWR sky130_fd_sc_hd__decap_6
XFILLER_32_365 VGND VGND VPWR VPWR sky130_fd_sc_hd__decap_4
X_6550_ _2066_ _2067_ VGND VGND VPWR VPWR _2068_ sky130_fd_sc_hd__nor2_1
XFILLER_9_561 VGND VGND VPWR VPWR sky130_fd_sc_hd__fill_1
X_5501_ _0813_ net246 VGND VGND VPWR VPWR _1211_ sky130_fd_sc_hd__nand2_1
X_6481_ net157 _2001_ VGND VGND VPWR VPWR _2002_ sky130_fd_sc_hd__xnor2_1
XFILLER_9_594 VGND VGND VPWR VPWR sky130_fd_sc_hd__fill_2
X_8220_ _3608_ VGND VGND VPWR VPWR _3609_ sky130_fd_sc_hd__inv_2
X_5432_ _1128_ _1130_ _1159_ VGND VGND VPWR VPWR _1161_ sky130_fd_sc_hd__or3_1
X_8151_ net462 net311 net308 net470 VGND VGND VPWR VPWR _3541_ sky130_fd_sc_hd__a22oi_1
X_5363_ _1008_ _1034_ _1033_ VGND VGND VPWR VPWR _1094_ sky130_fd_sc_hd__o21a_1
XFILLER_114_643 VGND VGND VPWR VPWR sky130_fd_sc_hd__fill_1
X_7102_ _2522_ _2565_ _2564_ VGND VGND VPWR VPWR _2568_ sky130_fd_sc_hd__and3_1
XFILLER_87_505 VPWR VGND VPWR VGND sky130_ef_sc_hd__decap_12
X_8082_ _3471_ _3472_ _3464_ VGND VGND VPWR VPWR _3474_ sky130_fd_sc_hd__a21o_1
X_5294_ _1026_ _1027_ VGND VGND VPWR VPWR _1028_ sky130_fd_sc_hd__nor2_1
XFILLER_101_337 VPWR VGND VPWR VGND sky130_ef_sc_hd__decap_12
X_7033_ net465 net330 VGND VGND VPWR VPWR _2500_ sky130_fd_sc_hd__nand2_1
XTAP_TAPCELL_ROW_87_1303 VGND VPWR sky130_fd_sc_hd__tapvpwrvgnd_1
X_8984_ clknet_leaf_27_clk _0096_ VGND VGND VPWR VPWR net33 sky130_fd_sc_hd__dfxtp_1
XFILLER_35_16 VGND VGND VPWR VPWR sky130_fd_sc_hd__fill_2
X_7935_ _3327_ _3328_ _3326_ VGND VGND VPWR VPWR _3330_ sky130_fd_sc_hd__a21o_1
XFILLER_70_416 VGND VGND VPWR VPWR sky130_fd_sc_hd__decap_4
X_7866_ net403 pe_array\[2\].u_pe.accum_reg\[3\] net219 _3263_ VGND VGND VPWR VPWR
+ _3264_ sky130_fd_sc_hd__o2bb2a_1
XFILLER_63_490 VGND VGND VPWR VPWR sky130_fd_sc_hd__decap_8
XFILLER_51_630 VGND VGND VPWR VPWR sky130_fd_sc_hd__fill_2
Xclkbuf_leaf_62_clk clknet_3_1__leaf_clk VGND VGND VPWR VPWR clknet_leaf_62_clk sky130_fd_sc_hd__clkbuf_8
X_6817_ net488 net335 net332 net494 VGND VGND VPWR VPWR _2289_ sky130_fd_sc_hd__a22oi_1
XFILLER_23_343 VGND VGND VPWR VPWR sky130_fd_sc_hd__fill_1
X_7797_ net15 _3206_ _3207_ net303 VGND VGND VPWR VPWR _0360_ sky130_fd_sc_hd__a22o_1
XFILLER_51_15 VPWR VGND VPWR VGND sky130_ef_sc_hd__decap_12
XTAP_TAPCELL_ROW_21_500 VGND VPWR sky130_fd_sc_hd__tapvpwrvgnd_1
XTAP_TAPCELL_ROW_21_511 VGND VPWR sky130_fd_sc_hd__tapvpwrvgnd_1
XFILLER_23_376 VPWR VGND VPWR VGND sky130_ef_sc_hd__decap_12
X_6748_ net494 net342 pe_array\[1\].u_pe.accum_reg\[2\] VGND VGND VPWR VPWR _2223_
+ sky130_fd_sc_hd__a21oi_1
XTAP_TAPCELL_ROW_98_1432 VGND VPWR sky130_fd_sc_hd__tapvpwrvgnd_1
X_6679_ _2191_ _2192_ VGND VGND VPWR VPWR _2193_ sky130_fd_sc_hd__xnor2_1
X_8418_ net263 _3798_ _3799_ VGND VGND VPWR VPWR _3801_ sky130_fd_sc_hd__or3_1
X_8349_ net684 _3732_ _3733_ VGND VGND VPWR VPWR _3734_ sky130_fd_sc_hd__nor3_1
XFILLER_2_214 VGND VGND VPWR VPWR sky130_fd_sc_hd__decap_8
XFILLER_104_131 VGND VGND VPWR VPWR sky130_fd_sc_hd__fill_1
XFILLER_116_41 VPWR VGND VPWR VGND sky130_ef_sc_hd__decap_12
XFILLER_105_687 VPWR VGND VPWR VGND sky130_ef_sc_hd__decap_12
XFILLER_116_85 VPWR VGND VPWR VGND sky130_ef_sc_hd__decap_12
XFILLER_104_197 VPWR VGND VPWR VGND sky130_ef_sc_hd__decap_12
XFILLER_58_251 VGND VGND VPWR VPWR sky130_fd_sc_hd__fill_1
XFILLER_18_115 VGND VGND VPWR VPWR sky130_fd_sc_hd__fill_2
XFILLER_19_638 VGND VGND VPWR VPWR sky130_fd_sc_hd__decap_3
XTAP_TAPCELL_ROW_29_600 VGND VPWR sky130_fd_sc_hd__tapvpwrvgnd_1
XFILLER_73_221 VGND VGND VPWR VPWR sky130_fd_sc_hd__decap_3
XTAP_TAPCELL_ROW_57_942 VGND VPWR sky130_fd_sc_hd__tapvpwrvgnd_1
XFILLER_18_137 VGND VGND VPWR VPWR sky130_fd_sc_hd__decap_3
XFILLER_61_416 VGND VGND VPWR VPWR sky130_fd_sc_hd__fill_2
XFILLER_27_671 VGND VGND VPWR VPWR sky130_fd_sc_hd__fill_1
XFILLER_92_55 VGND VGND VPWR VPWR sky130_fd_sc_hd__fill_2
XFILLER_61_449 VGND VGND VPWR VPWR sky130_fd_sc_hd__fill_1
Xclkbuf_leaf_53_clk clknet_3_0__leaf_clk VGND VGND VPWR VPWR clknet_leaf_53_clk sky130_fd_sc_hd__clkbuf_8
XFILLER_26_181 VGND VGND VPWR VPWR sky130_fd_sc_hd__fill_2
XFILLER_14_354 VGND VGND VPWR VPWR sky130_fd_sc_hd__decap_8
XFILLER_14_365 VPWR VGND VPWR VGND sky130_ef_sc_hd__decap_12
XFILLER_42_641 VGND VGND VPWR VPWR sky130_fd_sc_hd__decap_3
XFILLER_6_520 VGND VGND VPWR VPWR sky130_fd_sc_hd__fill_2
XFILLER_10_582 VGND VGND VPWR VPWR sky130_fd_sc_hd__fill_1
XFILLER_6_531 VGND VGND VPWR VPWR sky130_fd_sc_hd__fill_1
XFILLER_41_81 VGND VGND VPWR VPWR sky130_fd_sc_hd__fill_2
Xrebuffer190 net459 VGND VGND VPWR VPWR net705 sky130_fd_sc_hd__clkbuf_1
XTAP_TAPCELL_ROW_71_1104 VGND VPWR sky130_fd_sc_hd__tapvpwrvgnd_1
XFILLER_96_324 VPWR VGND VPWR VGND sky130_ef_sc_hd__decap_12
XFILLER_96_379 VGND VGND VPWR VPWR sky130_fd_sc_hd__decap_8
XPHY_EDGE_ROW_10_Right_10 VGND VGND VPWR VPWR sky130_fd_sc_hd__decap_3
XFILLER_2_53 VPWR VGND VPWR VGND sky130_ef_sc_hd__decap_12
XFILLER_49_273 VGND VGND VPWR VPWR sky130_fd_sc_hd__decap_6
XFILLER_49_284 VPWR VGND VPWR VGND sky130_ef_sc_hd__decap_12
XTAP_TAPCELL_ROW_69_1077 VGND VPWR sky130_fd_sc_hd__tapvpwrvgnd_1
X_5981_ _1514_ _1515_ VGND VGND VPWR VPWR _1516_ sky130_fd_sc_hd__xor2_1
X_7720_ _3164_ _3165_ VGND VGND VPWR VPWR _3166_ sky130_fd_sc_hd__xnor2_1
Xclkbuf_leaf_44_clk clknet_3_2__leaf_clk VGND VGND VPWR VPWR clknet_leaf_44_clk sky130_fd_sc_hd__clkbuf_8
X_4932_ _0635_ net834 _0634_ VGND VGND VPWR VPWR _0678_ sky130_fd_sc_hd__o21a_1
XTAP_TAPCELL_ROW_82_1233 VGND VPWR sky130_fd_sc_hd__tapvpwrvgnd_1
XTAP_TAPCELL_ROW_35_669 VGND VPWR sky130_fd_sc_hd__tapvpwrvgnd_1
X_7651_ _3063_ _3098_ VGND VGND VPWR VPWR _3100_ sky130_fd_sc_hd__nor2_1
X_6602_ _2118_ _2117_ VGND VGND VPWR VPWR _2119_ sky130_fd_sc_hd__and2b_1
X_4863_ net297 net436 pe_array\[3\].u_pe.accum_reg\[12\] VGND VGND VPWR VPWR _0610_
+ sky130_fd_sc_hd__a21oi_1
X_7582_ net156 _3032_ VGND VGND VPWR VPWR _3033_ sky130_fd_sc_hd__xnor2_1
X_4794_ _0496_ _0498_ net645 _0541_ VGND VGND VPWR VPWR _0543_ sky130_fd_sc_hd__o211ai_2
X_6533_ _2021_ _2023_ _2051_ VGND VGND VPWR VPWR _2052_ sky130_fd_sc_hd__o21a_1
X_9321_ clknet_leaf_11_clk _0433_ VGND VGND VPWR VPWR pe_accum\[2\]\[31\] sky130_fd_sc_hd__dfxtp_1
X_6464_ _1751_ _1838_ _1979_ _1984_ VGND VGND VPWR VPWR _1985_ sky130_fd_sc_hd__a31o_4
X_9252_ clknet_leaf_0_clk _0364_ VGND VGND VPWR VPWR pe_array\[3\].u_pe.weight_in\[6\]
+ sky130_fd_sc_hd__dfxtp_1
Xoutput110 net110 VGND VGND VPWR VPWR result_data[64] sky130_fd_sc_hd__buf_2
XFILLER_106_429 VPWR VGND VPWR VGND sky130_ef_sc_hd__decap_12
X_8203_ pe_array\[2\].u_pe.accum_reg\[12\] net439 net313 VGND VGND VPWR VPWR _3592_
+ sky130_fd_sc_hd__and3_4
X_5415_ net181 _1143_ VGND VGND VPWR VPWR _1145_ sky130_fd_sc_hd__xor2_1
Xoutput143 net143 VGND VGND VPWR VPWR result_data[94] sky130_fd_sc_hd__buf_2
X_6395_ _1863_ _1890_ _1891_ _1895_ VGND VGND VPWR VPWR _1919_ sky130_fd_sc_hd__o22a_1
Xoutput132 net132 VGND VGND VPWR VPWR result_data[84] sky130_fd_sc_hd__buf_2
Xoutput121 net121 VGND VGND VPWR VPWR result_data[74] sky130_fd_sc_hd__buf_2
X_9183_ clknet_leaf_39_clk _0295_ VGND VGND VPWR VPWR pe_array\[1\].u_pe.accum_reg\[1\]
+ sky130_fd_sc_hd__dfxtp_1
XFILLER_114_473 VGND VGND VPWR VPWR sky130_fd_sc_hd__decap_3
XFILLER_114_451 VGND VGND VPWR VPWR sky130_fd_sc_hd__decap_8
XFILLER_99_162 VGND VGND VPWR VPWR sky130_fd_sc_hd__fill_1
XTAP_TAPCELL_ROW_93_1373 VGND VPWR sky130_fd_sc_hd__tapvpwrvgnd_1
X_8134_ _3521_ _3523_ _3475_ _3477_ VGND VGND VPWR VPWR _3525_ sky130_fd_sc_hd__o211ai_2
XTAP_TAPCELL_ROW_7_339 VGND VPWR sky130_fd_sc_hd__tapvpwrvgnd_1
X_5346_ net748 _1076_ VGND VGND VPWR VPWR _1078_ sky130_fd_sc_hd__xnor2_1
XFILLER_114_495 VGND VGND VPWR VPWR sky130_fd_sc_hd__decap_8
XFILLER_99_195 VGND VGND VPWR VPWR sky130_fd_sc_hd__decap_8
X_8065_ _3456_ _3451_ VGND VGND VPWR VPWR _3457_ sky130_fd_sc_hd__and2b_1
X_5277_ net398 pe_array\[3\].u_pe.accum_reg\[24\] net256 _1011_ VGND VGND VPWR VPWR
+ _1012_ sky130_fd_sc_hd__o2bb2a_4
XFILLER_87_368 VGND VGND VPWR VPWR sky130_fd_sc_hd__decap_4
X_7016_ _2434_ _2483_ VGND VGND VPWR VPWR _2484_ sky130_fd_sc_hd__xnor2_1
XFILLER_101_167 VGND VGND VPWR VPWR sky130_fd_sc_hd__fill_1
XPHY_EDGE_ROW_106_Right_106 VGND VGND VPWR VPWR sky130_fd_sc_hd__decap_3
X_8967_ clknet_leaf_54_clk _0079_ VGND VGND VPWR VPWR pe_array\[1\].u_pe.weight_in\[2\]
+ sky130_fd_sc_hd__dfxtp_1
XFILLER_55_254 VGND VGND VPWR VPWR sky130_fd_sc_hd__decap_4
XTAP_TAPCELL_ROW_54_901 VGND VPWR sky130_fd_sc_hd__tapvpwrvgnd_1
XFILLER_16_608 VGND VGND VPWR VPWR sky130_fd_sc_hd__fill_1
X_7918_ _3254_ _3282_ _3281_ VGND VGND VPWR VPWR _3314_ sky130_fd_sc_hd__a21bo_1
XFILLER_15_129 VGND VGND VPWR VPWR sky130_fd_sc_hd__fill_1
Xclkbuf_leaf_35_clk clknet_3_6__leaf_clk VGND VGND VPWR VPWR clknet_leaf_35_clk sky130_fd_sc_hd__clkbuf_8
X_8898_ clknet_leaf_53_clk _0010_ VGND VGND VPWR VPWR pe_array\[3\].u_pe.tap_count\[2\]
+ sky130_fd_sc_hd__dfxtp_1
X_7849_ _3245_ _3246_ net504 net321 VGND VGND VPWR VPWR _3247_ sky130_fd_sc_hd__and4bb_1
XFILLER_23_173 VGND VGND VPWR VPWR sky130_fd_sc_hd__decap_4
XFILLER_24_685 VGND VGND VPWR VPWR sky130_fd_sc_hd__decap_3
XTAP_TAPCELL_ROW_102_1480 VGND VPWR sky130_fd_sc_hd__tapvpwrvgnd_1
XFILLER_109_278 VGND VGND VPWR VPWR sky130_fd_sc_hd__fill_2
XFILLER_11_51 VGND VGND VPWR VPWR sky130_fd_sc_hd__decap_4
XFILLER_105_473 VPWR VGND VPWR VGND sky130_ef_sc_hd__decap_12
XFILLER_87_44 VGND VGND VPWR VPWR sky130_fd_sc_hd__decap_4
XFILLER_78_324 VGND VGND VPWR VPWR sky130_fd_sc_hd__decap_3
XFILLER_78_346 VGND VGND VPWR VPWR sky130_fd_sc_hd__fill_1
XFILLER_66_508 VGND VGND VPWR VPWR sky130_fd_sc_hd__fill_1
Xfanout392 net393 VGND VGND VPWR VPWR net392 sky130_fd_sc_hd__clkbuf_2
Xclone127 _1568_ VGND VGND VPWR VPWR net642 sky130_fd_sc_hd__clkbuf_1
Xfanout381 net382 VGND VGND VPWR VPWR net381 sky130_fd_sc_hd__buf_1
Xfanout370 net396 VGND VGND VPWR VPWR net370 sky130_fd_sc_hd__clkbuf_4
Xclone138 net288 VGND VGND VPWR VPWR net653 sky130_fd_sc_hd__clkbuf_1
XFILLER_46_221 VGND VGND VPWR VPWR sky130_fd_sc_hd__fill_1
XTAP_TAPCELL_ROW_105_1509 VGND VPWR sky130_fd_sc_hd__tapvpwrvgnd_1
Xclkbuf_leaf_26_clk clknet_3_7__leaf_clk VGND VGND VPWR VPWR clknet_leaf_26_clk sky130_fd_sc_hd__clkbuf_8
XFILLER_30_611 VPWR VGND VPWR VGND sky130_ef_sc_hd__decap_12
XTAP_TAPCELL_ROW_32_639 VGND VPWR sky130_fd_sc_hd__tapvpwrvgnd_1
Xinput12 weight_addr[1] VGND VGND VPWR VPWR net12 sky130_fd_sc_hd__buf_2
XTAP_TAPCELL_ROW_12_396 VGND VPWR sky130_fd_sc_hd__tapvpwrvgnd_1
XTAP_TAPCELL_ROW_116_1649 VGND VPWR sky130_fd_sc_hd__tapvpwrvgnd_1
X_6180_ _1710_ VGND VGND VPWR VPWR _1711_ sky130_fd_sc_hd__inv_2
X_5200_ _0934_ _0935_ VGND VGND VPWR VPWR _0937_ sky130_fd_sc_hd__xor2_1
XFILLER_42_3 VPWR VGND VPWR VGND sky130_ef_sc_hd__decap_12
XFILLER_111_421 VGND VGND VPWR VPWR sky130_fd_sc_hd__decap_4
XFILLER_69_313 VPWR VGND VPWR VGND sky130_ef_sc_hd__decap_12
X_5131_ net397 pe_array\[3\].u_pe.accum_reg\[19\] net255 _0870_ VGND VGND VPWR VPWR
+ _0871_ sky130_fd_sc_hd__o2bb2a_4
X_5062_ net178 _0802_ _0803_ VGND VGND VPWR VPWR _0804_ sky130_fd_sc_hd__nand3_2
XFILLER_111_465 VGND VGND VPWR VPWR sky130_fd_sc_hd__fill_1
X_8821_ _4190_ _4179_ VGND VGND VPWR VPWR _4191_ sky130_fd_sc_hd__xnor2_2
XFILLER_25_405 VGND VGND VPWR VPWR sky130_fd_sc_hd__decap_3
XFILLER_37_265 VGND VGND VPWR VPWR sky130_fd_sc_hd__decap_4
XFILLER_37_276 VGND VGND VPWR VPWR sky130_fd_sc_hd__decap_4
X_8752_ net403 pe_array\[2\].u_pe.accum_reg\[28\] net220 _4124_ VGND VGND VPWR VPWR
+ _4125_ sky130_fd_sc_hd__o2bb2a_4
XFILLER_80_544 VGND VGND VPWR VPWR sky130_fd_sc_hd__fill_1
XFILLER_16_29 VGND VGND VPWR VPWR sky130_fd_sc_hd__fill_2
XFILLER_25_449 VPWR VGND VPWR VGND sky130_ef_sc_hd__decap_12
X_5964_ _1498_ _1497_ _1465_ VGND VGND VPWR VPWR _1500_ sky130_fd_sc_hd__a21o_1
Xclkbuf_leaf_17_clk clknet_3_4__leaf_clk VGND VGND VPWR VPWR clknet_leaf_17_clk sky130_fd_sc_hd__clkbuf_8
X_7703_ _2698_ _3149_ VGND VGND VPWR VPWR _3150_ sky130_fd_sc_hd__xnor2_1
X_8683_ _4030_ _4056_ VGND VGND VPWR VPWR _4058_ sky130_fd_sc_hd__xnor2_1
X_5895_ _1422_ _1430_ VGND VGND VPWR VPWR _1432_ sky130_fd_sc_hd__xnor2_1
X_4915_ net204 _0658_ _0660_ VGND VGND VPWR VPWR _0661_ sky130_fd_sc_hd__or3b_4
XFILLER_20_132 VGND VGND VPWR VPWR sky130_fd_sc_hd__fill_2
X_4846_ _0547_ _0552_ _0545_ VGND VGND VPWR VPWR _0594_ sky130_fd_sc_hd__a21oi_1
X_7634_ _3080_ _3081_ VGND VGND VPWR VPWR _3083_ sky130_fd_sc_hd__xnor2_1
X_7565_ net406 pe_array\[1\].u_pe.accum_reg\[25\] net229 _3016_ VGND VGND VPWR VPWR
+ _3017_ sky130_fd_sc_hd__o2bb2a_4
X_6516_ _2035_ VGND VGND VPWR VPWR _2036_ sky130_fd_sc_hd__inv_2
X_9304_ clknet_leaf_4_clk _0416_ VGND VGND VPWR VPWR pe_accum\[2\]\[14\] sky130_fd_sc_hd__dfxtp_1
X_4777_ _0522_ _0523_ net287 VGND VGND VPWR VPWR _0526_ sky130_fd_sc_hd__o21ai_1
XFILLER_4_309 VPWR VGND VPWR VGND sky130_ef_sc_hd__decap_12
X_7496_ net156 _2948_ VGND VGND VPWR VPWR _2950_ sky130_fd_sc_hd__xnor2_1
X_6447_ net171 _1968_ VGND VGND VPWR VPWR _1969_ sky130_fd_sc_hd__nand2_1
X_9235_ clknet_leaf_46_clk _0347_ VGND VGND VPWR VPWR pe_accum\[1\]\[21\] sky130_fd_sc_hd__dfxtp_1
X_6378_ _1898_ _1899_ net707 VGND VGND VPWR VPWR _1902_ sky130_fd_sc_hd__o21ai_1
X_9166_ clknet_leaf_26_clk _0278_ VGND VGND VPWR VPWR pe_accum\[0\]\[20\] sky130_fd_sc_hd__dfxtp_1
XFILLER_88_633 VGND VGND VPWR VPWR sky130_fd_sc_hd__fill_2
X_8117_ net442 net318 VGND VGND VPWR VPWR _3508_ sky130_fd_sc_hd__and2_2
X_5329_ _1035_ _1033_ _1060_ VGND VGND VPWR VPWR _1062_ sky130_fd_sc_hd__and3_1
XFILLER_114_292 VPWR VGND VPWR VGND sky130_ef_sc_hd__decap_12
X_9097_ clknet_leaf_60_clk _0209_ VGND VGND VPWR VPWR net48 sky130_fd_sc_hd__dfxtp_1
X_8048_ _3438_ _3439_ _3405_ VGND VGND VPWR VPWR _3441_ sky130_fd_sc_hd__o21a_1
XFILLER_57_69 VPWR VGND VPWR VGND sky130_ef_sc_hd__decap_12
XFILLER_56_541 VGND VGND VPWR VPWR sky130_fd_sc_hd__decap_3
XFILLER_56_530 VGND VGND VPWR VPWR sky130_fd_sc_hd__fill_2
XFILLER_28_210 VPWR VGND VPWR VGND sky130_ef_sc_hd__decap_12
XFILLER_28_265 VPWR VGND VPWR VGND sky130_ef_sc_hd__decap_12
XFILLER_83_393 VGND VGND VPWR VPWR sky130_fd_sc_hd__fill_2
XFILLER_31_408 VGND VGND VPWR VPWR sky130_fd_sc_hd__fill_2
XFILLER_43_279 VGND VGND VPWR VPWR sky130_fd_sc_hd__fill_1
XFILLER_7_158 VGND VGND VPWR VPWR sky130_fd_sc_hd__decap_8
XFILLER_105_281 VPWR VGND VPWR VGND sky130_ef_sc_hd__decap_12
XFILLER_93_113 VGND VGND VPWR VPWR sky130_fd_sc_hd__fill_2
XFILLER_78_176 VGND VGND VPWR VPWR sky130_fd_sc_hd__decap_6
XFILLER_19_221 VGND VGND VPWR VPWR sky130_fd_sc_hd__decap_3
XFILLER_19_232 VPWR VGND VPWR VGND sky130_ef_sc_hd__decap_12
XFILLER_19_254 VPWR VGND VPWR VGND sky130_ef_sc_hd__decap_12
XFILLER_19_276 VGND VGND VPWR VPWR sky130_fd_sc_hd__decap_4
XTAP_TAPCELL_ROW_66_1047 VGND VPWR sky130_fd_sc_hd__tapvpwrvgnd_1
XTAP_TAPCELL_ROW_17_455 VGND VPWR sky130_fd_sc_hd__tapvpwrvgnd_1
XFILLER_22_419 VGND VGND VPWR VPWR sky130_fd_sc_hd__fill_1
XTAP_TAPCELL_ROW_45_797 VGND VPWR sky130_fd_sc_hd__tapvpwrvgnd_1
XFILLER_63_90 VPWR VGND VPWR VGND sky130_ef_sc_hd__decap_12
X_5680_ net18 _1230_ _1231_ net310 VGND VGND VPWR VPWR _0219_ sky130_fd_sc_hd__a22o_1
X_4700_ _0448_ _0449_ _0450_ VGND VGND VPWR VPWR _0451_ sky130_fd_sc_hd__nand3_2
XFILLER_8_41 VPWR VGND VPWR VGND sky130_ef_sc_hd__decap_12
XFILLER_30_474 VGND VGND VPWR VPWR sky130_fd_sc_hd__fill_2
X_4631_ net492 net483 net294 net292 VGND VGND VPWR VPWR _4393_ sky130_fd_sc_hd__and4_1
X_7350_ _2806_ _2807_ _2808_ VGND VGND VPWR VPWR _2809_ sky130_fd_sc_hd__nand3_1
X_4562_ _4323_ _4324_ VGND VGND VPWR VPWR _4326_ sky130_fd_sc_hd__xnor2_1
X_6301_ _1825_ _1824_ _1826_ VGND VGND VPWR VPWR _1828_ sky130_fd_sc_hd__a21o_1
X_7281_ _2740_ _2739_ _2741_ VGND VGND VPWR VPWR _2742_ sky130_fd_sc_hd__and3_1
X_4493_ net507 _4227_ net258 _4260_ VGND VGND VPWR VPWR _4261_ sky130_fd_sc_hd__o22a_1
X_6232_ _1758_ _1759_ net201 VGND VGND VPWR VPWR _1761_ sky130_fd_sc_hd__a21o_1
XTAP_TAPCELL_ROW_77_1176 VGND VPWR sky130_fd_sc_hd__tapvpwrvgnd_1
X_9020_ clknet_leaf_50_clk _0132_ VGND VGND VPWR VPWR net90 sky130_fd_sc_hd__dfxtp_1
XTAP_TAPCELL_ROW_90_1332 VGND VPWR sky130_fd_sc_hd__tapvpwrvgnd_1
X_6163_ net642 _1691_ _1693_ VGND VGND VPWR VPWR _1694_ sky130_fd_sc_hd__or3b_1
X_6094_ _1626_ VGND VGND VPWR VPWR _1627_ sky130_fd_sc_hd__inv_2
X_5114_ _0822_ net205 _0820_ VGND VGND VPWR VPWR _0854_ sky130_fd_sc_hd__a21o_1
XFILLER_111_284 VPWR VGND VPWR VGND sky130_ef_sc_hd__decap_12
X_5045_ net295 net433 pe_array\[3\].u_pe.accum_reg\[17\] VGND VGND VPWR VPWR _0787_
+ sky130_fd_sc_hd__a21oi_1
XFILLER_38_585 VGND VGND VPWR VPWR sky130_fd_sc_hd__decap_3
X_8804_ _4148_ _4174_ VGND VGND VPWR VPWR _4175_ sky130_fd_sc_hd__xor2_1
X_6996_ _2460_ _2461_ net551 VGND VGND VPWR VPWR _2464_ sky130_fd_sc_hd__o21ai_1
X_8735_ _4106_ _4107_ VGND VGND VPWR VPWR _4108_ sky130_fd_sc_hd__and2_1
XFILLER_80_363 VGND VGND VPWR VPWR sky130_fd_sc_hd__fill_1
X_5947_ pe_array\[0\].u_pe.accum_reg\[9\] net644 net358 VGND VGND VPWR VPWR _1483_
+ sky130_fd_sc_hd__and3_4
XFILLER_43_27 VPWR VGND VPWR VGND sky130_ef_sc_hd__decap_12
X_8666_ net264 _4040_ VGND VGND VPWR VPWR _4041_ sky130_fd_sc_hd__xnor2_1
X_5878_ _1414_ _1415_ VGND VGND VPWR VPWR _1416_ sky130_fd_sc_hd__nor2_1
X_7617_ _3039_ _3037_ VGND VGND VPWR VPWR _3067_ sky130_fd_sc_hd__nor2_2
X_8597_ net402 pe_array\[2\].u_pe.accum_reg\[23\] net218 _3974_ VGND VGND VPWR VPWR
+ _3975_ sky130_fd_sc_hd__o2bb2a_4
X_4829_ net204 _0574_ _0576_ VGND VGND VPWR VPWR _0577_ sky130_fd_sc_hd__or3b_4
XFILLER_5_629 VPWR VGND VPWR VGND sky130_ef_sc_hd__decap_12
X_7548_ net197 _2971_ _2970_ VGND VGND VPWR VPWR _3000_ sky130_fd_sc_hd__a21o_1
X_7479_ pe_array\[1\].u_pe.accum_reg\[23\] net448 net339 VGND VGND VPWR VPWR _2933_
+ sky130_fd_sc_hd__and3_1
XFILLER_108_53 VPWR VGND VPWR VGND sky130_ef_sc_hd__decap_12
X_9218_ clknet_leaf_39_clk _0330_ VGND VGND VPWR VPWR pe_accum\[1\]\[4\] sky130_fd_sc_hd__dfxtp_1
XFILLER_0_301 VGND VGND VPWR VPWR sky130_fd_sc_hd__decap_6
X_9149_ clknet_leaf_22_clk _0261_ VGND VGND VPWR VPWR pe_accum\[0\]\[3\] sky130_fd_sc_hd__dfxtp_1
XFILLER_88_441 VGND VGND VPWR VPWR sky130_fd_sc_hd__fill_2
XFILLER_68_46 VGND VGND VPWR VPWR sky130_fd_sc_hd__fill_1
XFILLER_76_614 VPWR VGND VPWR VGND sky130_ef_sc_hd__decap_12
XFILLER_48_316 VGND VGND VPWR VPWR sky130_fd_sc_hd__decap_4
XFILLER_102_273 VGND VGND VPWR VPWR sky130_fd_sc_hd__decap_8
XFILLER_75_113 VPWR VGND VPWR VGND sky130_ef_sc_hd__decap_12
XFILLER_91_617 VPWR VGND VPWR VGND sky130_ef_sc_hd__decap_12
XFILLER_84_56 VGND VGND VPWR VPWR sky130_fd_sc_hd__fill_1
XFILLER_91_639 VGND VGND VPWR VPWR sky130_fd_sc_hd__decap_8
XFILLER_29_585 VGND VGND VPWR VPWR sky130_fd_sc_hd__decap_8
XFILLER_44_533 VGND VGND VPWR VPWR sky130_fd_sc_hd__decap_8
XFILLER_56_393 VGND VGND VPWR VPWR sky130_fd_sc_hd__fill_1
XTAP_TAPCELL_ROW_14_425 VGND VPWR sky130_fd_sc_hd__tapvpwrvgnd_1
XTAP_TAPCELL_ROW_42_756 VGND VPWR sky130_fd_sc_hd__tapvpwrvgnd_1
XFILLER_8_445 VPWR VGND VPWR VGND sky130_ef_sc_hd__decap_12
XFILLER_33_93 VGND VGND VPWR VPWR sky130_fd_sc_hd__decap_3
XFILLER_8_489 VGND VGND VPWR VPWR sky130_fd_sc_hd__decap_4
XTAP_TAPCELL_ROW_113_1608 VGND VPWR sky130_fd_sc_hd__tapvpwrvgnd_1
XFILLER_98_227 VPWR VGND VPWR VGND sky130_ef_sc_hd__decap_12
XFILLER_79_441 VGND VGND VPWR VPWR sky130_fd_sc_hd__decap_6
XFILLER_3_194 VGND VGND VPWR VPWR sky130_fd_sc_hd__decap_3
XFILLER_66_102 VGND VGND VPWR VPWR sky130_fd_sc_hd__fill_1
XFILLER_94_499 VGND VGND VPWR VPWR sky130_fd_sc_hd__fill_2
XFILLER_81_105 VGND VGND VPWR VPWR sky130_fd_sc_hd__fill_1
X_6850_ _2318_ _2320_ VGND VGND VPWR VPWR _2321_ sky130_fd_sc_hd__nand2_1
XFILLER_47_393 VGND VGND VPWR VPWR sky130_fd_sc_hd__decap_8
X_5801_ _1306_ _1339_ VGND VGND VPWR VPWR _1341_ sky130_fd_sc_hd__xnor2_1
X_6781_ _2234_ _2252_ VGND VGND VPWR VPWR _2255_ sky130_fd_sc_hd__nor2_1
XPHY_EDGE_ROW_8_Right_8 VGND VGND VPWR VPWR sky130_fd_sc_hd__decap_3
X_8520_ _3897_ _3898_ _3899_ VGND VGND VPWR VPWR _3900_ sky130_fd_sc_hd__and3_1
X_5732_ _1271_ _1272_ _1254_ _1255_ VGND VGND VPWR VPWR _1274_ sky130_fd_sc_hd__a211o_1
XFILLER_22_249 VGND VGND VPWR VPWR sky130_fd_sc_hd__decap_3
X_8451_ _3799_ _3800_ _3830_ _3831_ VGND VGND VPWR VPWR _3833_ sky130_fd_sc_hd__o211ai_1
XTAP_TAPCELL_ROW_79_1205 VGND VPWR sky130_fd_sc_hd__tapvpwrvgnd_1
X_5663_ net957 net364 VGND VGND VPWR VPWR _0204_ sky130_fd_sc_hd__and2_1
X_8382_ _3620_ _3765_ _3766_ VGND VGND VPWR VPWR _3767_ sky130_fd_sc_hd__o21a_4
X_7402_ net528 _2858_ VGND VGND VPWR VPWR _2859_ sky130_fd_sc_hd__xnor2_1
X_5594_ net979 net373 VGND VGND VPWR VPWR _0135_ sky130_fd_sc_hd__and2_1
X_4614_ _4374_ _4375_ _4376_ VGND VGND VPWR VPWR _4377_ sky130_fd_sc_hd__nand3_2
Xhold401 pe_accum\[2\]\[24\] VGND VGND VPWR VPWR net916 sky130_fd_sc_hd__dlygate4sd3_1
X_7333_ net425 _2792_ VGND VGND VPWR VPWR _0311_ sky130_fd_sc_hd__nor2_1
X_4545_ _4302_ _4308_ _4309_ VGND VGND VPWR VPWR _4310_ sky130_fd_sc_hd__nand3_1
Xhold412 pe_accum\[3\]\[5\] VGND VGND VPWR VPWR net927 sky130_fd_sc_hd__dlygate4sd3_1
Xhold434 pe_accum\[1\]\[18\] VGND VGND VPWR VPWR net949 sky130_fd_sc_hd__dlygate4sd3_1
Xhold445 pe_accum\[1\]\[22\] VGND VGND VPWR VPWR net960 sky130_fd_sc_hd__dlygate4sd3_1
Xhold423 pe_accum\[1\]\[12\] VGND VGND VPWR VPWR net938 sky130_fd_sc_hd__dlygate4sd3_1
Xmax_cap153 _0637_ VGND VGND VPWR VPWR net153 sky130_fd_sc_hd__clkbuf_1
X_9003_ clknet_leaf_22_clk _0115_ VGND VGND VPWR VPWR net71 sky130_fd_sc_hd__dfxtp_1
Xhold478 pe_accum\[3\]\[4\] VGND VGND VPWR VPWR net993 sky130_fd_sc_hd__dlygate4sd3_1
Xhold467 pe_accum\[3\]\[24\] VGND VGND VPWR VPWR net982 sky130_fd_sc_hd__dlygate4sd3_1
Xhold456 pe_accum\[3\]\[19\] VGND VGND VPWR VPWR net971 sky130_fd_sc_hd__dlygate4sd3_1
XFILLER_1_109 VGND VGND VPWR VPWR sky130_fd_sc_hd__decap_3
X_7264_ _2687_ _2723_ _2724_ VGND VGND VPWR VPWR _2726_ sky130_fd_sc_hd__and3_1
X_4476_ pe_array\[3\].u_pe.tap_count\[2\] _4246_ VGND VGND VPWR VPWR _4247_ sky130_fd_sc_hd__and2_1
Xhold489 pe_accum\[2\]\[0\] VGND VGND VPWR VPWR net1004 sky130_fd_sc_hd__dlygate4sd3_1
X_6215_ net412 pe_array\[0\].u_pe.accum_reg\[15\] net240 _1744_ VGND VGND VPWR VPWR
+ _1745_ sky130_fd_sc_hd__o2bb2a_1
X_7195_ net427 _2658_ VGND VGND VPWR VPWR _0307_ sky130_fd_sc_hd__nor2_1
XPHY_EDGE_ROW_39_Right_39 VGND VGND VPWR VPWR sky130_fd_sc_hd__decap_3
X_6146_ net430 _1677_ VGND VGND VPWR VPWR _0239_ sky130_fd_sc_hd__nor2_1
XFILLER_97_293 VGND VGND VPWR VPWR sky130_fd_sc_hd__decap_6
XFILLER_97_271 VGND VGND VPWR VPWR sky130_fd_sc_hd__decap_8
XFILLER_85_422 VGND VGND VPWR VPWR sky130_fd_sc_hd__decap_8
XFILLER_57_113 VGND VGND VPWR VPWR sky130_fd_sc_hd__fill_2
X_6077_ pe_array\[0\].u_pe.accum_reg\[12\] net458 net361 VGND VGND VPWR VPWR _1610_
+ sky130_fd_sc_hd__and3_1
XFILLER_58_669 VPWR VGND VPWR VGND sky130_ef_sc_hd__decap_12
XFILLER_72_116 VPWR VGND VPWR VGND sky130_ef_sc_hd__decap_12
X_5028_ _0768_ _0769_ _0770_ VGND VGND VPWR VPWR _0771_ sky130_fd_sc_hd__and3_1
XFILLER_26_533 VPWR VGND VPWR VGND sky130_ef_sc_hd__decap_12
XFILLER_13_249 VGND VGND VPWR VPWR sky130_fd_sc_hd__decap_8
X_6979_ net479 net328 net326 net487 VGND VGND VPWR VPWR _2447_ sky130_fd_sc_hd__a22oi_1
XPHY_EDGE_ROW_48_Right_48 VGND VGND VPWR VPWR sky130_fd_sc_hd__decap_3
XFILLER_110_65 VPWR VGND VPWR VGND sky130_ef_sc_hd__decap_12
X_8718_ _4007_ _4033_ VGND VGND VPWR VPWR _4091_ sky130_fd_sc_hd__or2_1
X_8649_ _3994_ _3996_ _4024_ VGND VGND VPWR VPWR _4025_ sky130_fd_sc_hd__o21a_1
XFILLER_70_69 VGND VGND VPWR VPWR sky130_fd_sc_hd__decap_3
XPHY_EDGE_ROW_57_Right_57 VGND VGND VPWR VPWR sky130_fd_sc_hd__decap_3
XFILLER_76_400 VGND VGND VPWR VPWR sky130_fd_sc_hd__decap_8
XFILLER_1_665 VGND VGND VPWR VPWR sky130_fd_sc_hd__decap_6
XFILLER_95_66 VGND VGND VPWR VPWR sky130_fd_sc_hd__fill_1
XFILLER_0_197 VGND VGND VPWR VPWR sky130_fd_sc_hd__fill_2
XFILLER_48_157 VGND VGND VPWR VPWR sky130_fd_sc_hd__fill_1
XFILLER_49_669 VGND VGND VPWR VPWR sky130_fd_sc_hd__decap_3
XTAP_TAPCELL_ROW_47_815 VGND VPWR sky130_fd_sc_hd__tapvpwrvgnd_1
XFILLER_29_393 VPWR VGND VPWR VGND sky130_ef_sc_hd__decap_12
XFILLER_44_330 VGND VGND VPWR VPWR sky130_fd_sc_hd__decap_3
XPHY_EDGE_ROW_66_Right_66 VGND VGND VPWR VPWR sky130_fd_sc_hd__decap_3
XTAP_TAPCELL_ROW_63_1006 VGND VPWR sky130_fd_sc_hd__tapvpwrvgnd_1
XFILLER_44_363 VGND VGND VPWR VPWR sky130_fd_sc_hd__fill_1
XTAP_TAPCELL_ROW_27_572 VGND VPWR sky130_fd_sc_hd__tapvpwrvgnd_1
XTAP_TAPCELL_ROW_27_583 VGND VPWR sky130_fd_sc_hd__tapvpwrvgnd_1
XFILLER_32_569 VPWR VGND VPWR VGND sky130_ef_sc_hd__decap_12
XFILLER_8_253 VGND VGND VPWR VPWR sky130_fd_sc_hd__decap_4
XPHY_EDGE_ROW_75_Right_75 VGND VGND VPWR VPWR sky130_fd_sc_hd__decap_3
XFILLER_99_536 VGND VGND VPWR VPWR sky130_fd_sc_hd__decap_8
XTAP_TAPCELL_ROW_74_1146 VGND VPWR sky130_fd_sc_hd__tapvpwrvgnd_1
XFILLER_113_357 VGND VGND VPWR VPWR sky130_fd_sc_hd__fill_2
XFILLER_4_481 VGND VGND VPWR VPWR sky130_fd_sc_hd__fill_1
X_6000_ _1481_ _1488_ _1487_ VGND VGND VPWR VPWR _1535_ sky130_fd_sc_hd__a21bo_1
XFILLER_79_271 VGND VGND VPWR VPWR sky130_fd_sc_hd__decap_3
XFILLER_39_113 VGND VGND VPWR VPWR sky130_fd_sc_hd__fill_1
XFILLER_67_466 VGND VGND VPWR VPWR sky130_fd_sc_hd__fill_1
XFILLER_67_455 VGND VGND VPWR VPWR sky130_fd_sc_hd__fill_1
XFILLER_55_617 VPWR VGND VPWR VGND sky130_ef_sc_hd__decap_12
XFILLER_94_263 VPWR VGND VPWR VGND sky130_ef_sc_hd__decap_12
XPHY_EDGE_ROW_84_Right_84 VGND VGND VPWR VPWR sky130_fd_sc_hd__decap_3
X_7951_ net512 net506 net310 net309 VGND VGND VPWR VPWR _3346_ sky130_fd_sc_hd__and4_1
X_7882_ _3272_ _3278_ VGND VGND VPWR VPWR _3279_ sky130_fd_sc_hd__xnor2_2
XFILLER_54_138 VGND VGND VPWR VPWR sky130_fd_sc_hd__fill_2
X_6902_ _2330_ _2331_ _2332_ VGND VGND VPWR VPWR _2372_ sky130_fd_sc_hd__o21bai_1
XTAP_TAPCELL_ROW_85_1275 VGND VPWR sky130_fd_sc_hd__tapvpwrvgnd_1
XFILLER_63_683 VGND VGND VPWR VPWR sky130_fd_sc_hd__fill_1
X_6833_ _2304_ _2302_ _2286_ VGND VGND VPWR VPWR _2305_ sky130_fd_sc_hd__and3_1
XFILLER_24_29 VGND VGND VPWR VPWR sky130_fd_sc_hd__decap_3
XFILLER_35_385 VGND VGND VPWR VPWR sky130_fd_sc_hd__decap_6
X_6764_ net489 net343 pe_array\[1\].u_pe.accum_reg\[3\] VGND VGND VPWR VPWR _2238_
+ sky130_fd_sc_hd__a21oi_1
X_6695_ net959 net234 _1418_ net242 VGND VGND VPWR VPWR _0265_ sky130_fd_sc_hd__o2bb2ai_1
X_5715_ _1246_ _1247_ VGND VGND VPWR VPWR _1258_ sky130_fd_sc_hd__nor2_1
X_8503_ _3620_ _3765_ _3766_ _3883_ VGND VGND VPWR VPWR _3884_ sky130_fd_sc_hd__o211a_4
X_8434_ _3814_ _3815_ net160 VGND VGND VPWR VPWR _3817_ sky130_fd_sc_hd__a21o_1
X_5646_ net927 net367 VGND VGND VPWR VPWR _0187_ sky130_fd_sc_hd__and2_1
XPHY_EDGE_ROW_93_Right_93 VGND VGND VPWR VPWR sky130_fd_sc_hd__decap_3
XFILLER_117_641 VGND VGND VPWR VPWR sky130_fd_sc_hd__decap_3
X_8365_ net160 _3748_ _3749_ VGND VGND VPWR VPWR _3750_ sky130_fd_sc_hd__nand3_1
X_5577_ net1009 net390 VGND VGND VPWR VPWR _0118_ sky130_fd_sc_hd__and2_1
XFILLER_117_685 VPWR VGND VPWR VGND sky130_ef_sc_hd__decap_12
X_8296_ _3679_ _3680_ _3681_ VGND VGND VPWR VPWR _3683_ sky130_fd_sc_hd__a21o_1
X_7316_ _2773_ _2774_ net195 VGND VGND VPWR VPWR _2776_ sky130_fd_sc_hd__a21o_1
X_4528_ _4291_ _4292_ _4270_ VGND VGND VPWR VPWR _4294_ sky130_fd_sc_hd__a21oi_1
XFILLER_104_346 VPWR VGND VPWR VGND sky130_ef_sc_hd__decap_12
X_4459_ net12 _4239_ VGND VGND VPWR VPWR _4240_ sky130_fd_sc_hd__nor2_2
X_7247_ _2705_ _2706_ _2668_ _2669_ VGND VGND VPWR VPWR _2709_ sky130_fd_sc_hd__a211o_1
XFILLER_49_15 VPWR VGND VPWR VGND sky130_ef_sc_hd__decap_12
XFILLER_58_433 VPWR VGND VPWR VGND sky130_ef_sc_hd__decap_12
X_7178_ _2639_ _2640_ _2641_ VGND VGND VPWR VPWR _2642_ sky130_fd_sc_hd__nand3_1
XFILLER_85_252 VPWR VGND VPWR VGND sky130_ef_sc_hd__decap_12
X_6129_ _1658_ _1657_ _1659_ VGND VGND VPWR VPWR _1661_ sky130_fd_sc_hd__a21o_1
XFILLER_58_477 VPWR VGND VPWR VGND sky130_ef_sc_hd__decap_12
XFILLER_45_116 VPWR VGND VPWR VGND sky130_ef_sc_hd__decap_12
XFILLER_85_296 VGND VGND VPWR VPWR sky130_fd_sc_hd__fill_1
XFILLER_73_469 VGND VGND VPWR VPWR sky130_fd_sc_hd__fill_1
XFILLER_26_363 VGND VGND VPWR VPWR sky130_fd_sc_hd__fill_1
XFILLER_81_491 VPWR VGND VPWR VGND sky130_ef_sc_hd__decap_12
XFILLER_81_24 VGND VGND VPWR VPWR sky130_fd_sc_hd__fill_2
XFILLER_14_525 VGND VGND VPWR VPWR sky130_fd_sc_hd__decap_6
XTAP_TAPCELL_ROW_24_542 VGND VPWR sky130_fd_sc_hd__tapvpwrvgnd_1
XTAP_TAPCELL_ROW_52_873 VGND VPWR sky130_fd_sc_hd__tapvpwrvgnd_1
XFILLER_107_162 VGND VGND VPWR VPWR sky130_fd_sc_hd__fill_2
XFILLER_5_289 VGND VGND VPWR VPWR sky130_fd_sc_hd__decap_4
XFILLER_30_83 VGND VGND VPWR VPWR sky130_fd_sc_hd__fill_1
XFILLER_68_219 VPWR VGND VPWR VGND sky130_ef_sc_hd__decap_12
XFILLER_1_473 VPWR VGND VPWR VGND sky130_ef_sc_hd__decap_12
XFILLER_37_606 VGND VGND VPWR VPWR sky130_fd_sc_hd__decap_8
XFILLER_91_211 VGND VGND VPWR VPWR sky130_fd_sc_hd__decap_3
XFILLER_37_617 VGND VGND VPWR VPWR sky130_fd_sc_hd__decap_3
XFILLER_91_233 VGND VGND VPWR VPWR sky130_fd_sc_hd__decap_3
XFILLER_52_609 VGND VGND VPWR VPWR sky130_fd_sc_hd__decap_6
XFILLER_45_661 VGND VGND VPWR VPWR sky130_fd_sc_hd__fill_2
XFILLER_60_620 VPWR VGND VPWR VGND sky130_ef_sc_hd__decap_12
XFILLER_17_385 VGND VGND VPWR VPWR sky130_fd_sc_hd__decap_6
XFILLER_44_182 VGND VGND VPWR VPWR sky130_fd_sc_hd__decap_8
X_5500_ net905 net249 _1210_ net369 VGND VGND VPWR VPWR _0060_ sky130_fd_sc_hd__o211a_1
X_6480_ _1999_ _2000_ VGND VGND VPWR VPWR _2001_ sky130_fd_sc_hd__nor2_1
XFILLER_9_584 VGND VGND VPWR VPWR sky130_fd_sc_hd__fill_1
X_5431_ _1128_ _1130_ _1159_ VGND VGND VPWR VPWR _1160_ sky130_fd_sc_hd__o21ai_1
X_8150_ net470 net462 net311 net308 VGND VGND VPWR VPWR _3540_ sky130_fd_sc_hd__and4_1
X_5362_ _0985_ _0981_ _1091_ _1092_ VGND VGND VPWR VPWR _1093_ sky130_fd_sc_hd__a211o_4
XFILLER_113_110 VGND VGND VPWR VPWR sky130_fd_sc_hd__fill_2
X_8081_ _3464_ _3471_ _3472_ VGND VGND VPWR VPWR _3473_ sky130_fd_sc_hd__nand3_1
X_7101_ _2564_ net537 _2522_ VGND VGND VPWR VPWR _2567_ sky130_fd_sc_hd__a21oi_2
X_5293_ _0997_ _0999_ _1025_ VGND VGND VPWR VPWR _1027_ sky130_fd_sc_hd__nor3_1
X_7032_ _2455_ _2498_ VGND VGND VPWR VPWR _2499_ sky130_fd_sc_hd__and2b_2
XFILLER_114_699 VGND VGND VPWR VPWR sky130_fd_sc_hd__fill_1
XFILLER_101_316 VPWR VGND VPWR VGND sky130_ef_sc_hd__decap_12
XFILLER_87_539 VGND VGND VPWR VPWR sky130_fd_sc_hd__fill_1
XFILLER_101_349 VGND VGND VPWR VPWR sky130_fd_sc_hd__decap_8
XFILLER_95_572 VGND VGND VPWR VPWR sky130_fd_sc_hd__fill_1
X_8983_ clknet_leaf_23_clk _0095_ VGND VGND VPWR VPWR net149 sky130_fd_sc_hd__dfxtp_1
X_7934_ _3326_ _3327_ _3328_ VGND VGND VPWR VPWR _3329_ sky130_fd_sc_hd__nand3_1
X_7865_ _3261_ _3262_ VGND VGND VPWR VPWR _3263_ sky130_fd_sc_hd__nand2_1
X_6816_ net494 net488 net334 net332 VGND VGND VPWR VPWR _2288_ sky130_fd_sc_hd__and4_1
X_7796_ net14 _3206_ _3207_ net304 VGND VGND VPWR VPWR _0359_ sky130_fd_sc_hd__a22o_1
X_6747_ net430 _2222_ VGND VGND VPWR VPWR _0295_ sky130_fd_sc_hd__nor2_1
XFILLER_51_27 VPWR VGND VPWR VGND sky130_ef_sc_hd__decap_12
XTAP_TAPCELL_ROW_21_501 VGND VPWR sky130_fd_sc_hd__tapvpwrvgnd_1
XFILLER_23_388 VGND VGND VPWR VPWR sky130_fd_sc_hd__decap_4
XTAP_TAPCELL_ROW_98_1433 VGND VPWR sky130_fd_sc_hd__tapvpwrvgnd_1
X_6678_ _2165_ _2166_ net642 VGND VGND VPWR VPWR _2192_ sky130_fd_sc_hd__mux2_1
XFILLER_109_449 VPWR VGND VPWR VGND sky130_ef_sc_hd__decap_12
X_5629_ net925 net383 VGND VGND VPWR VPWR _0170_ sky130_fd_sc_hd__and2_1
X_8417_ net263 _3798_ _3799_ VGND VGND VPWR VPWR _3800_ sky130_fd_sc_hd__nor3_1
X_8348_ net679 net314 pe_array\[2\].u_pe.accum_reg\[16\] VGND VGND VPWR VPWR _3733_
+ sky130_fd_sc_hd__a21oi_1
XFILLER_104_110 VGND VGND VPWR VPWR sky130_fd_sc_hd__fill_1
X_8279_ _3625_ _3665_ VGND VGND VPWR VPWR _3666_ sky130_fd_sc_hd__nand2_1
XFILLER_116_53 VPWR VGND VPWR VGND sky130_ef_sc_hd__decap_12
XFILLER_105_699 VGND VGND VPWR VPWR sky130_fd_sc_hd__fill_1
XFILLER_116_97 VPWR VGND VPWR VGND sky130_ef_sc_hd__decap_12
XFILLER_76_35 VGND VGND VPWR VPWR sky130_fd_sc_hd__fill_1
XFILLER_19_617 VGND VGND VPWR VPWR sky130_fd_sc_hd__decap_4
XTAP_TAPCELL_ROW_29_601 VGND VPWR sky130_fd_sc_hd__tapvpwrvgnd_1
XTAP_TAPCELL_ROW_57_943 VGND VPWR sky130_fd_sc_hd__tapvpwrvgnd_1
XTAP_TAPCELL_ROW_57_932 VGND VPWR sky130_fd_sc_hd__tapvpwrvgnd_1
XFILLER_18_149 VGND VGND VPWR VPWR sky130_fd_sc_hd__fill_1
XTAP_TAPCELL_ROW_107_1540 VGND VPWR sky130_fd_sc_hd__tapvpwrvgnd_1
XTAP_TAPCELL_ROW_1_270 VGND VPWR sky130_fd_sc_hd__tapvpwrvgnd_1
XFILLER_92_67 VGND VGND VPWR VPWR sky130_fd_sc_hd__decap_6
Xrebuffer90 _1413_ VGND VGND VPWR VPWR net605 sky130_fd_sc_hd__buf_2
XFILLER_26_193 VGND VGND VPWR VPWR sky130_fd_sc_hd__decap_3
XFILLER_14_377 VPWR VGND VPWR VGND sky130_ef_sc_hd__decap_12
XFILLER_41_93 VGND VGND VPWR VPWR sky130_fd_sc_hd__fill_1
XTAP_TAPCELL_ROW_71_1105 VGND VPWR sky130_fd_sc_hd__tapvpwrvgnd_1
XFILLER_96_336 VPWR VGND VPWR VGND sky130_ef_sc_hd__decap_12
XFILLER_1_281 VGND VGND VPWR VPWR sky130_fd_sc_hd__fill_1
XFILLER_110_168 VPWR VGND VPWR VGND sky130_ef_sc_hd__decap_12
XFILLER_2_65 VPWR VGND VPWR VGND sky130_ef_sc_hd__decap_12
XFILLER_77_594 VPWR VGND VPWR VGND sky130_ef_sc_hd__decap_12
XFILLER_49_296 VGND VGND VPWR VPWR sky130_fd_sc_hd__decap_3
XTAP_TAPCELL_ROW_69_1078 VGND VPWR sky130_fd_sc_hd__tapvpwrvgnd_1
X_5980_ net491 _4232_ VGND VGND VPWR VPWR _1515_ sky130_fd_sc_hd__nor2_1
XFILLER_18_661 VPWR VGND VPWR VGND sky130_ef_sc_hd__decap_12
XFILLER_92_597 VGND VGND VPWR VPWR sky130_fd_sc_hd__decap_4
X_4931_ _0676_ VGND VGND VPWR VPWR _0677_ sky130_fd_sc_hd__inv_2
XTAP_TAPCELL_ROW_82_1234 VGND VPWR sky130_fd_sc_hd__tapvpwrvgnd_1
XFILLER_32_141 VPWR VGND VPWR VGND sky130_ef_sc_hd__decap_12
X_7650_ _3063_ _3098_ VGND VGND VPWR VPWR _3099_ sky130_fd_sc_hd__and2_1
X_4862_ _0597_ _0607_ VGND VGND VPWR VPWR _0609_ sky130_fd_sc_hd__xnor2_1
X_6601_ net172 _2081_ _2080_ VGND VGND VPWR VPWR _2118_ sky130_fd_sc_hd__a21oi_1
X_9320_ clknet_leaf_11_clk _0432_ VGND VGND VPWR VPWR pe_accum\[2\]\[30\] sky130_fd_sc_hd__dfxtp_1
X_7581_ _3030_ _3031_ VGND VGND VPWR VPWR _3032_ sky130_fd_sc_hd__nor2_1
X_4793_ _0496_ _0498_ _0540_ _0541_ VGND VGND VPWR VPWR _0542_ sky130_fd_sc_hd__o211a_1
X_6532_ net654 _2050_ VGND VGND VPWR VPWR _2051_ sky130_fd_sc_hd__xnor2_1
X_6463_ _1980_ _1983_ _1982_ VGND VGND VPWR VPWR _1984_ sky130_fd_sc_hd__or3_4
X_9251_ clknet_leaf_0_clk _0363_ VGND VGND VPWR VPWR pe_array\[3\].u_pe.weight_in\[5\]
+ sky130_fd_sc_hd__dfxtp_1
X_9182_ clknet_leaf_32_clk _0294_ VGND VGND VPWR VPWR pe_array\[1\].u_pe.accum_reg\[0\]
+ sky130_fd_sc_hd__dfxtp_1
X_8202_ _3588_ _3589_ VGND VGND VPWR VPWR _3591_ sky130_fd_sc_hd__xnor2_1
X_5414_ net181 _1143_ VGND VGND VPWR VPWR _1144_ sky130_fd_sc_hd__and2_1
Xoutput100 net100 VGND VGND VPWR VPWR result_data[55] sky130_fd_sc_hd__buf_2
Xoutput111 net111 VGND VGND VPWR VPWR result_data[65] sky130_fd_sc_hd__buf_2
Xoutput133 net133 VGND VGND VPWR VPWR result_data[85] sky130_fd_sc_hd__buf_2
X_6394_ _1889_ _1917_ VGND VGND VPWR VPWR _1918_ sky130_fd_sc_hd__xnor2_1
Xoutput122 net122 VGND VGND VPWR VPWR result_data[75] sky130_fd_sc_hd__buf_2
X_8133_ _3475_ _3477_ _3523_ _3521_ VGND VGND VPWR VPWR _3524_ sky130_fd_sc_hd__a211o_4
Xoutput144 net144 VGND VGND VPWR VPWR result_data[95] sky130_fd_sc_hd__buf_2
XTAP_TAPCELL_ROW_93_1374 VGND VPWR sky130_fd_sc_hd__tapvpwrvgnd_1
X_5345_ net185 _1076_ VGND VGND VPWR VPWR _1077_ sky130_fd_sc_hd__nor2_1
XFILLER_101_113 VPWR VGND VPWR VGND sky130_ef_sc_hd__decap_12
XFILLER_101_102 VGND VGND VPWR VPWR sky130_fd_sc_hd__decap_8
X_8064_ _3452_ _3455_ VGND VGND VPWR VPWR _3456_ sky130_fd_sc_hd__xnor2_1
X_5276_ _0986_ _1009_ VGND VGND VPWR VPWR _1011_ sky130_fd_sc_hd__xor2_2
XFILLER_68_550 VPWR VGND VPWR VGND sky130_ef_sc_hd__decap_12
X_7015_ _2480_ _2481_ VGND VGND VPWR VPWR _2483_ sky130_fd_sc_hd__xor2_1
XFILLER_83_542 VPWR VGND VPWR VGND sky130_ef_sc_hd__decap_12
XFILLER_55_211 VPWR VGND VPWR VGND sky130_ef_sc_hd__decap_12
XFILLER_46_27 VGND VGND VPWR VPWR sky130_fd_sc_hd__fill_1
XFILLER_83_575 VPWR VGND VPWR VGND sky130_ef_sc_hd__decap_12
X_8966_ clknet_leaf_54_clk _0078_ VGND VGND VPWR VPWR pe_array\[1\].u_pe.weight_in\[1\]
+ sky130_fd_sc_hd__dfxtp_1
XTAP_TAPCELL_ROW_54_902 VGND VPWR sky130_fd_sc_hd__tapvpwrvgnd_1
X_7917_ _3311_ _3312_ VGND VGND VPWR VPWR _3313_ sky130_fd_sc_hd__nor2_1
XFILLER_70_203 VGND VGND VPWR VPWR sky130_fd_sc_hd__fill_1
XFILLER_70_247 VGND VGND VPWR VPWR sky130_fd_sc_hd__fill_1
XFILLER_24_631 VGND VGND VPWR VPWR sky130_fd_sc_hd__decap_8
X_8897_ clknet_leaf_57_clk _0009_ VGND VGND VPWR VPWR pe_array\[3\].u_pe.tap_count\[1\]
+ sky130_fd_sc_hd__dfxtp_1
X_7848_ pe_array\[2\].u_pe.accum_reg\[3\] net513 net318 VGND VGND VPWR VPWR _3246_
+ sky130_fd_sc_hd__and3_1
XFILLER_51_472 VGND VGND VPWR VPWR sky130_fd_sc_hd__fill_2
XTAP_TAPCELL_ROW_102_1481 VGND VPWR sky130_fd_sc_hd__tapvpwrvgnd_1
XFILLER_23_196 VGND VGND VPWR VPWR sky130_fd_sc_hd__fill_1
X_7779_ net225 _3016_ VGND VGND VPWR VPWR _3199_ sky130_fd_sc_hd__nand2_2
XFILLER_2_3 VPWR VGND VPWR VGND sky130_ef_sc_hd__decap_12
XFILLER_105_485 VGND VGND VPWR VPWR sky130_fd_sc_hd__decap_6
Xfanout393 net394 VGND VGND VPWR VPWR net393 sky130_fd_sc_hd__clkbuf_2
Xclone139 _1684_ VGND VGND VPWR VPWR net654 sky130_fd_sc_hd__clkbuf_1
Xfanout360 net362 VGND VGND VPWR VPWR net360 sky130_fd_sc_hd__buf_2
Xfanout382 net389 VGND VGND VPWR VPWR net382 sky130_fd_sc_hd__clkbuf_2
Xfanout371 net372 VGND VGND VPWR VPWR net371 sky130_fd_sc_hd__buf_2
XFILLER_74_531 VGND VGND VPWR VPWR sky130_fd_sc_hd__fill_1
XFILLER_74_597 VGND VGND VPWR VPWR sky130_fd_sc_hd__decap_3
XFILLER_34_439 VGND VGND VPWR VPWR sky130_fd_sc_hd__fill_1
XFILLER_36_82 VGND VGND VPWR VPWR sky130_fd_sc_hd__fill_2
XFILLER_46_277 VPWR VGND VPWR VGND sky130_ef_sc_hd__decap_12
XFILLER_30_623 VGND VGND VPWR VPWR sky130_fd_sc_hd__decap_8
Xinput13 weight_din[0] VGND VGND VPWR VPWR net13 sky130_fd_sc_hd__clkbuf_2
XTAP_TAPCELL_ROW_12_397 VGND VPWR sky130_fd_sc_hd__tapvpwrvgnd_1
XFILLER_6_395 VPWR VGND VPWR VGND sky130_ef_sc_hd__decap_12
XFILLER_96_100 VGND VGND VPWR VPWR sky130_fd_sc_hd__decap_4
X_5130_ _0868_ _0869_ VGND VGND VPWR VPWR _0870_ sky130_fd_sc_hd__xor2_2
XFILLER_35_3 VGND VGND VPWR VPWR sky130_fd_sc_hd__decap_4
X_5061_ _0799_ _0800_ _0801_ VGND VGND VPWR VPWR _0803_ sky130_fd_sc_hd__a21o_1
XFILLER_77_391 VGND VGND VPWR VPWR sky130_fd_sc_hd__fill_1
X_8820_ _4172_ _4189_ VGND VGND VPWR VPWR _4190_ sky130_fd_sc_hd__xnor2_1
X_8751_ _4122_ _4123_ VGND VGND VPWR VPWR _4124_ sky130_fd_sc_hd__or2_4
XFILLER_92_372 VGND VGND VPWR VPWR sky130_fd_sc_hd__fill_2
XFILLER_80_523 VGND VGND VPWR VPWR sky130_fd_sc_hd__decap_4
X_5963_ _1465_ net609 _1498_ VGND VGND VPWR VPWR _1499_ sky130_fd_sc_hd__nand3_2
XFILLER_80_567 VGND VGND VPWR VPWR sky130_fd_sc_hd__fill_1
X_7702_ _3147_ _3148_ VGND VGND VPWR VPWR _3149_ sky130_fd_sc_hd__nor2_1
X_4914_ _0656_ _0657_ _0611_ _0612_ VGND VGND VPWR VPWR _0660_ sky130_fd_sc_hd__a211o_1
XFILLER_40_409 VGND VGND VPWR VPWR sky130_fd_sc_hd__decap_3
X_8682_ _4030_ _4056_ VGND VGND VPWR VPWR _4057_ sky130_fd_sc_hd__and2_1
X_5894_ _1422_ _1430_ VGND VGND VPWR VPWR _1431_ sky130_fd_sc_hd__nand2b_1
XFILLER_32_29 VPWR VGND VPWR VGND sky130_ef_sc_hd__decap_12
X_4845_ _0591_ _0592_ VGND VGND VPWR VPWR _0593_ sky130_fd_sc_hd__or2_1
X_7633_ _3080_ _3081_ VGND VGND VPWR VPWR _3082_ sky130_fd_sc_hd__and2_1
XFILLER_21_667 VGND VGND VPWR VPWR sky130_fd_sc_hd__decap_4
X_4776_ net287 _0522_ _0523_ VGND VGND VPWR VPWR _0525_ sky130_fd_sc_hd__or3_4
X_7564_ _3015_ _3014_ VGND VGND VPWR VPWR _3016_ sky130_fd_sc_hd__nand2_2
X_6515_ _2033_ _2034_ VGND VGND VPWR VPWR _2035_ sky130_fd_sc_hd__nor2_1
X_9303_ clknet_leaf_3_clk _0415_ VGND VGND VPWR VPWR pe_accum\[2\]\[13\] sky130_fd_sc_hd__dfxtp_1
X_7495_ net168 _2948_ VGND VGND VPWR VPWR _2949_ sky130_fd_sc_hd__nand2_1
X_6446_ _1966_ _1967_ VGND VGND VPWR VPWR _1968_ sky130_fd_sc_hd__xnor2_1
X_9234_ clknet_leaf_46_clk _0346_ VGND VGND VPWR VPWR pe_accum\[1\]\[20\] sky130_fd_sc_hd__dfxtp_1
X_9165_ clknet_leaf_25_clk _0277_ VGND VGND VPWR VPWR pe_accum\[0\]\[19\] sky130_fd_sc_hd__dfxtp_1
X_6377_ net279 _1898_ _1899_ VGND VGND VPWR VPWR _1901_ sky130_fd_sc_hd__or3_1
X_8116_ net462 net559 _3506_ VGND VGND VPWR VPWR _3507_ sky130_fd_sc_hd__a21boi_1
X_5328_ _1035_ _1033_ _1060_ VGND VGND VPWR VPWR _1061_ sky130_fd_sc_hd__a21oi_2
XFILLER_0_505 VPWR VGND VPWR VGND sky130_ef_sc_hd__decap_12
X_9096_ clknet_leaf_60_clk _0208_ VGND VGND VPWR VPWR net47 sky130_fd_sc_hd__dfxtp_1
XFILLER_88_645 VGND VGND VPWR VPWR sky130_fd_sc_hd__decap_8
X_8047_ _3405_ _3438_ _3439_ VGND VGND VPWR VPWR _3440_ sky130_fd_sc_hd__nor3_2
XFILLER_102_477 VGND VGND VPWR VPWR sky130_fd_sc_hd__decap_8
X_5259_ _0992_ _0993_ VGND VGND VPWR VPWR _0994_ sky130_fd_sc_hd__nor2_1
XFILLER_28_222 VGND VGND VPWR VPWR sky130_fd_sc_hd__decap_8
XFILLER_71_501 VGND VGND VPWR VPWR sky130_fd_sc_hd__decap_3
XFILLER_56_564 VGND VGND VPWR VPWR sky130_fd_sc_hd__fill_1
XFILLER_56_553 VGND VGND VPWR VPWR sky130_fd_sc_hd__fill_1
XFILLER_28_233 VGND VGND VPWR VPWR sky130_fd_sc_hd__decap_8
XFILLER_28_244 VGND VGND VPWR VPWR sky130_fd_sc_hd__decap_8
XFILLER_28_277 VPWR VGND VPWR VGND sky130_ef_sc_hd__decap_12
XFILLER_43_214 VGND VGND VPWR VPWR sky130_fd_sc_hd__fill_2
XFILLER_43_225 VGND VGND VPWR VPWR sky130_fd_sc_hd__decap_8
X_8949_ clknet_leaf_64_clk _0061_ VGND VGND VPWR VPWR pe_accum\[3\]\[17\] sky130_fd_sc_hd__dfxtp_1
XFILLER_43_269 VGND VGND VPWR VPWR sky130_fd_sc_hd__fill_1
XFILLER_11_111 VGND VGND VPWR VPWR sky130_fd_sc_hd__fill_1
XFILLER_11_144 VGND VGND VPWR VPWR sky130_fd_sc_hd__fill_1
XFILLER_78_111 VGND VGND VPWR VPWR sky130_fd_sc_hd__fill_1
XFILLER_105_293 VGND VGND VPWR VPWR sky130_fd_sc_hd__decap_4
Xfanout190 _3551_ VGND VGND VPWR VPWR net190 sky130_fd_sc_hd__clkbuf_2
XFILLER_59_391 VGND VGND VPWR VPWR sky130_fd_sc_hd__fill_1
XFILLER_19_200 VGND VGND VPWR VPWR sky130_fd_sc_hd__decap_8
XFILLER_47_531 VGND VGND VPWR VPWR sky130_fd_sc_hd__decap_4
XFILLER_93_169 VPWR VGND VPWR VGND sky130_ef_sc_hd__decap_12
XFILLER_19_244 VGND VGND VPWR VPWR sky130_fd_sc_hd__decap_3
XFILLER_47_81 VPWR VGND VPWR VGND sky130_ef_sc_hd__decap_12
XFILLER_62_501 VGND VGND VPWR VPWR sky130_fd_sc_hd__decap_4
XFILLER_19_299 VPWR VGND VPWR VGND sky130_ef_sc_hd__decap_12
XTAP_TAPCELL_ROW_66_1048 VGND VPWR sky130_fd_sc_hd__tapvpwrvgnd_1
XFILLER_62_589 VGND VGND VPWR VPWR sky130_fd_sc_hd__decap_4
XFILLER_15_461 VGND VGND VPWR VPWR sky130_fd_sc_hd__decap_4
XTAP_TAPCELL_ROW_17_456 VGND VPWR sky130_fd_sc_hd__tapvpwrvgnd_1
XFILLER_34_269 VGND VGND VPWR VPWR sky130_fd_sc_hd__fill_1
XFILLER_63_80 VGND VGND VPWR VPWR sky130_fd_sc_hd__decap_4
XFILLER_15_483 VGND VGND VPWR VPWR sky130_fd_sc_hd__fill_2
XTAP_TAPCELL_ROW_45_798 VGND VPWR sky130_fd_sc_hd__tapvpwrvgnd_1
X_4630_ net483 net293 net292 net492 VGND VGND VPWR VPWR _4392_ sky130_fd_sc_hd__a22oi_1
XFILLER_8_53 VPWR VGND VPWR VGND sky130_ef_sc_hd__decap_12
X_6300_ _1824_ _1825_ _1826_ VGND VGND VPWR VPWR _1827_ sky130_fd_sc_hd__nand3_1
X_4561_ net509 net292 _4323_ VGND VGND VPWR VPWR _4325_ sky130_fd_sc_hd__and3_1
XFILLER_7_671 VGND VGND VPWR VPWR sky130_fd_sc_hd__fill_1
X_7280_ net195 _2709_ _2707_ VGND VGND VPWR VPWR _2741_ sky130_fd_sc_hd__a21o_1
X_4492_ _4251_ _4258_ VGND VGND VPWR VPWR _4260_ sky130_fd_sc_hd__xor2_1
X_6231_ net199 _1757_ _1759_ VGND VGND VPWR VPWR _1760_ sky130_fd_sc_hd__or3b_4
XTAP_TAPCELL_ROW_77_1177 VGND VPWR sky130_fd_sc_hd__tapvpwrvgnd_1
XTAP_TAPCELL_ROW_90_1333 VGND VPWR sky130_fd_sc_hd__tapvpwrvgnd_1
X_6162_ _1690_ _1689_ _1650_ _1651_ VGND VGND VPWR VPWR _1693_ sky130_fd_sc_hd__a211o_1
XFILLER_97_420 VGND VGND VPWR VPWR sky130_fd_sc_hd__fill_1
X_5113_ _0850_ _0851_ net205 VGND VGND VPWR VPWR _0853_ sky130_fd_sc_hd__a21o_1
XFILLER_111_241 VPWR VGND VPWR VGND sky130_ef_sc_hd__decap_12
X_6093_ _1580_ _1582_ _1623_ _1625_ VGND VGND VPWR VPWR _1626_ sky130_fd_sc_hd__a211oi_2
XFILLER_69_177 VGND VGND VPWR VPWR sky130_fd_sc_hd__decap_3
XFILLER_111_296 VPWR VGND VPWR VGND sky130_ef_sc_hd__decap_12
XFILLER_85_648 VGND VGND VPWR VPWR sky130_fd_sc_hd__decap_4
XFILLER_69_199 VGND VGND VPWR VPWR sky130_fd_sc_hd__fill_1
X_5044_ pe_array\[3\].u_pe.accum_reg\[17\] net297 net433 VGND VGND VPWR VPWR _0786_
+ sky130_fd_sc_hd__and3_1
XFILLER_38_531 VGND VGND VPWR VPWR sky130_fd_sc_hd__fill_1
X_8803_ _4172_ _4173_ VGND VGND VPWR VPWR _4174_ sky130_fd_sc_hd__nand2_1
XFILLER_25_225 VPWR VGND VPWR VGND sky130_ef_sc_hd__decap_12
X_6995_ _2460_ net270 _2461_ VGND VGND VPWR VPWR _2463_ sky130_fd_sc_hd__or3_4
X_8734_ _4066_ _4071_ _4073_ VGND VGND VPWR VPWR _4107_ sky130_fd_sc_hd__a21o_1
XFILLER_80_386 VPWR VGND VPWR VGND sky130_ef_sc_hd__decap_12
X_5946_ net454 net358 pe_array\[0\].u_pe.accum_reg\[9\] VGND VGND VPWR VPWR _1482_
+ sky130_fd_sc_hd__a21oi_1
X_8665_ _4038_ _4039_ VGND VGND VPWR VPWR _4040_ sky130_fd_sc_hd__nor2_1
X_5877_ _1376_ _1377_ _1375_ VGND VGND VPWR VPWR _1415_ sky130_fd_sc_hd__o21a_1
XFILLER_43_39 VPWR VGND VPWR VGND sky130_ef_sc_hd__decap_12
X_4828_ _0572_ _0573_ _0522_ _0524_ VGND VGND VPWR VPWR _0576_ sky130_fd_sc_hd__a211o_1
X_7616_ _3035_ _3064_ VGND VGND VPWR VPWR _3066_ sky130_fd_sc_hd__xnor2_1
X_8596_ _3973_ _3972_ VGND VGND VPWR VPWR _3974_ sky130_fd_sc_hd__xnor2_2
X_7547_ net194 _2998_ VGND VGND VPWR VPWR _2999_ sky130_fd_sc_hd__xnor2_1
X_4759_ net293 net469 _0437_ net578 VGND VGND VPWR VPWR _0508_ sky130_fd_sc_hd__a31o_1
X_7478_ net448 net339 pe_array\[1\].u_pe.accum_reg\[23\] VGND VGND VPWR VPWR _2932_
+ sky130_fd_sc_hd__a21oi_1
XFILLER_107_558 VGND VGND VPWR VPWR sky130_fd_sc_hd__fill_2
X_6429_ net431 _1951_ VGND VGND VPWR VPWR _0248_ sky130_fd_sc_hd__nor2_1
X_9217_ clknet_leaf_32_clk _0329_ VGND VGND VPWR VPWR pe_accum\[1\]\[3\] sky130_fd_sc_hd__dfxtp_1
XFILLER_108_65 VPWR VGND VPWR VGND sky130_ef_sc_hd__decap_12
X_9148_ clknet_leaf_21_clk _0260_ VGND VGND VPWR VPWR pe_accum\[0\]\[2\] sky130_fd_sc_hd__dfxtp_1
XFILLER_102_241 VGND VGND VPWR VPWR sky130_fd_sc_hd__fill_1
XFILLER_88_453 VGND VGND VPWR VPWR sky130_fd_sc_hd__decap_3
XFILLER_76_626 VPWR VGND VPWR VGND sky130_ef_sc_hd__decap_12
X_9079_ clknet_leaf_60_clk _0191_ VGND VGND VPWR VPWR net28 sky130_fd_sc_hd__dfxtp_1
XFILLER_0_379 VGND VGND VPWR VPWR sky130_fd_sc_hd__fill_2
XFILLER_75_136 VPWR VGND VPWR VGND sky130_ef_sc_hd__decap_12
XFILLER_75_125 VGND VGND VPWR VPWR sky130_fd_sc_hd__fill_2
XFILLER_91_629 VGND VGND VPWR VPWR sky130_fd_sc_hd__decap_6
XFILLER_90_117 VPWR VGND VPWR VGND sky130_ef_sc_hd__decap_12
XFILLER_44_501 VGND VGND VPWR VPWR sky130_fd_sc_hd__fill_1
XFILLER_71_364 VGND VGND VPWR VPWR sky130_fd_sc_hd__fill_1
XFILLER_71_353 VGND VGND VPWR VPWR sky130_fd_sc_hd__fill_2
XFILLER_17_84 VGND VGND VPWR VPWR sky130_fd_sc_hd__decap_3
XFILLER_44_589 VGND VGND VPWR VPWR sky130_fd_sc_hd__decap_3
XTAP_TAPCELL_ROW_14_426 VGND VPWR sky130_fd_sc_hd__tapvpwrvgnd_1
XTAP_TAPCELL_ROW_42_757 VGND VPWR sky130_fd_sc_hd__tapvpwrvgnd_1
XFILLER_12_475 VGND VGND VPWR VPWR sky130_fd_sc_hd__fill_1
XFILLER_8_457 VPWR VGND VPWR VGND sky130_ef_sc_hd__decap_12
XTAP_TAPCELL_ROW_113_1609 VGND VPWR sky130_fd_sc_hd__tapvpwrvgnd_1
XFILLER_113_528 VPWR VGND VPWR VGND sky130_ef_sc_hd__decap_12
XFILLER_98_239 VPWR VGND VPWR VGND sky130_ef_sc_hd__decap_12
XFILLER_79_420 VPWR VGND VPWR VGND sky130_ef_sc_hd__decap_12
XFILLER_3_173 VGND VGND VPWR VPWR sky130_fd_sc_hd__fill_1
XFILLER_67_615 VGND VGND VPWR VPWR sky130_fd_sc_hd__fill_1
XFILLER_94_445 VPWR VGND VPWR VGND sky130_ef_sc_hd__decap_12
XFILLER_79_486 VGND VGND VPWR VPWR sky130_fd_sc_hd__decap_8
XFILLER_35_534 VGND VGND VPWR VPWR sky130_fd_sc_hd__fill_2
X_5800_ _1306_ _1339_ VGND VGND VPWR VPWR _1340_ sky130_fd_sc_hd__or2_1
X_6780_ _2253_ VGND VGND VPWR VPWR _2254_ sky130_fd_sc_hd__inv_2
XFILLER_22_206 VPWR VGND VPWR VGND sky130_ef_sc_hd__decap_12
X_5731_ _1254_ _1255_ _1271_ _1272_ VGND VGND VPWR VPWR _1273_ sky130_fd_sc_hd__o211a_1
X_8450_ _3799_ _3800_ _3830_ _3831_ VGND VGND VPWR VPWR _3832_ sky130_fd_sc_hd__o211a_1
XTAP_TAPCELL_ROW_79_1206 VGND VPWR sky130_fd_sc_hd__tapvpwrvgnd_1
X_5662_ net980 net363 VGND VGND VPWR VPWR _0203_ sky130_fd_sc_hd__and2_1
X_8381_ _3764_ _3763_ VGND VGND VPWR VPWR _3766_ sky130_fd_sc_hd__or2_4
X_7401_ _2856_ _2857_ VGND VGND VPWR VPWR _2858_ sky130_fd_sc_hd__and2b_1
X_5593_ net948 net373 VGND VGND VPWR VPWR _0134_ sky130_fd_sc_hd__and2_1
X_4613_ _4331_ _4338_ _4337_ VGND VGND VPWR VPWR _4376_ sky130_fd_sc_hd__a21bo_1
XFILLER_116_300 VGND VGND VPWR VPWR sky130_fd_sc_hd__decap_8
X_7332_ net407 pe_array\[1\].u_pe.accum_reg\[17\] net229 _2791_ VGND VGND VPWR VPWR
+ _2792_ sky130_fd_sc_hd__o2bb2a_4
Xhold402 pe_accum\[3\]\[8\] VGND VGND VPWR VPWR net917 sky130_fd_sc_hd__dlygate4sd3_1
X_4544_ _4307_ _4306_ _4278_ _4279_ VGND VGND VPWR VPWR _4309_ sky130_fd_sc_hd__a211o_1
Xhold435 pe_accum\[2\]\[7\] VGND VGND VPWR VPWR net950 sky130_fd_sc_hd__dlygate4sd3_1
Xhold413 pe_accum\[2\]\[28\] VGND VGND VPWR VPWR net928 sky130_fd_sc_hd__dlygate4sd3_1
X_7263_ _2723_ _2724_ _2687_ VGND VGND VPWR VPWR _2725_ sky130_fd_sc_hd__a21oi_1
Xhold424 pe_accum\[3\]\[12\] VGND VGND VPWR VPWR net939 sky130_fd_sc_hd__dlygate4sd3_1
X_9002_ clknet_leaf_22_clk _0114_ VGND VGND VPWR VPWR net70 sky130_fd_sc_hd__dfxtp_1
XFILLER_104_517 VPWR VGND VPWR VGND sky130_ef_sc_hd__decap_12
Xmax_cap154 _3821_ VGND VGND VPWR VPWR net154 sky130_fd_sc_hd__clkbuf_1
X_6214_ _1742_ _1743_ VGND VGND VPWR VPWR _1744_ sky130_fd_sc_hd__xnor2_2
Xhold468 pe_accum\[3\]\[27\] VGND VGND VPWR VPWR net983 sky130_fd_sc_hd__dlygate4sd3_1
X_4475_ net416 _4245_ _4246_ VGND VGND VPWR VPWR _0009_ sky130_fd_sc_hd__nor3_1
Xhold446 pe_accum\[1\]\[24\] VGND VGND VPWR VPWR net961 sky130_fd_sc_hd__dlygate4sd3_1
Xhold457 pe_accum\[1\]\[8\] VGND VGND VPWR VPWR net972 sky130_fd_sc_hd__dlygate4sd3_1
Xhold479 pe_accum\[2\]\[17\] VGND VGND VPWR VPWR net994 sky130_fd_sc_hd__dlygate4sd3_1
X_7194_ net408 pe_array\[1\].u_pe.accum_reg\[13\] net229 _2657_ VGND VGND VPWR VPWR
+ _2658_ sky130_fd_sc_hd__o2bb2a_4
X_6145_ net412 pe_array\[0\].u_pe.accum_reg\[13\] net240 _1676_ VGND VGND VPWR VPWR
+ _1677_ sky130_fd_sc_hd__o2bb2a_1
X_6076_ _1598_ _1607_ VGND VGND VPWR VPWR _1609_ sky130_fd_sc_hd__xnor2_1
XFILLER_57_169 VGND VGND VPWR VPWR sky130_fd_sc_hd__decap_8
XFILLER_57_147 VPWR VGND VPWR VGND sky130_ef_sc_hd__decap_12
X_5027_ _0719_ _0737_ _0736_ VGND VGND VPWR VPWR _0770_ sky130_fd_sc_hd__a21bo_1
XFILLER_72_128 VPWR VGND VPWR VGND sky130_ef_sc_hd__decap_12
XFILLER_66_681 VGND VGND VPWR VPWR sky130_fd_sc_hd__decap_8
XFILLER_81_640 VPWR VGND VPWR VGND sky130_ef_sc_hd__decap_12
XFILLER_54_27 VGND VGND VPWR VPWR sky130_fd_sc_hd__fill_1
XFILLER_53_331 VGND VGND VPWR VPWR sky130_fd_sc_hd__fill_1
XFILLER_26_545 VPWR VGND VPWR VGND sky130_ef_sc_hd__decap_12
XFILLER_38_394 VGND VGND VPWR VPWR sky130_fd_sc_hd__fill_2
XFILLER_81_673 VPWR VGND VPWR VGND sky130_ef_sc_hd__decap_12
XFILLER_26_589 VGND VGND VPWR VPWR sky130_fd_sc_hd__decap_4
X_8717_ _4058_ _4086_ VGND VGND VPWR VPWR _4090_ sky130_fd_sc_hd__or2_1
XFILLER_80_183 VGND VGND VPWR VPWR sky130_fd_sc_hd__decap_6
XFILLER_53_386 VGND VGND VPWR VPWR sky130_fd_sc_hd__decap_6
X_6978_ net487 net479 net328 net326 VGND VGND VPWR VPWR _2446_ sky130_fd_sc_hd__and4_1
XFILLER_110_77 VGND VGND VPWR VPWR sky130_fd_sc_hd__decap_6
X_5929_ _1429_ _1431_ VGND VGND VPWR VPWR _1465_ sky130_fd_sc_hd__nand2_1
X_8648_ net176 _4022_ VGND VGND VPWR VPWR _4024_ sky130_fd_sc_hd__xnor2_1
X_8579_ net191 _3925_ _3923_ VGND VGND VPWR VPWR _3957_ sky130_fd_sc_hd__a21o_1
XFILLER_5_405 VPWR VGND VPWR VGND sky130_ef_sc_hd__decap_12
XFILLER_79_13 VGND VGND VPWR VPWR sky130_fd_sc_hd__fill_1
XFILLER_5_449 VPWR VGND VPWR VGND sky130_ef_sc_hd__decap_12
XFILLER_102_3 VPWR VGND VPWR VGND sky130_ef_sc_hd__decap_12
XFILLER_110_509 VGND VGND VPWR VPWR sky130_fd_sc_hd__decap_4
XFILLER_103_561 VPWR VGND VPWR VGND sky130_ef_sc_hd__decap_12
XFILLER_95_12 VGND VGND VPWR VPWR sky130_fd_sc_hd__decap_4
XFILLER_49_615 VGND VGND VPWR VPWR sky130_fd_sc_hd__fill_1
XFILLER_0_187 VGND VGND VPWR VPWR sky130_fd_sc_hd__fill_1
XFILLER_76_467 VGND VGND VPWR VPWR sky130_fd_sc_hd__fill_1
XFILLER_28_50 VGND VGND VPWR VPWR sky130_fd_sc_hd__fill_1
XFILLER_36_309 VPWR VGND VPWR VGND sky130_ef_sc_hd__decap_12
XFILLER_17_501 VGND VGND VPWR VPWR sky130_fd_sc_hd__decap_3
XFILLER_17_512 VGND VGND VPWR VPWR sky130_fd_sc_hd__decap_8
XTAP_TAPCELL_ROW_47_816 VGND VPWR sky130_fd_sc_hd__tapvpwrvgnd_1
XTAP_TAPCELL_ROW_63_1007 VGND VPWR sky130_fd_sc_hd__tapvpwrvgnd_1
XFILLER_32_515 VGND VGND VPWR VPWR sky130_fd_sc_hd__fill_1
XFILLER_72_695 VGND VGND VPWR VPWR sky130_fd_sc_hd__fill_1
XTAP_TAPCELL_ROW_27_573 VGND VPWR sky130_fd_sc_hd__tapvpwrvgnd_1
XFILLER_12_272 VGND VGND VPWR VPWR sky130_fd_sc_hd__decap_6
XFILLER_40_570 VGND VGND VPWR VPWR sky130_fd_sc_hd__decap_6
XFILLER_8_232 VGND VGND VPWR VPWR sky130_fd_sc_hd__decap_4
XTAP_TAPCELL_ROW_74_1136 VGND VPWR sky130_fd_sc_hd__tapvpwrvgnd_1
XTAP_TAPCELL_ROW_74_1147 VGND VPWR sky130_fd_sc_hd__tapvpwrvgnd_1
XFILLER_94_275 VGND VGND VPWR VPWR sky130_fd_sc_hd__fill_2
XFILLER_82_415 VGND VGND VPWR VPWR sky130_fd_sc_hd__fill_1
X_7950_ net506 net309 VGND VGND VPWR VPWR _3345_ sky130_fd_sc_hd__nand2_1
XFILLER_67_489 VGND VGND VPWR VPWR sky130_fd_sc_hd__decap_4
XFILLER_55_629 VPWR VGND VPWR VGND sky130_ef_sc_hd__decap_12
XFILLER_54_117 VGND VGND VPWR VPWR sky130_fd_sc_hd__fill_1
XPHY_EDGE_ROW_19_Left_137 VGND VGND VPWR VPWR sky130_fd_sc_hd__decap_3
XFILLER_27_309 VGND VGND VPWR VPWR sky130_fd_sc_hd__fill_1
XFILLER_39_169 VGND VGND VPWR VPWR sky130_fd_sc_hd__decap_4
X_7881_ _3273_ _3276_ VGND VGND VPWR VPWR _3278_ sky130_fd_sc_hd__xor2_2
XFILLER_63_640 VGND VGND VPWR VPWR sky130_fd_sc_hd__decap_8
XFILLER_47_191 VGND VGND VPWR VPWR sky130_fd_sc_hd__decap_8
X_6901_ _2367_ _2370_ VGND VGND VPWR VPWR _2371_ sky130_fd_sc_hd__xnor2_1
XFILLER_63_673 VGND VGND VPWR VPWR sky130_fd_sc_hd__fill_1
X_6832_ _2299_ _2300_ _2301_ VGND VGND VPWR VPWR _2304_ sky130_fd_sc_hd__a21o_1
XFILLER_90_470 VGND VGND VPWR VPWR sky130_fd_sc_hd__decap_3
XTAP_TAPCELL_ROW_85_1276 VGND VPWR sky130_fd_sc_hd__tapvpwrvgnd_1
X_6763_ net430 _2237_ VGND VGND VPWR VPWR _0296_ sky130_fd_sc_hd__nor2_1
X_5714_ _1255_ _1256_ VGND VGND VPWR VPWR _1257_ sky130_fd_sc_hd__nor2_1
X_6694_ net1025 net235 _1378_ net243 VGND VGND VPWR VPWR _0264_ sky130_fd_sc_hd__o2bb2ai_1
X_8502_ _3758_ _3794_ _3879_ VGND VGND VPWR VPWR _3883_ sky130_fd_sc_hd__nor3_1
X_8433_ net160 _3814_ _3815_ VGND VGND VPWR VPWR _3816_ sky130_fd_sc_hd__nand3_1
X_5645_ net993 net371 VGND VGND VPWR VPWR _0186_ sky130_fd_sc_hd__and2_1
XPHY_EDGE_ROW_28_Left_146 VGND VGND VPWR VPWR sky130_fd_sc_hd__decap_3
X_5576_ net999 net392 VGND VGND VPWR VPWR _0117_ sky130_fd_sc_hd__and2_1
X_8364_ _3745_ _3746_ _3747_ VGND VGND VPWR VPWR _3749_ sky130_fd_sc_hd__a21o_1
XFILLER_117_697 VGND VGND VPWR VPWR sky130_fd_sc_hd__decap_3
XFILLER_116_141 VGND VGND VPWR VPWR sky130_fd_sc_hd__fill_1
X_8295_ _3679_ _3680_ _3681_ VGND VGND VPWR VPWR _3682_ sky130_fd_sc_hd__nand3_1
X_7315_ net193 _2772_ _2774_ VGND VGND VPWR VPWR _2775_ sky130_fd_sc_hd__or3b_1
X_4527_ _4292_ _4291_ _4270_ VGND VGND VPWR VPWR _4293_ sky130_fd_sc_hd__and3_1
X_4458_ net422 net11 net21 VGND VGND VPWR VPWR _4239_ sky130_fd_sc_hd__or3b_1
X_7246_ _2668_ _2669_ _2705_ _2706_ VGND VGND VPWR VPWR _2708_ sky130_fd_sc_hd__o211ai_1
XFILLER_49_27 VPWR VGND VPWR VGND sky130_ef_sc_hd__decap_12
XFILLER_104_369 VGND VGND VPWR VPWR sky130_fd_sc_hd__fill_1
XFILLER_104_358 VGND VGND VPWR VPWR sky130_fd_sc_hd__decap_6
X_7177_ net197 _2593_ _2591_ VGND VGND VPWR VPWR _2641_ sky130_fd_sc_hd__a21o_1
X_6128_ _1657_ _1658_ _1659_ VGND VGND VPWR VPWR _1660_ sky130_fd_sc_hd__nand3_1
XFILLER_112_391 VGND VGND VPWR VPWR sky130_fd_sc_hd__fill_2
XFILLER_65_15 VPWR VGND VPWR VGND sky130_ef_sc_hd__decap_12
XFILLER_58_445 VPWR VGND VPWR VGND sky130_ef_sc_hd__decap_12
XPHY_EDGE_ROW_37_Left_155 VGND VGND VPWR VPWR sky130_fd_sc_hd__decap_3
X_6059_ _1547_ _1592_ VGND VGND VPWR VPWR _1593_ sky130_fd_sc_hd__xor2_2
XFILLER_58_489 VPWR VGND VPWR VGND sky130_ef_sc_hd__decap_12
XFILLER_18_309 VGND VGND VPWR VPWR sky130_fd_sc_hd__fill_1
XFILLER_45_128 VGND VGND VPWR VPWR sky130_fd_sc_hd__decap_3
XFILLER_45_139 VGND VGND VPWR VPWR sky130_fd_sc_hd__fill_1
XFILLER_41_312 VGND VGND VPWR VPWR sky130_fd_sc_hd__decap_3
XFILLER_53_194 VGND VGND VPWR VPWR sky130_fd_sc_hd__fill_1
XTAP_TAPCELL_ROW_24_543 VGND VPWR sky130_fd_sc_hd__tapvpwrvgnd_1
XTAP_TAPCELL_ROW_52_874 VGND VPWR sky130_fd_sc_hd__tapvpwrvgnd_1
XPHY_EDGE_ROW_46_Left_164 VGND VGND VPWR VPWR sky130_fd_sc_hd__decap_3
XFILLER_14_85 VGND VGND VPWR VPWR sky130_fd_sc_hd__fill_1
XFILLER_5_268 VPWR VGND VPWR VGND sky130_ef_sc_hd__decap_12
XPHY_EDGE_ROW_55_Left_173 VGND VGND VPWR VPWR sky130_fd_sc_hd__decap_3
XFILLER_1_485 VPWR VGND VPWR VGND sky130_ef_sc_hd__decap_12
XFILLER_103_391 VGND VGND VPWR VPWR sky130_fd_sc_hd__fill_1
XFILLER_49_445 VGND VGND VPWR VPWR sky130_fd_sc_hd__decap_3
XFILLER_76_275 VGND VGND VPWR VPWR sky130_fd_sc_hd__decap_4
XFILLER_91_245 VGND VGND VPWR VPWR sky130_fd_sc_hd__fill_1
XFILLER_91_223 VGND VGND VPWR VPWR sky130_fd_sc_hd__fill_1
XFILLER_91_278 VGND VGND VPWR VPWR sky130_fd_sc_hd__fill_2
XFILLER_55_81 VPWR VGND VPWR VGND sky130_ef_sc_hd__decap_12
XFILLER_45_673 VGND VGND VPWR VPWR sky130_fd_sc_hd__decap_3
XFILLER_60_632 VPWR VGND VPWR VGND sky130_ef_sc_hd__decap_12
XPHY_EDGE_ROW_64_Left_182 VGND VGND VPWR VPWR sky130_fd_sc_hd__decap_3
XFILLER_32_334 VGND VGND VPWR VPWR sky130_fd_sc_hd__decap_6
XFILLER_44_194 VGND VGND VPWR VPWR sky130_fd_sc_hd__fill_2
XFILLER_9_552 VGND VGND VPWR VPWR sky130_fd_sc_hd__decap_8
X_5430_ net630 _1158_ VGND VGND VPWR VPWR _1159_ sky130_fd_sc_hd__xnor2_1
XFILLER_65_3 VPWR VGND VPWR VGND sky130_ef_sc_hd__decap_12
XFILLER_114_601 VPWR VGND VPWR VGND sky130_ef_sc_hd__decap_12
X_5361_ _1009_ _1034_ VGND VGND VPWR VPWR _1092_ sky130_fd_sc_hd__or2_1
XFILLER_114_645 VPWR VGND VPWR VGND sky130_ef_sc_hd__decap_12
X_8080_ _3469_ _3470_ _3425_ _3426_ VGND VGND VPWR VPWR _3472_ sky130_fd_sc_hd__a211o_1
X_5292_ _0997_ _0999_ _1025_ VGND VGND VPWR VPWR _1026_ sky130_fd_sc_hd__o21a_1
X_7100_ _2564_ _2565_ VGND VGND VPWR VPWR _2566_ sky130_fd_sc_hd__and2_1
XPHY_EDGE_ROW_73_Left_191 VGND VGND VPWR VPWR sky130_fd_sc_hd__decap_3
XFILLER_4_290 VGND VGND VPWR VPWR sky130_fd_sc_hd__decap_6
X_7031_ net334 net333 net452 VGND VGND VPWR VPWR _2498_ sky130_fd_sc_hd__o21a_1
XFILLER_101_328 VGND VGND VPWR VPWR sky130_fd_sc_hd__decap_8
X_8982_ clknet_leaf_22_clk _0094_ VGND VGND VPWR VPWR net138 sky130_fd_sc_hd__dfxtp_1
XFILLER_82_212 VPWR VGND VPWR VGND sky130_ef_sc_hd__decap_12
X_7933_ pe_array\[2\].u_pe.accum_reg\[6\] net486 net317 VGND VGND VPWR VPWR _3328_
+ sky130_fd_sc_hd__nand3_1
XFILLER_27_139 VGND VGND VPWR VPWR sky130_fd_sc_hd__fill_1
X_7864_ _3258_ _3259_ VGND VGND VPWR VPWR _3262_ sky130_fd_sc_hd__nand2_1
XFILLER_23_301 VGND VGND VPWR VPWR sky130_fd_sc_hd__decap_8
X_6815_ net588 net331 VGND VGND VPWR VPWR _2287_ sky130_fd_sc_hd__nand2_1
X_7795_ net13 _3206_ _3207_ net307 VGND VGND VPWR VPWR _0358_ sky130_fd_sc_hd__a22o_1
XFILLER_51_654 VGND VGND VPWR VPWR sky130_fd_sc_hd__fill_1
XFILLER_51_643 VGND VGND VPWR VPWR sky130_fd_sc_hd__decap_4
X_6746_ net412 pe_array\[1\].u_pe.accum_reg\[1\] net232 _2221_ VGND VGND VPWR VPWR
+ _2222_ sky130_fd_sc_hd__o2bb2a_1
XFILLER_11_529 VPWR VGND VPWR VGND sky130_ef_sc_hd__decap_12
XTAP_TAPCELL_ROW_21_502 VGND VPWR sky130_fd_sc_hd__tapvpwrvgnd_1
XFILLER_51_39 VPWR VGND VPWR VGND sky130_ef_sc_hd__decap_12
XFILLER_50_197 VPWR VGND VPWR VGND sky130_ef_sc_hd__decap_12
XTAP_TAPCELL_ROW_98_1434 VGND VPWR sky130_fd_sc_hd__tapvpwrvgnd_1
X_6677_ _4226_ _2190_ VGND VGND VPWR VPWR _2191_ sky130_fd_sc_hd__xnor2_1
X_5628_ net975 net381 VGND VGND VPWR VPWR _0169_ sky130_fd_sc_hd__and2_1
X_8416_ pe_array\[2\].u_pe.accum_reg\[18\] net441 net315 VGND VGND VPWR VPWR _3799_
+ sky130_fd_sc_hd__and3_1
XFILLER_105_601 VPWR VGND VPWR VGND sky130_ef_sc_hd__decap_12
X_8347_ pe_array\[2\].u_pe.accum_reg\[16\] net439 net313 VGND VGND VPWR VPWR _3732_
+ sky130_fd_sc_hd__and3_1
X_5559_ net907 net391 VGND VGND VPWR VPWR _0100_ sky130_fd_sc_hd__and2_1
XFILLER_117_483 VGND VGND VPWR VPWR sky130_fd_sc_hd__decap_3
X_8278_ _3581_ _3664_ VGND VGND VPWR VPWR _3665_ sky130_fd_sc_hd__xnor2_4
XFILLER_116_65 VPWR VGND VPWR VGND sky130_ef_sc_hd__decap_12
X_7229_ _2689_ _2690_ VGND VGND VPWR VPWR _2692_ sky130_fd_sc_hd__nand2_1
XFILLER_100_361 VGND VGND VPWR VPWR sky130_fd_sc_hd__decap_3
XFILLER_58_253 VPWR VGND VPWR VGND sky130_ef_sc_hd__decap_12
XTAP_TAPCELL_ROW_29_602 VGND VPWR sky130_fd_sc_hd__tapvpwrvgnd_1
XTAP_TAPCELL_ROW_57_933 VGND VPWR sky130_fd_sc_hd__tapvpwrvgnd_1
XFILLER_46_437 VPWR VGND VPWR VGND sky130_ef_sc_hd__decap_12
XTAP_TAPCELL_ROW_107_1541 VGND VPWR sky130_fd_sc_hd__tapvpwrvgnd_1
XTAP_TAPCELL_ROW_1_260 VGND VPWR sky130_fd_sc_hd__tapvpwrvgnd_1
XFILLER_33_109 VGND VGND VPWR VPWR sky130_fd_sc_hd__decap_3
Xrebuffer91 _1818_ VGND VGND VPWR VPWR net606 sky130_fd_sc_hd__buf_1
XFILLER_73_289 VGND VGND VPWR VPWR sky130_fd_sc_hd__fill_2
XTAP_TAPCELL_ROW_1_271 VGND VPWR sky130_fd_sc_hd__tapvpwrvgnd_1
XFILLER_27_673 VGND VGND VPWR VPWR sky130_fd_sc_hd__fill_2
XFILLER_25_51 VGND VGND VPWR VPWR sky130_fd_sc_hd__decap_4
XFILLER_14_389 VPWR VGND VPWR VGND sky130_ef_sc_hd__decap_12
XFILLER_25_95 VGND VGND VPWR VPWR sky130_fd_sc_hd__fill_1
XFILLER_115_409 VPWR VGND VPWR VGND sky130_ef_sc_hd__decap_12
XTAP_TAPCELL_ROW_71_1106 VGND VPWR sky130_fd_sc_hd__tapvpwrvgnd_1
XTAP_TAPCELL_ROW_9_360 VGND VPWR sky130_fd_sc_hd__tapvpwrvgnd_1
XFILLER_111_615 VGND VGND VPWR VPWR sky130_fd_sc_hd__fill_1
XFILLER_110_147 VGND VGND VPWR VPWR sky130_fd_sc_hd__decap_6
XFILLER_96_348 VGND VGND VPWR VPWR sky130_fd_sc_hd__fill_2
XFILLER_64_201 VGND VGND VPWR VPWR sky130_fd_sc_hd__fill_1
XFILLER_2_77 VGND VGND VPWR VPWR sky130_fd_sc_hd__decap_6
XFILLER_92_521 VGND VGND VPWR VPWR sky130_fd_sc_hd__fill_1
XTAP_TAPCELL_ROW_69_1079 VGND VPWR sky130_fd_sc_hd__tapvpwrvgnd_1
XFILLER_18_673 VGND VGND VPWR VPWR sky130_fd_sc_hd__decap_6
X_4930_ _0674_ _0675_ VGND VGND VPWR VPWR _0676_ sky130_fd_sc_hd__nand2b_1
XTAP_TAPCELL_ROW_82_1235 VGND VPWR sky130_fd_sc_hd__tapvpwrvgnd_1
XFILLER_32_120 VGND VGND VPWR VPWR sky130_fd_sc_hd__decap_3
X_4861_ _0597_ _0607_ VGND VGND VPWR VPWR _0608_ sky130_fd_sc_hd__nand2b_1
X_6600_ net157 _2116_ VGND VGND VPWR VPWR _2117_ sky130_fd_sc_hd__xnor2_1
XFILLER_32_153 VGND VGND VPWR VPWR sky130_fd_sc_hd__fill_2
XFILLER_60_495 VGND VGND VPWR VPWR sky130_fd_sc_hd__decap_6
X_7580_ _3001_ _3003_ _3029_ VGND VGND VPWR VPWR _3031_ sky130_fd_sc_hd__nor3_1
X_4792_ _0537_ net585 _0476_ _0478_ VGND VGND VPWR VPWR _0541_ sky130_fd_sc_hd__o211ai_2
X_6531_ _2047_ _2048_ VGND VGND VPWR VPWR _2050_ sky130_fd_sc_hd__xnor2_1
X_6462_ _1894_ _1892_ _1978_ VGND VGND VPWR VPWR _1983_ sky130_fd_sc_hd__a21oi_2
X_9250_ clknet_leaf_0_clk _0362_ VGND VGND VPWR VPWR pe_array\[3\].u_pe.weight_in\[4\]
+ sky130_fd_sc_hd__dfxtp_1
XFILLER_9_393 VPWR VGND VPWR VGND sky130_ef_sc_hd__decap_12
X_6393_ _1914_ _1915_ VGND VGND VPWR VPWR _1917_ sky130_fd_sc_hd__xnor2_1
X_8201_ _3589_ _3588_ VGND VGND VPWR VPWR _3590_ sky130_fd_sc_hd__nand2b_1
X_9181_ clknet_leaf_39_clk _0293_ VGND VGND VPWR VPWR pe_array\[1\].u_pe.tap_count\[3\]
+ sky130_fd_sc_hd__dfxtp_1
X_5413_ _1141_ _1142_ VGND VGND VPWR VPWR _1143_ sky130_fd_sc_hd__nor2_1
Xoutput101 net101 VGND VGND VPWR VPWR result_data[56] sky130_fd_sc_hd__buf_2
Xoutput112 net112 VGND VGND VPWR VPWR result_data[66] sky130_fd_sc_hd__buf_2
Xoutput134 net134 VGND VGND VPWR VPWR result_data[86] sky130_fd_sc_hd__buf_2
Xoutput123 net123 VGND VGND VPWR VPWR result_data[76] sky130_fd_sc_hd__buf_2
X_8132_ _3519_ _3520_ _3504_ VGND VGND VPWR VPWR _3523_ sky130_fd_sc_hd__a21oi_2
X_5344_ _1074_ _1075_ VGND VGND VPWR VPWR _1076_ sky130_fd_sc_hd__or2_1
XTAP_TAPCELL_ROW_93_1375 VGND VPWR sky130_fd_sc_hd__tapvpwrvgnd_1
XTAP_TAPCELL_ROW_93_1364 VGND VPWR sky130_fd_sc_hd__tapvpwrvgnd_1
Xoutput145 net145 VGND VGND VPWR VPWR result_data[96] sky130_fd_sc_hd__buf_2
X_8063_ _3453_ _3454_ VGND VGND VPWR VPWR _3455_ sky130_fd_sc_hd__or2_1
X_5275_ _0985_ _0981_ _1009_ VGND VGND VPWR VPWR _1010_ sky130_fd_sc_hd__a21o_1
XFILLER_101_125 VGND VGND VPWR VPWR sky130_fd_sc_hd__fill_1
XFILLER_87_348 VGND VGND VPWR VPWR sky130_fd_sc_hd__fill_1
X_7014_ _2477_ _2479_ _2481_ VGND VGND VPWR VPWR _2482_ sky130_fd_sc_hd__or3_4
XFILLER_28_415 VGND VGND VPWR VPWR sky130_fd_sc_hd__decap_4
XFILLER_110_681 VPWR VGND VPWR VGND sky130_ef_sc_hd__decap_12
XFILLER_83_521 VGND VGND VPWR VPWR sky130_fd_sc_hd__fill_2
XFILLER_55_223 VGND VGND VPWR VPWR sky130_fd_sc_hd__fill_1
XFILLER_28_426 VGND VGND VPWR VPWR sky130_fd_sc_hd__decap_8
XFILLER_83_554 VGND VGND VPWR VPWR sky130_fd_sc_hd__decap_6
X_8965_ clknet_leaf_36_clk _0077_ VGND VGND VPWR VPWR pe_array\[1\].u_pe.weight_in\[0\]
+ sky130_fd_sc_hd__dfxtp_1
XTAP_TAPCELL_ROW_54_903 VGND VPWR sky130_fd_sc_hd__tapvpwrvgnd_1
XFILLER_83_587 VGND VGND VPWR VPWR sky130_fd_sc_hd__decap_6
X_7916_ _3305_ _3307_ _3310_ VGND VGND VPWR VPWR _3312_ sky130_fd_sc_hd__a21oi_1
XFILLER_70_215 VGND VGND VPWR VPWR sky130_fd_sc_hd__fill_1
X_8896_ clknet_leaf_57_clk _0008_ VGND VGND VPWR VPWR pe_array\[3\].u_pe.tap_count\[0\]
+ sky130_fd_sc_hd__dfxtp_1
X_7847_ net513 net318 pe_array\[2\].u_pe.accum_reg\[3\] VGND VGND VPWR VPWR _3245_
+ sky130_fd_sc_hd__a21oi_1
XFILLER_62_27 VGND VGND VPWR VPWR sky130_fd_sc_hd__fill_1
XTAP_TAPCELL_ROW_34_660 VGND VPWR sky130_fd_sc_hd__tapvpwrvgnd_1
XTAP_TAPCELL_ROW_102_1482 VGND VPWR sky130_fd_sc_hd__tapvpwrvgnd_1
XFILLER_11_337 VPWR VGND VPWR VGND sky130_ef_sc_hd__decap_12
X_7778_ net961 net221 _3198_ net373 VGND VGND VPWR VPWR _0350_ sky130_fd_sc_hd__o211a_1
X_6729_ net1017 _2206_ net391 VGND VGND VPWR VPWR _2208_ sky130_fd_sc_hd__o21ai_1
XFILLER_109_225 VGND VGND VPWR VPWR sky130_fd_sc_hd__fill_2
XFILLER_3_503 VGND VGND VPWR VPWR sky130_fd_sc_hd__fill_1
XFILLER_87_57 VGND VGND VPWR VPWR sky130_fd_sc_hd__decap_4
Xfanout350 net351 VGND VGND VPWR VPWR net350 sky130_fd_sc_hd__buf_2
XTAP_TAPCELL_ROW_6_330 VGND VPWR sky130_fd_sc_hd__tapvpwrvgnd_1
Xfanout383 net389 VGND VGND VPWR VPWR net383 sky130_fd_sc_hd__buf_2
Xfanout361 net362 VGND VGND VPWR VPWR net361 sky130_fd_sc_hd__clkbuf_2
Xfanout372 net396 VGND VGND VPWR VPWR net372 sky130_fd_sc_hd__clkbuf_2
Xfanout394 net395 VGND VGND VPWR VPWR net394 sky130_fd_sc_hd__clkbuf_2
XFILLER_74_565 VGND VGND VPWR VPWR sky130_fd_sc_hd__fill_2
XFILLER_34_407 VGND VGND VPWR VPWR sky130_fd_sc_hd__decap_6
XFILLER_46_289 VGND VGND VPWR VPWR sky130_fd_sc_hd__decap_3
XFILLER_15_654 VGND VGND VPWR VPWR sky130_fd_sc_hd__decap_4
Xinput14 weight_din[1] VGND VGND VPWR VPWR net14 sky130_fd_sc_hd__buf_2
XTAP_TAPCELL_ROW_12_398 VGND VPWR sky130_fd_sc_hd__tapvpwrvgnd_1
XFILLER_111_401 VGND VGND VPWR VPWR sky130_fd_sc_hd__decap_4
XFILLER_96_123 VGND VGND VPWR VPWR sky130_fd_sc_hd__fill_1
X_5060_ _0799_ _0800_ _0801_ VGND VGND VPWR VPWR _0802_ sky130_fd_sc_hd__nand3_1
XFILLER_28_3 VGND VGND VPWR VPWR sky130_fd_sc_hd__fill_1
XFILLER_65_521 VPWR VGND VPWR VGND sky130_ef_sc_hd__decap_12
XFILLER_37_223 VGND VGND VPWR VPWR sky130_fd_sc_hd__fill_1
XFILLER_37_245 VGND VGND VPWR VPWR sky130_fd_sc_hd__decap_3
X_8750_ _4092_ _4095_ _4121_ VGND VGND VPWR VPWR _4123_ sky130_fd_sc_hd__and3_1
X_5962_ _1494_ _1496_ _1450_ _1452_ VGND VGND VPWR VPWR _1498_ sky130_fd_sc_hd__o211ai_2
XFILLER_18_470 VGND VGND VPWR VPWR sky130_fd_sc_hd__fill_1
X_4913_ _0611_ _0612_ _0656_ _0657_ VGND VGND VPWR VPWR _0659_ sky130_fd_sc_hd__o211ai_1
X_7701_ _3116_ _3119_ _3146_ VGND VGND VPWR VPWR _3148_ sky130_fd_sc_hd__nor3_1
X_8681_ _4053_ _4054_ VGND VGND VPWR VPWR _4056_ sky130_fd_sc_hd__xnor2_1
X_5893_ _1423_ _1428_ VGND VGND VPWR VPWR _1430_ sky130_fd_sc_hd__xnor2_1
X_4844_ _0542_ _0589_ _0590_ VGND VGND VPWR VPWR _0592_ sky130_fd_sc_hd__and3_1
X_7632_ _3043_ _3045_ VGND VGND VPWR VPWR _3081_ sky130_fd_sc_hd__or2_1
XFILLER_20_145 VGND VGND VPWR VPWR sky130_fd_sc_hd__decap_4
XTAP_TAPCELL_ROW_31_630 VGND VPWR sky130_fd_sc_hd__tapvpwrvgnd_1
X_4775_ net287 _0522_ _0523_ VGND VGND VPWR VPWR _0524_ sky130_fd_sc_hd__nor3_2
X_7563_ _2988_ _2986_ _3013_ VGND VGND VPWR VPWR _3015_ sky130_fd_sc_hd__nand3_2
X_6514_ _2004_ _2032_ VGND VGND VPWR VPWR _2034_ sky130_fd_sc_hd__nor2_1
X_9302_ clknet_leaf_4_clk _0414_ VGND VGND VPWR VPWR pe_accum\[2\]\[12\] sky130_fd_sc_hd__dfxtp_1
X_9233_ clknet_leaf_45_clk _0345_ VGND VGND VPWR VPWR pe_accum\[1\]\[19\] sky130_fd_sc_hd__dfxtp_1
X_7494_ _2946_ _2947_ VGND VGND VPWR VPWR _2948_ sky130_fd_sc_hd__xnor2_1
X_6445_ net177 _1934_ _1933_ VGND VGND VPWR VPWR _1967_ sky130_fd_sc_hd__a21oi_1
XFILLER_106_228 VGND VGND VPWR VPWR sky130_fd_sc_hd__fill_1
X_6376_ net279 _1898_ _1899_ VGND VGND VPWR VPWR _1900_ sky130_fd_sc_hd__nor3_1
X_9164_ clknet_leaf_27_clk _0276_ VGND VGND VPWR VPWR pe_accum\[0\]\[18\] sky130_fd_sc_hd__dfxtp_1
XFILLER_114_261 VGND VGND VPWR VPWR sky130_fd_sc_hd__decap_4
XFILLER_88_602 VGND VGND VPWR VPWR sky130_fd_sc_hd__fill_2
X_8115_ net443 _3418_ _3419_ net312 net463 VGND VGND VPWR VPWR _3506_ sky130_fd_sc_hd__a32o_1
X_9095_ clknet_leaf_61_clk _0207_ VGND VGND VPWR VPWR net46 sky130_fd_sc_hd__dfxtp_1
XFILLER_0_517 VGND VGND VPWR VPWR sky130_fd_sc_hd__decap_4
X_5327_ _1031_ _1058_ VGND VGND VPWR VPWR _1060_ sky130_fd_sc_hd__xnor2_1
XFILLER_88_657 VGND VGND VPWR VPWR sky130_fd_sc_hd__decap_4
X_8046_ _3436_ _3437_ _3380_ _3390_ VGND VGND VPWR VPWR _3439_ sky130_fd_sc_hd__a211oi_2
XFILLER_0_539 VGND VGND VPWR VPWR sky130_fd_sc_hd__decap_3
XFILLER_87_167 VGND VGND VPWR VPWR sky130_fd_sc_hd__fill_1
XFILLER_75_318 VGND VGND VPWR VPWR sky130_fd_sc_hd__fill_2
X_5258_ _0990_ _0991_ _0955_ _0956_ VGND VGND VPWR VPWR _0993_ sky130_fd_sc_hd__a211oi_1
XFILLER_102_489 VGND VGND VPWR VPWR sky130_fd_sc_hd__fill_1
XFILLER_87_189 VGND VGND VPWR VPWR sky130_fd_sc_hd__fill_2
XFILLER_56_521 VGND VGND VPWR VPWR sky130_fd_sc_hd__decap_6
X_5189_ pe_array\[3\].u_pe.accum_reg\[22\] net296 net434 VGND VGND VPWR VPWR _0926_
+ sky130_fd_sc_hd__and3_1
XFILLER_113_55 VGND VGND VPWR VPWR sky130_fd_sc_hd__fill_1
XTAP_TAPCELL_ROW_104_1500 VGND VPWR sky130_fd_sc_hd__tapvpwrvgnd_1
XFILLER_71_513 VGND VGND VPWR VPWR sky130_fd_sc_hd__fill_2
XFILLER_56_587 VGND VGND VPWR VPWR sky130_fd_sc_hd__fill_1
X_8948_ clknet_leaf_66_clk _0060_ VGND VGND VPWR VPWR pe_accum\[3\]\[16\] sky130_fd_sc_hd__dfxtp_1
XFILLER_28_289 VGND VGND VPWR VPWR sky130_fd_sc_hd__fill_2
X_8879_ net967 net213 _4220_ net385 VGND VGND VPWR VPWR _0429_ sky130_fd_sc_hd__o211a_1
XFILLER_51_281 VGND VGND VPWR VPWR sky130_fd_sc_hd__decap_4
XFILLER_12_624 VGND VGND VPWR VPWR sky130_fd_sc_hd__fill_1
XFILLER_11_189 VGND VGND VPWR VPWR sky130_fd_sc_hd__decap_3
XFILLER_11_167 VGND VGND VPWR VPWR sky130_fd_sc_hd__fill_1
XFILLER_22_41 VGND VGND VPWR VPWR sky130_fd_sc_hd__decap_4
XFILLER_22_63 VGND VGND VPWR VPWR sky130_fd_sc_hd__decap_4
XFILLER_22_74 VGND VGND VPWR VPWR sky130_fd_sc_hd__decap_8
XFILLER_22_85 VGND VGND VPWR VPWR sky130_fd_sc_hd__decap_3
XFILLER_79_613 VGND VGND VPWR VPWR sky130_fd_sc_hd__decap_3
XFILLER_3_377 VGND VGND VPWR VPWR sky130_fd_sc_hd__fill_1
XFILLER_94_616 VGND VGND VPWR VPWR sky130_fd_sc_hd__decap_8
XFILLER_66_307 VGND VGND VPWR VPWR sky130_fd_sc_hd__fill_1
XFILLER_93_126 VGND VGND VPWR VPWR sky130_fd_sc_hd__fill_1
Xfanout191 net192 VGND VGND VPWR VPWR net191 sky130_fd_sc_hd__buf_4
Xfanout180 net182 VGND VGND VPWR VPWR net180 sky130_fd_sc_hd__dlymetal6s2s_1
XFILLER_93_159 VGND VGND VPWR VPWR sky130_fd_sc_hd__decap_8
XFILLER_19_289 VGND VGND VPWR VPWR sky130_fd_sc_hd__decap_3
XFILLER_47_93 VGND VGND VPWR VPWR sky130_fd_sc_hd__fill_1
XTAP_TAPCELL_ROW_66_1049 VGND VPWR sky130_fd_sc_hd__tapvpwrvgnd_1
XFILLER_34_237 VGND VGND VPWR VPWR sky130_fd_sc_hd__decap_8
XTAP_TAPCELL_ROW_17_457 VGND VPWR sky130_fd_sc_hd__tapvpwrvgnd_1
XTAP_TAPCELL_ROW_45_788 VGND VPWR sky130_fd_sc_hd__tapvpwrvgnd_1
XFILLER_15_495 VGND VGND VPWR VPWR sky130_fd_sc_hd__decap_8
XFILLER_30_421 VPWR VGND VPWR VGND sky130_ef_sc_hd__decap_12
XTAP_TAPCELL_ROW_45_799 VGND VPWR sky130_fd_sc_hd__tapvpwrvgnd_1
XFILLER_8_65 VPWR VGND VPWR VGND sky130_ef_sc_hd__decap_12
X_4560_ net510 net292 VGND VGND VPWR VPWR _4324_ sky130_fd_sc_hd__nand2_1
XFILLER_8_98 VGND VGND VPWR VPWR sky130_fd_sc_hd__fill_2
X_4491_ _4258_ VGND VGND VPWR VPWR _4259_ sky130_fd_sc_hd__inv_2
X_6230_ _1755_ _1756_ _1720_ _1721_ VGND VGND VPWR VPWR _1759_ sky130_fd_sc_hd__a211o_1
XTAP_TAPCELL_ROW_77_1178 VGND VPWR sky130_fd_sc_hd__tapvpwrvgnd_1
XFILLER_6_182 VGND VGND VPWR VPWR sky130_fd_sc_hd__decap_8
X_6161_ _1650_ _1651_ _1689_ _1690_ VGND VGND VPWR VPWR _1692_ sky130_fd_sc_hd__o211ai_1
XTAP_TAPCELL_ROW_90_1334 VGND VPWR sky130_fd_sc_hd__tapvpwrvgnd_1
X_5112_ net205 _0850_ _0851_ VGND VGND VPWR VPWR _0852_ sky130_fd_sc_hd__nand3_1
XFILLER_111_253 VPWR VGND VPWR VGND sky130_ef_sc_hd__decap_12
XFILLER_97_454 VPWR VGND VPWR VGND sky130_ef_sc_hd__decap_12
X_6092_ _1621_ _1622_ _1609_ VGND VGND VPWR VPWR _1625_ sky130_fd_sc_hd__a21oi_1
XFILLER_69_167 VGND VGND VPWR VPWR sky130_fd_sc_hd__fill_1
X_5043_ net414 _0785_ VGND VGND VPWR VPWR _0028_ sky130_fd_sc_hd__nor2_1
X_8802_ _4142_ _4145_ _4171_ VGND VGND VPWR VPWR _4173_ sky130_fd_sc_hd__or3_1
XFILLER_80_321 VGND VGND VPWR VPWR sky130_fd_sc_hd__decap_4
XFILLER_25_237 VPWR VGND VPWR VGND sky130_ef_sc_hd__decap_12
X_6994_ net270 _2460_ _2461_ VGND VGND VPWR VPWR _2462_ sky130_fd_sc_hd__nor3_1
X_8733_ _4104_ _4105_ VGND VGND VPWR VPWR _4106_ sky130_fd_sc_hd__nor2_1
XFILLER_80_365 VGND VGND VPWR VPWR sky130_fd_sc_hd__decap_8
X_5945_ _1479_ _1480_ VGND VGND VPWR VPWR _1481_ sky130_fd_sc_hd__xor2_1
X_8664_ pe_array\[2\].u_pe.accum_reg\[26\] _3508_ VGND VGND VPWR VPWR _4039_ sky130_fd_sc_hd__nor2_1
XFILLER_80_398 VGND VGND VPWR VPWR sky130_fd_sc_hd__decap_3
X_5876_ _1380_ net605 VGND VGND VPWR VPWR _1414_ sky130_fd_sc_hd__xnor2_1
X_4827_ _0522_ _0524_ _0572_ _0573_ VGND VGND VPWR VPWR _0575_ sky130_fd_sc_hd__o211ai_1
X_7615_ _3035_ _3064_ VGND VGND VPWR VPWR _3065_ sky130_fd_sc_hd__nand2_1
X_8595_ _3944_ _3942_ VGND VGND VPWR VPWR _3973_ sky130_fd_sc_hd__nor2_2
X_4758_ _0473_ _0474_ _0471_ VGND VGND VPWR VPWR _0507_ sky130_fd_sc_hd__a21oi_1
X_7546_ _2996_ _2997_ VGND VGND VPWR VPWR _2998_ sky130_fd_sc_hd__and2b_1
XFILLER_107_526 VPWR VGND VPWR VGND sky130_ef_sc_hd__decap_12
X_7477_ _2931_ net425 VGND VGND VPWR VPWR _0316_ sky130_fd_sc_hd__nor2_1
X_4689_ net741 _0437_ net293 VGND VGND VPWR VPWR _0440_ sky130_fd_sc_hd__and3b_1
X_6428_ net411 pe_array\[0\].u_pe.accum_reg\[22\] net241 _1950_ VGND VGND VPWR VPWR
+ _1951_ sky130_fd_sc_hd__o2bb2a_1
X_9216_ clknet_leaf_31_clk _0328_ VGND VGND VPWR VPWR pe_accum\[1\]\[2\] sky130_fd_sc_hd__dfxtp_1
XFILLER_108_77 VGND VGND VPWR VPWR sky130_fd_sc_hd__decap_6
X_9147_ clknet_leaf_21_clk _0259_ VGND VGND VPWR VPWR pe_accum\[0\]\[1\] sky130_fd_sc_hd__dfxtp_1
X_6359_ _1853_ _1855_ VGND VGND VPWR VPWR _1884_ sky130_fd_sc_hd__and2b_1
XFILLER_88_421 VGND VGND VPWR VPWR sky130_fd_sc_hd__decap_4
X_9078_ clknet_leaf_59_clk _0190_ VGND VGND VPWR VPWR net27 sky130_fd_sc_hd__dfxtp_1
XFILLER_48_307 VGND VGND VPWR VPWR sky130_fd_sc_hd__fill_1
XTAP_TAPCELL_ROW_110_1570 VGND VPWR sky130_fd_sc_hd__tapvpwrvgnd_1
XFILLER_76_638 VGND VGND VPWR VPWR sky130_fd_sc_hd__decap_6
X_8029_ _3418_ net312 net443 _3419_ VGND VGND VPWR VPWR _3422_ sky130_fd_sc_hd__and4_4
XFILLER_90_129 VGND VGND VPWR VPWR sky130_fd_sc_hd__decap_8
XTAP_TAPCELL_ROW_14_416 VGND VPWR sky130_fd_sc_hd__tapvpwrvgnd_1
XFILLER_12_421 VPWR VGND VPWR VGND sky130_ef_sc_hd__decap_12
XTAP_TAPCELL_ROW_14_427 VGND VPWR sky130_fd_sc_hd__tapvpwrvgnd_1
XFILLER_24_270 VPWR VGND VPWR VGND sky130_ef_sc_hd__decap_12
XFILLER_8_403 VPWR VGND VPWR VGND sky130_ef_sc_hd__decap_12
XTAP_TAPCELL_ROW_42_758 VGND VPWR sky130_fd_sc_hd__tapvpwrvgnd_1
XFILLER_12_465 VGND VGND VPWR VPWR sky130_fd_sc_hd__fill_2
XFILLER_8_469 VGND VGND VPWR VPWR sky130_fd_sc_hd__decap_6
XFILLER_106_581 VGND VGND VPWR VPWR sky130_fd_sc_hd__decap_6
XFILLER_79_432 VGND VGND VPWR VPWR sky130_fd_sc_hd__fill_1
XFILLER_94_457 VPWR VGND VPWR VGND sky130_ef_sc_hd__decap_12
XFILLER_90_652 VGND VGND VPWR VPWR sky130_fd_sc_hd__decap_4
XFILLER_62_365 VGND VGND VPWR VPWR sky130_fd_sc_hd__fill_2
XFILLER_95_3 VGND VGND VPWR VPWR sky130_fd_sc_hd__decap_4
X_5730_ _1268_ _1269_ net498 net354 VGND VGND VPWR VPWR _1272_ sky130_fd_sc_hd__a2bb2o_1
XFILLER_15_270 VGND VGND VPWR VPWR sky130_fd_sc_hd__decap_3
XFILLER_22_218 VGND VGND VPWR VPWR sky130_fd_sc_hd__decap_6
XTAP_TAPCELL_ROW_79_1207 VGND VPWR sky130_fd_sc_hd__tapvpwrvgnd_1
X_7400_ _2854_ _2855_ _2824_ _2825_ VGND VGND VPWR VPWR _2857_ sky130_fd_sc_hd__a211o_1
X_5661_ net1007 net363 VGND VGND VPWR VPWR _0202_ sky130_fd_sc_hd__and2_1
X_8380_ _3404_ _3489_ _3619_ _3763_ VGND VGND VPWR VPWR _3765_ sky130_fd_sc_hd__a31o_4
X_5592_ net985 net372 VGND VGND VPWR VPWR _0133_ sky130_fd_sc_hd__and2_1
X_4612_ net521 _4372_ _4366_ VGND VGND VPWR VPWR _4375_ sky130_fd_sc_hd__a21o_1
X_7331_ _2790_ _2766_ VGND VGND VPWR VPWR _2791_ sky130_fd_sc_hd__xnor2_2
X_4543_ _4278_ _4279_ net579 _4307_ VGND VGND VPWR VPWR _4308_ sky130_fd_sc_hd__o211ai_2
XFILLER_116_345 VGND VGND VPWR VPWR sky130_fd_sc_hd__fill_1
Xhold403 pe_accum\[2\]\[6\] VGND VGND VPWR VPWR net918 sky130_fd_sc_hd__dlygate4sd3_1
Xhold436 pe_accum\[1\]\[20\] VGND VGND VPWR VPWR net951 sky130_fd_sc_hd__dlygate4sd3_1
Xhold425 pe_accum\[1\]\[14\] VGND VGND VPWR VPWR net940 sky130_fd_sc_hd__dlygate4sd3_1
X_7262_ _2720_ _2721_ _2722_ VGND VGND VPWR VPWR _2724_ sky130_fd_sc_hd__a21o_1
Xhold414 pe_accum\[3\]\[14\] VGND VGND VPWR VPWR net929 sky130_fd_sc_hd__dlygate4sd3_1
X_9001_ clknet_leaf_22_clk _0113_ VGND VGND VPWR VPWR net69 sky130_fd_sc_hd__dfxtp_1
XFILLER_104_529 VGND VGND VPWR VPWR sky130_fd_sc_hd__decap_3
Xhold469 pe_accum\[2\]\[23\] VGND VGND VPWR VPWR net984 sky130_fd_sc_hd__dlygate4sd3_1
XFILLER_89_218 VGND VGND VPWR VPWR sky130_fd_sc_hd__decap_6
X_6213_ _1711_ _1713_ _1708_ VGND VGND VPWR VPWR _1743_ sky130_fd_sc_hd__a21bo_1
Xhold458 pe_accum\[3\]\[2\] VGND VGND VPWR VPWR net973 sky130_fd_sc_hd__dlygate4sd3_1
Xhold447 pe_accum\[1\]\[13\] VGND VGND VPWR VPWR net962 sky130_fd_sc_hd__dlygate4sd3_1
X_4474_ net507 pe_array\[3\].u_pe.tap_count\[1\] pe_array\[3\].u_pe.tap_count\[0\]
+ VGND VGND VPWR VPWR _4246_ sky130_fd_sc_hd__and3_1
X_7193_ _2656_ _2654_ VGND VGND VPWR VPWR _2657_ sky130_fd_sc_hd__xnor2_4
XFILLER_112_562 VPWR VGND VPWR VGND sky130_ef_sc_hd__decap_12
XFILLER_97_251 VPWR VGND VPWR VGND sky130_ef_sc_hd__decap_12
X_6144_ _1671_ _1674_ _1675_ VGND VGND VPWR VPWR _1676_ sky130_fd_sc_hd__o21ai_1
X_6075_ _1598_ _1607_ VGND VGND VPWR VPWR _1608_ sky130_fd_sc_hd__nand2b_1
XFILLER_38_29 VPWR VGND VPWR VGND sky130_ef_sc_hd__decap_12
XFILLER_57_159 VGND VGND VPWR VPWR sky130_fd_sc_hd__decap_8
X_5026_ _0766_ _0767_ net180 VGND VGND VPWR VPWR _0769_ sky130_fd_sc_hd__a21o_1
XFILLER_81_652 VPWR VGND VPWR VGND sky130_ef_sc_hd__decap_12
XFILLER_26_557 VGND VGND VPWR VPWR sky130_fd_sc_hd__fill_1
X_6977_ _2408_ _2411_ _2409_ VGND VGND VPWR VPWR _2445_ sky130_fd_sc_hd__o21ba_1
X_8716_ net420 _4089_ VGND VGND VPWR VPWR _0397_ sky130_fd_sc_hd__nor2_1
XFILLER_81_685 VPWR VGND VPWR VGND sky130_ef_sc_hd__decap_12
X_5928_ net432 _1464_ VGND VGND VPWR VPWR _0234_ sky130_fd_sc_hd__nor2_1
X_8647_ net162 _4022_ VGND VGND VPWR VPWR _4023_ sky130_fd_sc_hd__nor2_1
X_5859_ _1393_ _1396_ VGND VGND VPWR VPWR _1397_ sky130_fd_sc_hd__xnor2_1
X_8578_ _3953_ _3954_ net191 VGND VGND VPWR VPWR _3956_ sky130_fd_sc_hd__a21o_1
XFILLER_5_417 VPWR VGND VPWR VGND sky130_ef_sc_hd__decap_12
X_7529_ net156 _2981_ VGND VGND VPWR VPWR _2982_ sky130_fd_sc_hd__xnor2_1
XFILLER_103_573 VPWR VGND VPWR VGND sky130_ef_sc_hd__decap_12
XFILLER_95_79 VGND VGND VPWR VPWR sky130_fd_sc_hd__fill_1
XFILLER_29_362 VGND VGND VPWR VPWR sky130_fd_sc_hd__fill_1
XTAP_TAPCELL_ROW_47_817 VGND VPWR sky130_fd_sc_hd__tapvpwrvgnd_1
XFILLER_91_449 VGND VGND VPWR VPWR sky130_fd_sc_hd__decap_4
XTAP_TAPCELL_ROW_63_1008 VGND VPWR sky130_fd_sc_hd__tapvpwrvgnd_1
XTAP_TAPCELL_ROW_27_574 VGND VPWR sky130_fd_sc_hd__tapvpwrvgnd_1
XFILLER_44_376 VGND VGND VPWR VPWR sky130_fd_sc_hd__fill_1
XFILLER_71_195 VGND VGND VPWR VPWR sky130_fd_sc_hd__fill_1
XFILLER_44_83 VGND VGND VPWR VPWR sky130_fd_sc_hd__fill_1
XFILLER_117_109 VGND VGND VPWR VPWR sky130_fd_sc_hd__decap_3
XFILLER_99_505 VGND VGND VPWR VPWR sky130_fd_sc_hd__fill_2
XTAP_TAPCELL_ROW_74_1137 VGND VPWR sky130_fd_sc_hd__tapvpwrvgnd_1
XFILLER_5_55 VGND VGND VPWR VPWR sky130_fd_sc_hd__fill_1
XFILLER_113_337 VPWR VGND VPWR VGND sky130_ef_sc_hd__decap_12
XFILLER_94_221 VPWR VGND VPWR VGND sky130_ef_sc_hd__decap_12
XFILLER_10_3 VPWR VGND VPWR VGND sky130_ef_sc_hd__decap_12
XFILLER_94_287 VGND VGND VPWR VPWR sky130_fd_sc_hd__fill_1
X_7880_ _3273_ _3276_ VGND VGND VPWR VPWR _3277_ sky130_fd_sc_hd__nor2_1
X_6900_ pe_array\[1\].u_pe.accum_reg\[7\] pe_array\[1\].u_pe.weight_in\[7\] VGND VGND
+ VPWR VPWR _2370_ sky130_fd_sc_hd__xnor2_1
XFILLER_35_310 VGND VGND VPWR VPWR sky130_fd_sc_hd__decap_8
XFILLER_63_652 VGND VGND VPWR VPWR sky130_fd_sc_hd__decap_4
X_6831_ _2302_ VGND VGND VPWR VPWR _2303_ sky130_fd_sc_hd__inv_2
XTAP_TAPCELL_ROW_85_1277 VGND VPWR sky130_fd_sc_hd__tapvpwrvgnd_1
X_8501_ _3880_ _3851_ _3823_ _3881_ _3850_ VGND VGND VPWR VPWR _3882_ sky130_fd_sc_hd__a311o_2
X_6762_ net412 pe_array\[1\].u_pe.accum_reg\[2\] net231 _2236_ VGND VGND VPWR VPWR
+ _2237_ sky130_fd_sc_hd__o2bb2a_1
X_6693_ net901 net233 _1342_ net242 VGND VGND VPWR VPWR _0263_ sky130_fd_sc_hd__o2bb2ai_1
X_5713_ net505 net354 _1253_ _1254_ VGND VGND VPWR VPWR _1256_ sky130_fd_sc_hd__o2bb2a_1
X_8432_ _3811_ _3812_ _3813_ VGND VGND VPWR VPWR _3815_ sky130_fd_sc_hd__a21o_1
X_5644_ net923 net371 VGND VGND VPWR VPWR _0185_ sky130_fd_sc_hd__and2_1
X_8363_ _3745_ _3746_ _3747_ VGND VGND VPWR VPWR _3748_ sky130_fd_sc_hd__nand3_1
X_5575_ net942 net392 VGND VGND VPWR VPWR _0116_ sky130_fd_sc_hd__and2_1
X_7314_ _2770_ _2771_ _2731_ _2733_ VGND VGND VPWR VPWR _2774_ sky130_fd_sc_hd__a211o_1
X_8294_ net189 _3641_ _3639_ VGND VGND VPWR VPWR _3681_ sky130_fd_sc_hd__a21o_1
XFILLER_2_409 VGND VGND VPWR VPWR sky130_fd_sc_hd__decap_8
X_4526_ _4289_ _4290_ _4265_ VGND VGND VPWR VPWR _4292_ sky130_fd_sc_hd__a21o_1
X_4457_ pe_array\[2\].u_pe.weight_in\[7\] VGND VGND VPWR VPWR _4238_ sky130_fd_sc_hd__inv_2
X_7245_ _2668_ _2669_ _2705_ _2706_ VGND VGND VPWR VPWR _2707_ sky130_fd_sc_hd__o211a_1
XFILLER_98_560 VGND VGND VPWR VPWR sky130_fd_sc_hd__decap_4
X_7176_ _2637_ _2638_ net195 VGND VGND VPWR VPWR _2640_ sky130_fd_sc_hd__a21o_1
XFILLER_49_39 VPWR VGND VPWR VGND sky130_ef_sc_hd__decap_12
X_6127_ net200 _1617_ _1615_ VGND VGND VPWR VPWR _1659_ sky130_fd_sc_hd__a21o_1
XFILLER_58_457 VPWR VGND VPWR VGND sky130_ef_sc_hd__decap_12
XFILLER_100_587 VGND VGND VPWR VPWR sky130_fd_sc_hd__fill_1
X_6058_ _1590_ _1591_ VGND VGND VPWR VPWR _1592_ sky130_fd_sc_hd__nor2_1
XFILLER_65_27 VPWR VGND VPWR VGND sky130_ef_sc_hd__decap_12
XFILLER_45_107 VGND VGND VPWR VPWR sky130_fd_sc_hd__decap_4
XFILLER_46_619 VGND VGND VPWR VPWR sky130_fd_sc_hd__decap_6
Xclkbuf_leaf_65_clk clknet_3_0__leaf_clk VGND VGND VPWR VPWR clknet_leaf_65_clk sky130_fd_sc_hd__clkbuf_8
X_5009_ net283 _0750_ _0751_ VGND VGND VPWR VPWR _0752_ sky130_fd_sc_hd__nor3_1
XTAP_TAPCELL_ROW_24_544 VGND VPWR sky130_fd_sc_hd__tapvpwrvgnd_1
XTAP_TAPCELL_ROW_52_875 VGND VPWR sky130_fd_sc_hd__tapvpwrvgnd_1
XFILLER_14_97 VPWR VGND VPWR VGND sky130_ef_sc_hd__decap_12
XFILLER_108_621 VGND VGND VPWR VPWR sky130_fd_sc_hd__decap_6
Xrebuffer352 _3549_ VGND VGND VPWR VPWR net867 sky130_fd_sc_hd__buf_2
XFILLER_30_85 VGND VGND VPWR VPWR sky130_fd_sc_hd__decap_8
XFILLER_110_307 VGND VGND VPWR VPWR sky130_fd_sc_hd__fill_1
XFILLER_1_497 VGND VGND VPWR VPWR sky130_fd_sc_hd__decap_6
XFILLER_64_405 VGND VGND VPWR VPWR sky130_fd_sc_hd__decap_8
XFILLER_49_479 VGND VGND VPWR VPWR sky130_fd_sc_hd__fill_2
XPHY_EDGE_ROW_101_Right_101 VGND VGND VPWR VPWR sky130_fd_sc_hd__decap_3
XFILLER_45_641 VGND VGND VPWR VPWR sky130_fd_sc_hd__decap_3
XFILLER_72_471 VGND VGND VPWR VPWR sky130_fd_sc_hd__decap_4
XFILLER_55_93 VPWR VGND VPWR VGND sky130_ef_sc_hd__decap_12
XFILLER_58_3 VPWR VGND VPWR VGND sky130_ef_sc_hd__decap_12
X_5360_ _1060_ _1087_ VGND VGND VPWR VPWR _1091_ sky130_fd_sc_hd__or2_1
XFILLER_114_613 VPWR VGND VPWR VGND sky130_ef_sc_hd__decap_12
X_5291_ net748 _1023_ VGND VGND VPWR VPWR _1025_ sky130_fd_sc_hd__xnor2_1
XFILLER_114_657 VPWR VGND VPWR VGND sky130_ef_sc_hd__decap_12
X_7030_ _2487_ _2495_ VGND VGND VPWR VPWR _2497_ sky130_fd_sc_hd__xnor2_1
X_8981_ clknet_leaf_22_clk _0093_ VGND VGND VPWR VPWR net127 sky130_fd_sc_hd__dfxtp_1
XFILLER_82_224 VPWR VGND VPWR VGND sky130_ef_sc_hd__decap_12
X_7932_ net486 net319 pe_array\[2\].u_pe.accum_reg\[6\] VGND VGND VPWR VPWR _3327_
+ sky130_fd_sc_hd__a21o_1
XFILLER_55_449 VGND VGND VPWR VPWR sky130_fd_sc_hd__fill_2
Xclkbuf_leaf_47_clk clknet_3_2__leaf_clk VGND VGND VPWR VPWR clknet_leaf_47_clk sky130_fd_sc_hd__clkbuf_8
X_7863_ _3258_ _3259_ VGND VGND VPWR VPWR _3261_ sky130_fd_sc_hd__or2_1
X_6814_ _2284_ _2285_ VGND VGND VPWR VPWR _2286_ sky130_fd_sc_hd__nor2_1
X_7794_ net21 net11 net12 net418 VGND VGND VPWR VPWR _3207_ sky130_fd_sc_hd__a31oi_4
X_6745_ _2211_ _2219_ VGND VGND VPWR VPWR _2221_ sky130_fd_sc_hd__xnor2_1
XTAP_TAPCELL_ROW_21_503 VGND VPWR sky130_fd_sc_hd__tapvpwrvgnd_1
XTAP_TAPCELL_ROW_98_1435 VGND VPWR sky130_fd_sc_hd__tapvpwrvgnd_1
XTAP_TAPCELL_ROW_98_1424 VGND VPWR sky130_fd_sc_hd__tapvpwrvgnd_1
X_6676_ pe_array\[0\].u_pe.accum_reg\[30\] net275 _2189_ VGND VGND VPWR VPWR _2190_
+ sky130_fd_sc_hd__o21ai_1
X_8415_ net441 net315 pe_array\[2\].u_pe.accum_reg\[18\] VGND VGND VPWR VPWR _3798_
+ sky130_fd_sc_hd__a21oi_1
X_5627_ net937 net381 VGND VGND VPWR VPWR _0168_ sky130_fd_sc_hd__and2_1
XFILLER_117_462 VGND VGND VPWR VPWR sky130_fd_sc_hd__decap_3
X_8346_ net419 _3731_ VGND VGND VPWR VPWR _0385_ sky130_fd_sc_hd__nor2_1
X_5558_ net895 net390 VGND VGND VPWR VPWR _0099_ sky130_fd_sc_hd__and2_1
XFILLER_105_613 VGND VGND VPWR VPWR sky130_fd_sc_hd__decap_3
X_8277_ net440 _4238_ _3624_ _3625_ VGND VGND VPWR VPWR _3664_ sky130_fd_sc_hd__o22a_4
X_4509_ net408 pe_array\[3\].u_pe.accum_reg\[2\] net257 _4275_ VGND VGND VPWR VPWR
+ _4276_ sky130_fd_sc_hd__o2bb2a_1
XFILLER_78_519 VGND VGND VPWR VPWR sky130_fd_sc_hd__fill_2
X_7228_ _2689_ _2690_ VGND VGND VPWR VPWR _2691_ sky130_fd_sc_hd__and2_1
X_5489_ net254 _0595_ VGND VGND VPWR VPWR _1205_ sky130_fd_sc_hd__nand2_1
Xfanout510 net511 VGND VGND VPWR VPWR net510 sky130_fd_sc_hd__buf_4
XFILLER_116_77 VGND VGND VPWR VPWR sky130_fd_sc_hd__decap_6
XFILLER_98_390 VGND VGND VPWR VPWR sky130_fd_sc_hd__decap_6
X_7159_ net452 net328 net326 VGND VGND VPWR VPWR _2623_ sky130_fd_sc_hd__and3_1
XFILLER_58_265 VGND VGND VPWR VPWR sky130_fd_sc_hd__fill_2
XTAP_TAPCELL_ROW_29_603 VGND VPWR sky130_fd_sc_hd__tapvpwrvgnd_1
XFILLER_100_384 VGND VGND VPWR VPWR sky130_fd_sc_hd__decap_3
XTAP_TAPCELL_ROW_57_934 VGND VPWR sky130_fd_sc_hd__tapvpwrvgnd_1
XFILLER_27_630 VPWR VGND VPWR VGND sky130_ef_sc_hd__decap_12
XFILLER_46_449 VPWR VGND VPWR VGND sky130_ef_sc_hd__decap_12
XTAP_TAPCELL_ROW_107_1542 VGND VPWR sky130_fd_sc_hd__tapvpwrvgnd_1
XFILLER_61_408 VGND VGND VPWR VPWR sky130_fd_sc_hd__decap_8
XTAP_TAPCELL_ROW_1_261 VGND VPWR sky130_fd_sc_hd__tapvpwrvgnd_1
XFILLER_27_663 VGND VGND VPWR VPWR sky130_fd_sc_hd__decap_3
Xclkbuf_leaf_38_clk clknet_3_3__leaf_clk VGND VGND VPWR VPWR clknet_leaf_38_clk sky130_fd_sc_hd__clkbuf_8
Xrebuffer81 net459 VGND VGND VPWR VPWR net596 sky130_fd_sc_hd__buf_6
XFILLER_73_279 VGND VGND VPWR VPWR sky130_fd_sc_hd__fill_1
Xrebuffer70 _0539_ VGND VGND VPWR VPWR net585 sky130_fd_sc_hd__buf_2
Xrebuffer92 _2184_ VGND VGND VPWR VPWR net607 sky130_fd_sc_hd__clkbuf_2
XPHY_EDGE_ROW_1_Left_119 VGND VGND VPWR VPWR sky130_fd_sc_hd__decap_3
XFILLER_41_165 VGND VGND VPWR VPWR sky130_fd_sc_hd__decap_3
XFILLER_10_530 VGND VGND VPWR VPWR sky130_fd_sc_hd__fill_2
XFILLER_6_512 VGND VGND VPWR VPWR sky130_fd_sc_hd__decap_8
XFILLER_41_51 VGND VGND VPWR VPWR sky130_fd_sc_hd__decap_4
Xrebuffer160 net678 VGND VGND VPWR VPWR net675 sky130_fd_sc_hd__buf_6
XFILLER_6_556 VGND VGND VPWR VPWR sky130_fd_sc_hd__decap_3
Xrebuffer171 _0672_ VGND VGND VPWR VPWR net686 sky130_fd_sc_hd__dlymetal6s2s_1
XTAP_TAPCELL_ROW_71_1107 VGND VPWR sky130_fd_sc_hd__tapvpwrvgnd_1
XTAP_TAPCELL_ROW_9_361 VGND VPWR sky130_fd_sc_hd__tapvpwrvgnd_1
XFILLER_92_533 VGND VGND VPWR VPWR sky130_fd_sc_hd__fill_1
XFILLER_37_449 VGND VGND VPWR VPWR sky130_fd_sc_hd__fill_1
Xclkbuf_leaf_29_clk clknet_3_6__leaf_clk VGND VGND VPWR VPWR clknet_leaf_29_clk sky130_fd_sc_hd__clkbuf_8
XFILLER_64_268 VPWR VGND VPWR VGND sky130_ef_sc_hd__decap_12
XFILLER_64_235 VGND VGND VPWR VPWR sky130_fd_sc_hd__decap_6
XFILLER_52_408 VGND VGND VPWR VPWR sky130_fd_sc_hd__decap_4
XFILLER_18_630 VPWR VGND VPWR VGND sky130_ef_sc_hd__decap_12
XFILLER_45_471 VGND VGND VPWR VPWR sky130_fd_sc_hd__fill_1
XTAP_TAPCELL_ROW_82_1236 VGND VPWR sky130_fd_sc_hd__tapvpwrvgnd_1
X_4860_ _0599_ _0605_ VGND VGND VPWR VPWR _0607_ sky130_fd_sc_hd__xnor2_1
XFILLER_82_91 VGND VGND VPWR VPWR sky130_fd_sc_hd__fill_1
XFILLER_20_305 VGND VGND VPWR VPWR sky130_fd_sc_hd__decap_3
X_6530_ _2048_ _2047_ VGND VGND VPWR VPWR _2049_ sky130_fd_sc_hd__and2b_1
XFILLER_20_316 VPWR VGND VPWR VGND sky130_ef_sc_hd__decap_12
X_4791_ _0476_ _0478_ _0537_ _0539_ VGND VGND VPWR VPWR _0540_ sky130_fd_sc_hd__a211o_4
X_6461_ _1941_ _1973_ _1981_ VGND VGND VPWR VPWR _1982_ sky130_fd_sc_hd__a21bo_1
X_6392_ _1915_ _1914_ VGND VGND VPWR VPWR _1916_ sky130_fd_sc_hd__and2b_1
X_9180_ clknet_leaf_31_clk _0292_ VGND VGND VPWR VPWR pe_array\[1\].u_pe.tap_count\[2\]
+ sky130_fd_sc_hd__dfxtp_1
X_8200_ _3539_ _3541_ _3540_ VGND VGND VPWR VPWR _3589_ sky130_fd_sc_hd__o21ba_1
X_5412_ _1109_ _1111_ _1140_ VGND VGND VPWR VPWR _1142_ sky130_fd_sc_hd__nor3_1
Xoutput113 net113 VGND VGND VPWR VPWR result_data[67] sky130_fd_sc_hd__buf_2
XFILLER_114_421 VGND VGND VPWR VPWR sky130_fd_sc_hd__decap_6
Xoutput124 net124 VGND VGND VPWR VPWR result_data[77] sky130_fd_sc_hd__buf_2
X_8131_ _3504_ _3519_ _3520_ VGND VGND VPWR VPWR _3522_ sky130_fd_sc_hd__nand3_1
X_5343_ _1044_ _1046_ _1073_ VGND VGND VPWR VPWR _1075_ sky130_fd_sc_hd__nor3_1
Xoutput102 net102 VGND VGND VPWR VPWR result_data[57] sky130_fd_sc_hd__buf_2
XFILLER_114_443 VGND VGND VPWR VPWR sky130_fd_sc_hd__decap_3
XFILLER_99_143 VGND VGND VPWR VPWR sky130_fd_sc_hd__fill_1
XTAP_TAPCELL_ROW_93_1365 VGND VPWR sky130_fd_sc_hd__tapvpwrvgnd_1
Xoutput135 net135 VGND VGND VPWR VPWR result_data[87] sky130_fd_sc_hd__buf_2
Xoutput146 net146 VGND VGND VPWR VPWR result_data[97] sky130_fd_sc_hd__buf_2
X_8062_ net477 net310 net308 net483 VGND VGND VPWR VPWR _3454_ sky130_fd_sc_hd__a22oi_1
X_5274_ _0973_ _1007_ VGND VGND VPWR VPWR _1009_ sky130_fd_sc_hd__xnor2_1
X_7013_ _2396_ _2430_ _2429_ VGND VGND VPWR VPWR _2481_ sky130_fd_sc_hd__a21boi_1
XFILLER_110_693 VGND VGND VPWR VPWR sky130_fd_sc_hd__decap_3
XFILLER_46_29 VPWR VGND VPWR VGND sky130_ef_sc_hd__decap_12
X_8964_ clknet_leaf_22_clk _0076_ VGND VGND VPWR VPWR net150 sky130_fd_sc_hd__dfxtp_1
XTAP_TAPCELL_ROW_54_904 VGND VPWR sky130_fd_sc_hd__tapvpwrvgnd_1
X_7915_ _3305_ _3307_ _3310_ VGND VGND VPWR VPWR _3311_ sky130_fd_sc_hd__and3_1
X_8895_ clknet_leaf_17_clk _0007_ VGND VGND VPWR VPWR pe_array\[0\].u_pe.weight_in\[7\]
+ sky130_fd_sc_hd__dfxtp_1
X_7846_ net422 _3244_ VGND VGND VPWR VPWR _0372_ sky130_fd_sc_hd__nor2_1
XFILLER_23_110 VGND VGND VPWR VPWR sky130_fd_sc_hd__fill_2
XFILLER_51_452 VPWR VGND VPWR VGND sky130_ef_sc_hd__decap_12
XTAP_TAPCELL_ROW_34_661 VGND VPWR sky130_fd_sc_hd__tapvpwrvgnd_1
XTAP_TAPCELL_ROW_102_1472 VGND VPWR sky130_fd_sc_hd__tapvpwrvgnd_1
XTAP_TAPCELL_ROW_62_992 VGND VPWR sky130_fd_sc_hd__tapvpwrvgnd_1
X_7777_ net222 _2990_ VGND VGND VPWR VPWR _3198_ sky130_fd_sc_hd__nand2_2
X_4989_ net184 _0731_ _0732_ VGND VGND VPWR VPWR _0733_ sky130_fd_sc_hd__or3_4
XTAP_TAPCELL_ROW_102_1483 VGND VPWR sky130_fd_sc_hd__tapvpwrvgnd_1
X_6728_ pe_array\[1\].u_pe.tap_count\[2\] _2206_ VGND VGND VPWR VPWR _2207_ sky130_fd_sc_hd__and2_1
XFILLER_11_349 VPWR VGND VPWR VGND sky130_ef_sc_hd__decap_12
X_6659_ _2140_ _2143_ _2173_ VGND VGND VPWR VPWR _2174_ sky130_fd_sc_hd__o21a_1
X_8329_ _3711_ _3712_ _3713_ VGND VGND VPWR VPWR _3715_ sky130_fd_sc_hd__a21oi_1
XFILLER_11_65 VGND VGND VPWR VPWR sky130_fd_sc_hd__decap_3
XFILLER_117_281 VGND VGND VPWR VPWR sky130_fd_sc_hd__fill_2
XFILLER_105_421 VGND VGND VPWR VPWR sky130_fd_sc_hd__fill_2
XFILLER_3_559 VGND VGND VPWR VPWR sky130_fd_sc_hd__fill_1
XFILLER_105_498 VGND VGND VPWR VPWR sky130_fd_sc_hd__decap_6
XTAP_TAPCELL_ROW_6_331 VGND VPWR sky130_fd_sc_hd__tapvpwrvgnd_1
XTAP_TAPCELL_ROW_6_320 VGND VPWR sky130_fd_sc_hd__tapvpwrvgnd_1
Xfanout340 pe_array\[1\].u_pe.weight_in\[0\] VGND VGND VPWR VPWR net340 sky130_fd_sc_hd__buf_2
Xfanout384 net389 VGND VGND VPWR VPWR net384 sky130_fd_sc_hd__buf_1
Xfanout351 pe_array\[0\].u_pe.weight_in\[3\] VGND VGND VPWR VPWR net351 sky130_fd_sc_hd__clkbuf_2
Xfanout362 pe_array\[0\].u_pe.weight_in\[0\] VGND VGND VPWR VPWR net362 sky130_fd_sc_hd__clkbuf_2
XFILLER_19_405 VPWR VGND VPWR VGND sky130_ef_sc_hd__decap_12
Xfanout373 net375 VGND VGND VPWR VPWR net373 sky130_fd_sc_hd__clkbuf_2
XFILLER_101_671 VGND VGND VPWR VPWR sky130_fd_sc_hd__fill_1
XFILLER_100_170 VPWR VGND VPWR VGND sky130_ef_sc_hd__decap_12
Xfanout395 net396 VGND VGND VPWR VPWR net395 sky130_fd_sc_hd__buf_2
XFILLER_19_449 VGND VGND VPWR VPWR sky130_fd_sc_hd__fill_2
XFILLER_61_216 VGND VGND VPWR VPWR sky130_fd_sc_hd__fill_1
XFILLER_27_482 VPWR VGND VPWR VGND sky130_ef_sc_hd__decap_12
XFILLER_52_83 VGND VGND VPWR VPWR sky130_fd_sc_hd__fill_1
Xinput15 weight_din[2] VGND VGND VPWR VPWR net15 sky130_fd_sc_hd__buf_2
XFILLER_10_360 VGND VGND VPWR VPWR sky130_fd_sc_hd__decap_4
XTAP_TAPCELL_ROW_12_399 VGND VPWR sky130_fd_sc_hd__tapvpwrvgnd_1
XFILLER_115_229 VGND VGND VPWR VPWR sky130_fd_sc_hd__fill_1
XFILLER_108_281 VPWR VGND VPWR VGND sky130_ef_sc_hd__decap_12
XFILLER_97_636 VGND VGND VPWR VPWR sky130_fd_sc_hd__fill_1
XFILLER_77_393 VPWR VGND VPWR VGND sky130_ef_sc_hd__decap_12
XFILLER_65_533 VPWR VGND VPWR VGND sky130_ef_sc_hd__decap_12
XFILLER_92_341 VGND VGND VPWR VPWR sky130_fd_sc_hd__decap_8
XFILLER_92_363 VGND VGND VPWR VPWR sky130_fd_sc_hd__fill_1
XFILLER_80_503 VGND VGND VPWR VPWR sky130_fd_sc_hd__decap_3
X_5961_ _1450_ _1452_ _1496_ _1494_ VGND VGND VPWR VPWR _1497_ sky130_fd_sc_hd__a211o_1
X_8680_ _4054_ _4053_ VGND VGND VPWR VPWR _4055_ sky130_fd_sc_hd__and2b_1
XFILLER_52_238 VGND VGND VPWR VPWR sky130_fd_sc_hd__decap_6
X_4912_ _0611_ _0612_ _0656_ _0657_ VGND VGND VPWR VPWR _0658_ sky130_fd_sc_hd__o211a_1
X_7700_ _3116_ _3119_ _3146_ VGND VGND VPWR VPWR _3147_ sky130_fd_sc_hd__o21a_1
X_5892_ _1423_ _1428_ VGND VGND VPWR VPWR _1429_ sky130_fd_sc_hd__nand2b_1
XFILLER_33_463 VGND VGND VPWR VPWR sky130_fd_sc_hd__decap_3
X_7631_ _3078_ _3079_ VGND VGND VPWR VPWR _3080_ sky130_fd_sc_hd__nor2_1
XFILLER_21_625 VGND VGND VPWR VPWR sky130_fd_sc_hd__fill_1
XFILLER_21_647 VGND VGND VPWR VPWR sky130_fd_sc_hd__fill_1
XTAP_TAPCELL_ROW_31_620 VGND VPWR sky130_fd_sc_hd__tapvpwrvgnd_1
X_4843_ _0590_ _0589_ _0542_ VGND VGND VPWR VPWR _0591_ sky130_fd_sc_hd__a21oi_4
XFILLER_20_124 VGND VGND VPWR VPWR sky130_fd_sc_hd__decap_8
XFILLER_20_157 VPWR VGND VPWR VGND sky130_ef_sc_hd__decap_12
X_4774_ net296 net438 pe_array\[3\].u_pe.accum_reg\[10\] VGND VGND VPWR VPWR _0523_
+ sky130_fd_sc_hd__a21oi_1
XTAP_TAPCELL_ROW_31_631 VGND VPWR sky130_fd_sc_hd__tapvpwrvgnd_1
X_7562_ _2988_ _2986_ _3013_ VGND VGND VPWR VPWR _3014_ sky130_fd_sc_hd__a21o_1
X_6513_ _2004_ _2032_ VGND VGND VPWR VPWR _2033_ sky130_fd_sc_hd__and2_1
X_9301_ clknet_leaf_4_clk _0413_ VGND VGND VPWR VPWR pe_accum\[2\]\[11\] sky130_fd_sc_hd__dfxtp_1
X_7493_ _2700_ _2916_ _2915_ VGND VGND VPWR VPWR _2947_ sky130_fd_sc_hd__a21oi_1
X_6444_ net175 _1963_ VGND VGND VPWR VPWR _1966_ sky130_fd_sc_hd__xnor2_1
Xclkbuf_leaf_9_clk clknet_3_5__leaf_clk VGND VGND VPWR VPWR clknet_leaf_9_clk sky130_fd_sc_hd__clkbuf_8
X_9232_ clknet_leaf_45_clk _0344_ VGND VGND VPWR VPWR pe_accum\[1\]\[18\] sky130_fd_sc_hd__dfxtp_1
X_6375_ pe_array\[0\].u_pe.accum_reg\[21\] net458 net360 VGND VGND VPWR VPWR _1899_
+ sky130_fd_sc_hd__and3_1
X_9163_ clknet_leaf_27_clk _0275_ VGND VGND VPWR VPWR pe_accum\[0\]\[17\] sky130_fd_sc_hd__dfxtp_1
XFILLER_114_251 VGND VGND VPWR VPWR sky130_fd_sc_hd__fill_1
XFILLER_102_402 VGND VGND VPWR VPWR sky130_fd_sc_hd__fill_2
X_8114_ _3464_ _3472_ _3471_ VGND VGND VPWR VPWR _3505_ sky130_fd_sc_hd__a21bo_1
X_9094_ clknet_leaf_61_clk _0206_ VGND VGND VPWR VPWR net45 sky130_fd_sc_hd__dfxtp_1
X_5326_ _1031_ _1058_ VGND VGND VPWR VPWR _1059_ sky130_fd_sc_hd__and2_1
XFILLER_114_273 VGND VGND VPWR VPWR sky130_fd_sc_hd__decap_8
XFILLER_87_113 VGND VGND VPWR VPWR sky130_fd_sc_hd__fill_1
X_8045_ _3380_ _3390_ _3436_ _3437_ VGND VGND VPWR VPWR _3438_ sky130_fd_sc_hd__o211a_1
X_5257_ _0955_ _0956_ _0990_ _0991_ VGND VGND VPWR VPWR _0992_ sky130_fd_sc_hd__o211a_1
X_5188_ net296 net434 pe_array\[3\].u_pe.accum_reg\[22\] VGND VGND VPWR VPWR _0925_
+ sky130_fd_sc_hd__a21oi_1
XTAP_TAPCELL_ROW_39_720 VGND VPWR sky130_fd_sc_hd__tapvpwrvgnd_1
XFILLER_56_533 VGND VGND VPWR VPWR sky130_fd_sc_hd__decap_8
XFILLER_16_419 VGND VGND VPWR VPWR sky130_fd_sc_hd__fill_1
X_8947_ clknet_leaf_68_clk _0059_ VGND VGND VPWR VPWR pe_accum\[3\]\[15\] sky130_fd_sc_hd__dfxtp_1
XTAP_TAPCELL_ROW_104_1501 VGND VPWR sky130_fd_sc_hd__tapvpwrvgnd_1
X_8878_ _4088_ net213 VGND VGND VPWR VPWR _4220_ sky130_fd_sc_hd__nand2_1
XFILLER_12_603 VGND VGND VPWR VPWR sky130_fd_sc_hd__fill_2
XFILLER_24_441 VPWR VGND VPWR VGND sky130_ef_sc_hd__decap_12
XFILLER_36_290 VGND VGND VPWR VPWR sky130_fd_sc_hd__decap_6
X_7829_ net404 pe_array\[2\].u_pe.accum_reg\[1\] net219 _3228_ VGND VGND VPWR VPWR
+ _3229_ sky130_fd_sc_hd__o2bb2a_1
XFILLER_11_113 VPWR VGND VPWR VGND sky130_ef_sc_hd__decap_12
XFILLER_24_474 VGND VGND VPWR VPWR sky130_fd_sc_hd__fill_2
XFILLER_24_485 VGND VGND VPWR VPWR sky130_fd_sc_hd__fill_2
XPHY_EDGE_ROW_91_Left_209 VGND VGND VPWR VPWR sky130_fd_sc_hd__decap_3
XTAP_TAPCELL_ROW_115_1630 VGND VPWR sky130_fd_sc_hd__tapvpwrvgnd_1
XFILLER_3_345 VPWR VGND VPWR VGND sky130_ef_sc_hd__decap_12
XFILLER_78_146 VGND VGND VPWR VPWR sky130_fd_sc_hd__fill_2
Xfanout192 _3551_ VGND VGND VPWR VPWR net192 sky130_fd_sc_hd__buf_4
Xfanout181 net182 VGND VGND VPWR VPWR net181 sky130_fd_sc_hd__clkbuf_4
Xfanout170 _2697_ VGND VGND VPWR VPWR net170 sky130_fd_sc_hd__clkbuf_4
XFILLER_47_500 VGND VGND VPWR VPWR sky130_fd_sc_hd__decap_4
XFILLER_74_341 VGND VGND VPWR VPWR sky130_fd_sc_hd__fill_2
XFILLER_59_393 VPWR VGND VPWR VGND sky130_ef_sc_hd__decap_12
XFILLER_62_525 VGND VGND VPWR VPWR sky130_fd_sc_hd__decap_6
XFILLER_34_216 VGND VGND VPWR VPWR sky130_fd_sc_hd__decap_4
XFILLER_15_441 VGND VGND VPWR VPWR sky130_fd_sc_hd__decap_6
XTAP_TAPCELL_ROW_17_458 VGND VPWR sky130_fd_sc_hd__tapvpwrvgnd_1
Xclkbuf_3_4__f_clk clknet_0_clk VGND VGND VPWR VPWR clknet_3_4__leaf_clk sky130_fd_sc_hd__clkbuf_16
XTAP_TAPCELL_ROW_45_789 VGND VPWR sky130_fd_sc_hd__tapvpwrvgnd_1
XFILLER_30_433 VGND VGND VPWR VPWR sky130_fd_sc_hd__decap_6
XFILLER_7_673 VPWR VGND VPWR VGND sky130_ef_sc_hd__decap_12
X_4490_ _4227_ _4257_ VGND VGND VPWR VPWR _4258_ sky130_fd_sc_hd__xnor2_1
XTAP_TAPCELL_ROW_77_1179 VGND VPWR sky130_fd_sc_hd__tapvpwrvgnd_1
X_6160_ _1650_ _1651_ _1689_ _1690_ VGND VGND VPWR VPWR _1691_ sky130_fd_sc_hd__o211a_1
XFILLER_40_3 VGND VGND VPWR VPWR sky130_fd_sc_hd__decap_8
XFILLER_111_210 VGND VGND VPWR VPWR sky130_fd_sc_hd__fill_1
XTAP_TAPCELL_ROW_90_1335 VGND VPWR sky130_fd_sc_hd__tapvpwrvgnd_1
X_5111_ _0848_ _0849_ _0815_ _0817_ VGND VGND VPWR VPWR _0851_ sky130_fd_sc_hd__a211o_1
X_6091_ _1609_ _1621_ _1622_ VGND VGND VPWR VPWR _1624_ sky130_fd_sc_hd__nand3_1
XFILLER_111_265 VPWR VGND VPWR VGND sky130_ef_sc_hd__decap_12
XFILLER_84_116 VGND VGND VPWR VPWR sky130_fd_sc_hd__decap_3
X_5042_ net397 pe_array\[3\].u_pe.accum_reg\[16\] net256 _0784_ VGND VGND VPWR VPWR
+ _0785_ sky130_fd_sc_hd__o2bb2a_4
XFILLER_38_511 VGND VGND VPWR VPWR sky130_fd_sc_hd__decap_4
X_8801_ _4142_ _4145_ _4171_ VGND VGND VPWR VPWR _4172_ sky130_fd_sc_hd__o21ai_2
XFILLER_80_300 VGND VGND VPWR VPWR sky130_fd_sc_hd__fill_1
XFILLER_65_363 VGND VGND VPWR VPWR sky130_fd_sc_hd__fill_2
XFILLER_38_577 VGND VGND VPWR VPWR sky130_fd_sc_hd__decap_8
XFILLER_53_525 VGND VGND VPWR VPWR sky130_fd_sc_hd__decap_3
XFILLER_25_249 VPWR VGND VPWR VGND sky130_ef_sc_hd__decap_12
X_6993_ net524 net341 pe_array\[1\].u_pe.accum_reg\[9\] VGND VGND VPWR VPWR _2461_
+ sky130_fd_sc_hd__a21oi_2
X_8732_ net192 _4103_ VGND VGND VPWR VPWR _4105_ sky130_fd_sc_hd__nor2_1
XFILLER_80_377 VGND VGND VPWR VPWR sky130_fd_sc_hd__decap_6
XFILLER_80_355 VGND VGND VPWR VPWR sky130_fd_sc_hd__decap_8
X_5944_ net473 net348 VGND VGND VPWR VPWR _1480_ sky130_fd_sc_hd__nand2_1
X_8663_ pe_array\[2\].u_pe.accum_reg\[26\] net442 net316 VGND VGND VPWR VPWR _4038_
+ sky130_fd_sc_hd__and3_1
X_5875_ _1410_ _1411_ VGND VGND VPWR VPWR _1413_ sky130_fd_sc_hd__xor2_1
X_8594_ _3971_ _3970_ VGND VGND VPWR VPWR _3972_ sky130_fd_sc_hd__or2_4
XFILLER_21_433 VGND VGND VPWR VPWR sky130_fd_sc_hd__fill_2
X_4826_ _0522_ _0524_ _0572_ _0573_ VGND VGND VPWR VPWR _0574_ sky130_fd_sc_hd__o211a_1
X_7614_ _3061_ _3062_ VGND VGND VPWR VPWR _3064_ sky130_fd_sc_hd__xnor2_1
X_7545_ _2994_ _2995_ _2965_ _2967_ VGND VGND VPWR VPWR _2997_ sky130_fd_sc_hd__a211o_1
X_4757_ net416 _0506_ VGND VGND VPWR VPWR _0021_ sky130_fd_sc_hd__nor2_1
XFILLER_107_538 VGND VGND VPWR VPWR sky130_fd_sc_hd__decap_6
XFILLER_107_505 VPWR VGND VPWR VGND sky130_ef_sc_hd__decap_12
XFILLER_4_109 VGND VGND VPWR VPWR sky130_fd_sc_hd__decap_4
X_7476_ net407 pe_array\[1\].u_pe.accum_reg\[22\] net230 _2930_ VGND VGND VPWR VPWR
+ _2931_ sky130_fd_sc_hd__o2bb2a_4
X_4688_ net477 net293 VGND VGND VPWR VPWR _0439_ sky130_fd_sc_hd__nand2_1
X_6427_ _1945_ _1949_ VGND VGND VPWR VPWR _1950_ sky130_fd_sc_hd__xnor2_1
X_9215_ clknet_leaf_31_clk _0327_ VGND VGND VPWR VPWR pe_accum\[1\]\[1\] sky130_fd_sc_hd__dfxtp_1
X_9146_ clknet_leaf_21_clk _0258_ VGND VGND VPWR VPWR pe_accum\[0\]\[0\] sky130_fd_sc_hd__dfxtp_1
X_6358_ net175 _1882_ VGND VGND VPWR VPWR _1883_ sky130_fd_sc_hd__xnor2_1
XFILLER_88_400 VPWR VGND VPWR VGND sky130_ef_sc_hd__decap_12
XFILLER_88_433 VGND VGND VPWR VPWR sky130_fd_sc_hd__decap_4
XFILLER_0_337 VGND VGND VPWR VPWR sky130_fd_sc_hd__decap_3
X_5309_ net288 _1041_ VGND VGND VPWR VPWR _1042_ sky130_fd_sc_hd__xnor2_1
X_6289_ _1781_ _1783_ _1814_ _1815_ VGND VGND VPWR VPWR _1816_ sky130_fd_sc_hd__o211a_1
X_9077_ clknet_leaf_59_clk _0189_ VGND VGND VPWR VPWR net26 sky130_fd_sc_hd__dfxtp_1
XTAP_TAPCELL_ROW_110_1571 VGND VPWR sky130_fd_sc_hd__tapvpwrvgnd_1
X_8028_ net443 _3418_ _3419_ net312 net478 VGND VGND VPWR VPWR _3421_ sky130_fd_sc_hd__a32o_1
XFILLER_29_555 VGND VGND VPWR VPWR sky130_fd_sc_hd__decap_4
XFILLER_90_108 VGND VGND VPWR VPWR sky130_fd_sc_hd__fill_2
XFILLER_84_661 VGND VGND VPWR VPWR sky130_fd_sc_hd__fill_1
XFILLER_71_333 VGND VGND VPWR VPWR sky130_fd_sc_hd__decap_3
XTAP_TAPCELL_ROW_14_417 VGND VPWR sky130_fd_sc_hd__tapvpwrvgnd_1
XFILLER_12_400 VPWR VGND VPWR VGND sky130_ef_sc_hd__decap_12
XFILLER_12_433 VPWR VGND VPWR VGND sky130_ef_sc_hd__decap_12
XFILLER_24_282 VGND VGND VPWR VPWR sky130_fd_sc_hd__decap_3
XFILLER_33_41 VGND VGND VPWR VPWR sky130_fd_sc_hd__decap_3
XTAP_TAPCELL_ROW_42_759 VGND VPWR sky130_fd_sc_hd__tapvpwrvgnd_1
XFILLER_12_477 VGND VGND VPWR VPWR sky130_fd_sc_hd__fill_1
XFILLER_8_415 VGND VGND VPWR VPWR sky130_fd_sc_hd__decap_4
XFILLER_4_643 VGND VGND VPWR VPWR sky130_fd_sc_hd__fill_1
XFILLER_79_411 VGND VGND VPWR VPWR sky130_fd_sc_hd__fill_2
XFILLER_3_186 VGND VGND VPWR VPWR sky130_fd_sc_hd__decap_8
XFILLER_67_617 VPWR VGND VPWR VGND sky130_ef_sc_hd__decap_12
XFILLER_94_469 VGND VGND VPWR VPWR sky130_fd_sc_hd__decap_6
XFILLER_75_683 VGND VGND VPWR VPWR sky130_fd_sc_hd__fill_1
XFILLER_90_664 VPWR VGND VPWR VGND sky130_ef_sc_hd__decap_12
XFILLER_74_81 VGND VGND VPWR VPWR sky130_fd_sc_hd__decap_3
XFILLER_50_539 VPWR VGND VPWR VGND sky130_ef_sc_hd__decap_12
X_5660_ net971 net363 VGND VGND VPWR VPWR _0201_ sky130_fd_sc_hd__and2_1
X_4611_ _4366_ _4372_ net521 VGND VGND VPWR VPWR _4374_ sky130_fd_sc_hd__nand3_1
X_5591_ net940 net372 VGND VGND VPWR VPWR _0132_ sky130_fd_sc_hd__and2_1
X_7330_ _2753_ _2789_ VGND VGND VPWR VPWR _2790_ sky130_fd_sc_hd__xnor2_1
X_4542_ _4303_ _4304_ net303 net492 VGND VGND VPWR VPWR _4307_ sky130_fd_sc_hd__a2bb2o_1
Xhold426 pe_accum\[0\]\[21\] VGND VGND VPWR VPWR net941 sky130_fd_sc_hd__dlygate4sd3_1
Xhold404 pe_accum\[3\]\[26\] VGND VGND VPWR VPWR net919 sky130_fd_sc_hd__dlygate4sd3_1
Xhold415 pe_accum\[3\]\[9\] VGND VGND VPWR VPWR net930 sky130_fd_sc_hd__dlygate4sd3_1
X_7261_ _2720_ _2721_ _2722_ VGND VGND VPWR VPWR _2723_ sky130_fd_sc_hd__nand3_2
X_4473_ net507 pe_array\[3\].u_pe.tap_count\[0\] net1013 VGND VGND VPWR VPWR _4245_
+ sky130_fd_sc_hd__a21oi_1
X_9000_ clknet_leaf_21_clk _0112_ VGND VGND VPWR VPWR net68 sky130_fd_sc_hd__dfxtp_1
Xhold448 pe_accum\[2\]\[9\] VGND VGND VPWR VPWR net963 sky130_fd_sc_hd__dlygate4sd3_1
X_6212_ _1706_ _1741_ VGND VGND VPWR VPWR _1742_ sky130_fd_sc_hd__xor2_1
Xhold437 pe_accum\[3\]\[30\] VGND VGND VPWR VPWR net952 sky130_fd_sc_hd__dlygate4sd3_1
Xhold459 pe_accum\[1\]\[25\] VGND VGND VPWR VPWR net974 sky130_fd_sc_hd__dlygate4sd3_1
XPHY_EDGE_ROW_115_Right_115 VGND VGND VPWR VPWR sky130_fd_sc_hd__decap_3
X_7192_ _2617_ _2611_ VGND VGND VPWR VPWR _2656_ sky130_fd_sc_hd__nor2_4
XFILLER_112_541 VGND VGND VPWR VPWR sky130_fd_sc_hd__fill_1
XFILLER_112_530 VGND VGND VPWR VPWR sky130_fd_sc_hd__fill_2
XFILLER_97_241 VGND VGND VPWR VPWR sky130_fd_sc_hd__decap_3
X_6143_ _1673_ _1674_ VGND VGND VPWR VPWR _1675_ sky130_fd_sc_hd__nand2_1
XFILLER_112_574 VPWR VGND VPWR VGND sky130_ef_sc_hd__decap_12
XFILLER_85_403 VGND VGND VPWR VPWR sky130_fd_sc_hd__decap_3
X_6074_ _1599_ _1605_ VGND VGND VPWR VPWR _1607_ sky130_fd_sc_hd__xnor2_1
XFILLER_57_105 VGND VGND VPWR VPWR sky130_fd_sc_hd__decap_4
XFILLER_85_469 VGND VGND VPWR VPWR sky130_fd_sc_hd__decap_3
X_5025_ net180 _0766_ _0767_ VGND VGND VPWR VPWR _0768_ sky130_fd_sc_hd__nand3_1
XFILLER_38_363 VGND VGND VPWR VPWR sky130_fd_sc_hd__fill_1
XFILLER_54_29 VPWR VGND VPWR VGND sky130_ef_sc_hd__decap_12
XFILLER_81_664 VGND VGND VPWR VPWR sky130_fd_sc_hd__decap_8
XFILLER_80_141 VPWR VGND VPWR VGND sky130_ef_sc_hd__decap_12
XFILLER_53_344 VGND VGND VPWR VPWR sky130_fd_sc_hd__decap_3
X_6976_ _2401_ _2402_ _2399_ VGND VGND VPWR VPWR _2444_ sky130_fd_sc_hd__a21oi_1
X_8715_ net402 pe_array\[2\].u_pe.accum_reg\[27\] net218 _4088_ VGND VGND VPWR VPWR
+ _4089_ sky130_fd_sc_hd__o2bb2a_4
XFILLER_81_697 VGND VGND VPWR VPWR sky130_fd_sc_hd__decap_3
X_5927_ net413 pe_array\[0\].u_pe.accum_reg\[8\] net238 _1463_ VGND VGND VPWR VPWR
+ _1464_ sky130_fd_sc_hd__o2bb2a_1
XFILLER_53_377 VGND VGND VPWR VPWR sky130_fd_sc_hd__fill_2
XFILLER_13_219 VGND VGND VPWR VPWR sky130_fd_sc_hd__fill_1
XFILLER_41_528 VGND VGND VPWR VPWR sky130_fd_sc_hd__fill_2
X_8646_ _4019_ _4020_ VGND VGND VPWR VPWR _4022_ sky130_fd_sc_hd__xor2_1
X_5858_ pe_array\[0\].u_pe.accum_reg\[7\] pe_array\[0\].u_pe.weight_in\[7\] VGND VGND
+ VPWR VPWR _1396_ sky130_fd_sc_hd__xnor2_1
XFILLER_21_241 VGND VGND VPWR VPWR sky130_fd_sc_hd__fill_1
XFILLER_21_252 VPWR VGND VPWR VGND sky130_ef_sc_hd__decap_12
X_8577_ net191 _3953_ _3954_ VGND VGND VPWR VPWR _3955_ sky130_fd_sc_hd__nand3_1
X_5789_ _1326_ _1327_ _1320_ VGND VGND VPWR VPWR _1329_ sky130_fd_sc_hd__a21o_1
X_4809_ net291 net460 net289 net469 VGND VGND VPWR VPWR _0557_ sky130_fd_sc_hd__a22oi_1
XPHY_EDGE_ROW_17_Right_17 VGND VGND VPWR VPWR sky130_fd_sc_hd__decap_3
XFILLER_5_429 VPWR VGND VPWR VGND sky130_ef_sc_hd__decap_12
X_7528_ _2979_ _2980_ VGND VGND VPWR VPWR _2981_ sky130_fd_sc_hd__nor2_1
XFILLER_107_335 VGND VGND VPWR VPWR sky130_fd_sc_hd__fill_1
X_7459_ net193 _2887_ _2885_ VGND VGND VPWR VPWR _2914_ sky130_fd_sc_hd__o21a_1
XTAP_TAPCELL_ROW_112_1600 VGND VPWR sky130_fd_sc_hd__tapvpwrvgnd_1
XFILLER_103_541 VGND VGND VPWR VPWR sky130_fd_sc_hd__decap_3
XFILLER_88_241 VGND VGND VPWR VPWR sky130_fd_sc_hd__decap_4
X_9129_ clknet_leaf_28_clk _0241_ VGND VGND VPWR VPWR pe_array\[0\].u_pe.accum_reg\[15\]
+ sky130_fd_sc_hd__dfxtp_1
XFILLER_0_134 VGND VGND VPWR VPWR sky130_fd_sc_hd__fill_2
XFILLER_103_585 VGND VGND VPWR VPWR sky130_fd_sc_hd__fill_1
XPHY_EDGE_ROW_26_Right_26 VGND VGND VPWR VPWR sky130_fd_sc_hd__decap_3
XFILLER_49_617 VGND VGND VPWR VPWR sky130_fd_sc_hd__fill_1
XTAP_TAPCELL_ROW_47_818 VGND VPWR sky130_fd_sc_hd__tapvpwrvgnd_1
XFILLER_28_85 VGND VGND VPWR VPWR sky130_fd_sc_hd__fill_1
XFILLER_17_558 VGND VGND VPWR VPWR sky130_fd_sc_hd__fill_2
XTAP_TAPCELL_ROW_63_1009 VGND VPWR sky130_fd_sc_hd__tapvpwrvgnd_1
XTAP_TAPCELL_ROW_27_575 VGND VPWR sky130_fd_sc_hd__tapvpwrvgnd_1
XPHY_EDGE_ROW_35_Right_35 VGND VGND VPWR VPWR sky130_fd_sc_hd__decap_3
XFILLER_40_583 VGND VGND VPWR VPWR sky130_fd_sc_hd__fill_1
XFILLER_60_83 VGND VGND VPWR VPWR sky130_fd_sc_hd__fill_1
XFILLER_113_305 VGND VGND VPWR VPWR sky130_fd_sc_hd__fill_2
XTAP_TAPCELL_ROW_74_1138 VGND VPWR sky130_fd_sc_hd__tapvpwrvgnd_1
XFILLER_113_349 VGND VGND VPWR VPWR sky130_fd_sc_hd__decap_8
XPHY_EDGE_ROW_44_Right_44 VGND VGND VPWR VPWR sky130_fd_sc_hd__decap_3
XFILLER_79_263 VGND VGND VPWR VPWR sky130_fd_sc_hd__decap_8
XFILLER_67_414 VGND VGND VPWR VPWR sky130_fd_sc_hd__decap_3
XFILLER_94_233 VPWR VGND VPWR VGND sky130_ef_sc_hd__decap_12
XFILLER_67_447 VGND VGND VPWR VPWR sky130_fd_sc_hd__fill_1
XFILLER_85_80 VPWR VGND VPWR VGND sky130_ef_sc_hd__decap_12
XFILLER_48_661 VGND VGND VPWR VPWR sky130_fd_sc_hd__fill_2
XFILLER_94_299 VGND VGND VPWR VPWR sky130_fd_sc_hd__fill_1
X_6830_ _2299_ _2300_ _2301_ VGND VGND VPWR VPWR _2302_ sky130_fd_sc_hd__nand3_1
XFILLER_35_333 VGND VGND VPWR VPWR sky130_fd_sc_hd__decap_3
XTAP_TAPCELL_ROW_85_1278 VGND VPWR sky130_fd_sc_hd__tapvpwrvgnd_1
XFILLER_62_163 VGND VGND VPWR VPWR sky130_fd_sc_hd__decap_4
XFILLER_62_152 VGND VGND VPWR VPWR sky130_fd_sc_hd__fill_2
X_6761_ _2234_ _2235_ VGND VGND VPWR VPWR _2236_ sky130_fd_sc_hd__or2_1
XFILLER_23_528 VPWR VGND VPWR VGND sky130_ef_sc_hd__decap_12
X_5712_ _1253_ _1254_ net505 net355 VGND VGND VPWR VPWR _1255_ sky130_fd_sc_hd__and4bb_1
X_8500_ _3819_ _3849_ net154 VGND VGND VPWR VPWR _3881_ sky130_fd_sc_hd__o21a_1
XPHY_EDGE_ROW_53_Right_53 VGND VGND VPWR VPWR sky130_fd_sc_hd__decap_3
X_6692_ net897 net233 _1311_ net242 VGND VGND VPWR VPWR _0262_ sky130_fd_sc_hd__o2bb2ai_1
X_8431_ _3811_ _3812_ _3813_ VGND VGND VPWR VPWR _3814_ sky130_fd_sc_hd__nand3_1
X_5643_ net973 net371 VGND VGND VPWR VPWR _0184_ sky130_fd_sc_hd__and2_1
X_5574_ net920 net393 VGND VGND VPWR VPWR _0115_ sky130_fd_sc_hd__and2_1
X_8362_ net161 _3715_ _3714_ VGND VGND VPWR VPWR _3747_ sky130_fd_sc_hd__o21bai_1
XFILLER_116_121 VGND VGND VPWR VPWR sky130_fd_sc_hd__decap_3
X_7313_ _2731_ _2733_ _2770_ _2771_ VGND VGND VPWR VPWR _2773_ sky130_fd_sc_hd__o211ai_1
X_4525_ _4265_ _4289_ _4290_ VGND VGND VPWR VPWR _4291_ sky130_fd_sc_hd__nand3_1
X_8293_ _3677_ _3678_ net189 VGND VGND VPWR VPWR _3680_ sky130_fd_sc_hd__a21o_1
X_4456_ net311 VGND VGND VPWR VPWR _4237_ sky130_fd_sc_hd__inv_2
XPHY_EDGE_ROW_62_Right_62 VGND VGND VPWR VPWR sky130_fd_sc_hd__decap_3
X_7244_ _2702_ _2703_ net266 VGND VGND VPWR VPWR _2706_ sky130_fd_sc_hd__o21ai_1
XFILLER_98_550 VGND VGND VPWR VPWR sky130_fd_sc_hd__decap_3
X_7175_ net193 _2636_ _2638_ VGND VGND VPWR VPWR _2639_ sky130_fd_sc_hd__or3b_4
XFILLER_100_511 VGND VGND VPWR VPWR sky130_fd_sc_hd__fill_2
X_6126_ _1655_ _1656_ net200 VGND VGND VPWR VPWR _1658_ sky130_fd_sc_hd__a21o_1
XFILLER_58_403 VGND VGND VPWR VPWR sky130_fd_sc_hd__fill_1
XFILLER_85_222 VGND VGND VPWR VPWR sky130_fd_sc_hd__fill_2
XFILLER_100_566 VGND VGND VPWR VPWR sky130_fd_sc_hd__fill_1
X_6057_ _1588_ _1589_ VGND VGND VPWR VPWR _1591_ sky130_fd_sc_hd__and2b_1
XFILLER_65_39 VPWR VGND VPWR VGND sky130_ef_sc_hd__decap_12
XFILLER_58_469 VGND VGND VPWR VPWR sky130_fd_sc_hd__decap_6
XFILLER_85_288 VGND VGND VPWR VPWR sky130_fd_sc_hd__decap_8
XFILLER_26_300 VGND VGND VPWR VPWR sky130_fd_sc_hd__fill_2
X_5008_ net295 net433 pe_array\[3\].u_pe.accum_reg\[16\] VGND VGND VPWR VPWR _0751_
+ sky130_fd_sc_hd__a21oi_1
XFILLER_54_664 VPWR VGND VPWR VGND sky130_ef_sc_hd__decap_12
XFILLER_54_653 VGND VGND VPWR VPWR sky130_fd_sc_hd__decap_3
XFILLER_54_642 VGND VGND VPWR VPWR sky130_fd_sc_hd__fill_2
XPHY_EDGE_ROW_71_Right_71 VGND VGND VPWR VPWR sky130_fd_sc_hd__decap_3
XTAP_TAPCELL_ROW_24_545 VGND VPWR sky130_fd_sc_hd__tapvpwrvgnd_1
X_6959_ _2425_ _2426_ _2407_ VGND VGND VPWR VPWR _2428_ sky130_fd_sc_hd__a21o_1
XTAP_TAPCELL_ROW_52_876 VGND VPWR sky130_fd_sc_hd__tapvpwrvgnd_1
X_8629_ _3968_ _4004_ VGND VGND VPWR VPWR _4006_ sky130_fd_sc_hd__nand2_1
XFILLER_14_76 VGND VGND VPWR VPWR sky130_fd_sc_hd__fill_1
XFILLER_5_204 VGND VGND VPWR VPWR sky130_fd_sc_hd__fill_1
Xrebuffer353 _3564_ VGND VGND VPWR VPWR net868 sky130_fd_sc_hd__dlymetal6s2s_1
XFILLER_107_154 VGND VGND VPWR VPWR sky130_fd_sc_hd__decap_8
XPHY_EDGE_ROW_80_Right_80 VGND VGND VPWR VPWR sky130_fd_sc_hd__decap_3
XFILLER_1_421 VPWR VGND VPWR VGND sky130_ef_sc_hd__decap_12
XFILLER_39_40 VPWR VGND VPWR VGND sky130_ef_sc_hd__decap_12
XFILLER_91_225 VGND VGND VPWR VPWR sky130_fd_sc_hd__decap_8
XFILLER_91_258 VPWR VGND VPWR VGND sky130_ef_sc_hd__decap_12
XFILLER_45_653 VGND VGND VPWR VPWR sky130_fd_sc_hd__decap_8
XFILLER_72_483 VGND VGND VPWR VPWR sky130_fd_sc_hd__decap_4
XFILLER_60_656 VGND VGND VPWR VPWR sky130_fd_sc_hd__decap_4
XFILLER_13_561 VGND VGND VPWR VPWR sky130_fd_sc_hd__decap_8
XFILLER_114_625 VPWR VGND VPWR VGND sky130_ef_sc_hd__decap_12
XFILLER_113_113 VPWR VGND VPWR VGND sky130_ef_sc_hd__decap_12
X_5290_ net185 _1023_ VGND VGND VPWR VPWR _1024_ sky130_fd_sc_hd__nor2_1
XFILLER_114_669 VPWR VGND VPWR VGND sky130_ef_sc_hd__decap_12
XFILLER_95_542 VGND VGND VPWR VPWR sky130_fd_sc_hd__fill_2
XFILLER_67_222 VGND VGND VPWR VPWR sky130_fd_sc_hd__fill_2
X_8980_ clknet_leaf_22_clk _0092_ VGND VGND VPWR VPWR net116 sky130_fd_sc_hd__dfxtp_1
X_7931_ net478 net321 VGND VGND VPWR VPWR _3326_ sky130_fd_sc_hd__and2_1
XFILLER_67_277 VGND VGND VPWR VPWR sky130_fd_sc_hd__decap_3
XFILLER_82_258 VGND VGND VPWR VPWR sky130_fd_sc_hd__fill_1
XFILLER_82_236 VGND VGND VPWR VPWR sky130_fd_sc_hd__fill_2
X_7862_ _3239_ _3258_ VGND VGND VPWR VPWR _3260_ sky130_fd_sc_hd__or2_1
X_6813_ net510 net329 _2258_ _2260_ VGND VGND VPWR VPWR _2285_ sky130_fd_sc_hd__a211oi_1
X_7793_ net370 net21 net11 net12 VGND VGND VPWR VPWR _3206_ sky130_fd_sc_hd__and4_2
XFILLER_23_325 VGND VGND VPWR VPWR sky130_fd_sc_hd__fill_1
X_6744_ _2211_ _2219_ VGND VGND VPWR VPWR _2220_ sky130_fd_sc_hd__nand2_1
XFILLER_51_678 VGND VGND VPWR VPWR sky130_fd_sc_hd__fill_1
X_6675_ pe_array\[0\].u_pe.accum_reg\[30\] net274 _1394_ VGND VGND VPWR VPWR _2189_
+ sky130_fd_sc_hd__a21o_1
XTAP_TAPCELL_ROW_21_504 VGND VPWR sky130_fd_sc_hd__tapvpwrvgnd_1
XTAP_TAPCELL_ROW_98_1425 VGND VPWR sky130_fd_sc_hd__tapvpwrvgnd_1
X_5626_ net994 net381 VGND VGND VPWR VPWR _0167_ sky130_fd_sc_hd__and2_1
X_8414_ net419 _3797_ VGND VGND VPWR VPWR _0387_ sky130_fd_sc_hd__nor2_1
XFILLER_117_441 VGND VGND VPWR VPWR sky130_fd_sc_hd__decap_3
X_5557_ net894 net390 VGND VGND VPWR VPWR _0098_ sky130_fd_sc_hd__and2_1
X_8345_ net401 pe_array\[2\].u_pe.accum_reg\[15\] net217 _3730_ VGND VGND VPWR VPWR
+ _3731_ sky130_fd_sc_hd__o2bb2a_4
X_8276_ _3662_ VGND VGND VPWR VPWR _3663_ sky130_fd_sc_hd__inv_2
X_5488_ net943 net250 _1204_ net365 VGND VGND VPWR VPWR _0054_ sky130_fd_sc_hd__o211a_1
X_4508_ _4273_ _4274_ VGND VGND VPWR VPWR _4275_ sky130_fd_sc_hd__or2_1
XFILLER_105_669 VGND VGND VPWR VPWR sky130_fd_sc_hd__decap_3
XFILLER_104_135 VGND VGND VPWR VPWR sky130_fd_sc_hd__decap_4
X_7227_ _2687_ _2688_ _2650_ VGND VGND VPWR VPWR _2690_ sky130_fd_sc_hd__o21ai_1
Xfanout511 net1 VGND VGND VPWR VPWR net511 sky130_fd_sc_hd__buf_6
Xfanout500 net501 VGND VGND VPWR VPWR net500 sky130_fd_sc_hd__buf_8
XFILLER_86_531 VGND VGND VPWR VPWR sky130_fd_sc_hd__fill_1
XFILLER_58_233 VGND VGND VPWR VPWR sky130_fd_sc_hd__fill_1
X_7158_ net328 net326 net452 VGND VGND VPWR VPWR _2622_ sky130_fd_sc_hd__o21ai_1
XFILLER_100_341 VPWR VGND VPWR VGND sky130_ef_sc_hd__decap_12
XFILLER_86_564 VGND VGND VPWR VPWR sky130_fd_sc_hd__decap_4
X_6109_ net644 net347 net344 VGND VGND VPWR VPWR _1641_ sky130_fd_sc_hd__and3_4
X_7089_ _2552_ _2553_ _2554_ VGND VGND VPWR VPWR _2555_ sky130_fd_sc_hd__nand3_2
XFILLER_58_299 VGND VGND VPWR VPWR sky130_fd_sc_hd__decap_4
XTAP_TAPCELL_ROW_57_935 VGND VPWR sky130_fd_sc_hd__tapvpwrvgnd_1
XTAP_TAPCELL_ROW_29_604 VGND VPWR sky130_fd_sc_hd__tapvpwrvgnd_1
XTAP_TAPCELL_ROW_107_1543 VGND VPWR sky130_fd_sc_hd__tapvpwrvgnd_1
XTAP_TAPCELL_ROW_107_1532 VGND VPWR sky130_fd_sc_hd__tapvpwrvgnd_1
XFILLER_73_258 VGND VGND VPWR VPWR sky130_fd_sc_hd__fill_2
XFILLER_27_642 VGND VGND VPWR VPWR sky130_fd_sc_hd__decap_4
Xrebuffer82 _3892_ VGND VGND VPWR VPWR net597 sky130_fd_sc_hd__dlymetal6s4s_1
Xrebuffer60 net445 VGND VGND VPWR VPWR net575 sky130_fd_sc_hd__clkbuf_2
XTAP_TAPCELL_ROW_1_262 VGND VPWR sky130_fd_sc_hd__tapvpwrvgnd_1
XFILLER_26_141 VGND VGND VPWR VPWR sky130_fd_sc_hd__decap_3
Xrebuffer71 net652 VGND VGND VPWR VPWR net586 sky130_fd_sc_hd__clkbuf_2
XFILLER_42_601 VPWR VGND VPWR VGND sky130_ef_sc_hd__decap_12
Xrebuffer93 net611 VGND VGND VPWR VPWR net608 sky130_fd_sc_hd__buf_6
XTAP_TAPCELL_ROW_37_692 VGND VPWR sky130_fd_sc_hd__tapvpwrvgnd_1
Xrebuffer161 _3603_ VGND VGND VPWR VPWR net676 sky130_fd_sc_hd__dlygate4sd1_1
XFILLER_10_597 VPWR VGND VPWR VGND sky130_ef_sc_hd__decap_12
Xrebuffer172 _0665_ VGND VGND VPWR VPWR net687 sky130_fd_sc_hd__buf_6
XTAP_TAPCELL_ROW_71_1108 VGND VPWR sky130_fd_sc_hd__tapvpwrvgnd_1
XFILLER_111_617 VPWR VGND VPWR VGND sky130_ef_sc_hd__decap_12
XTAP_TAPCELL_ROW_9_362 VGND VPWR sky130_fd_sc_hd__tapvpwrvgnd_1
XFILLER_110_116 VGND VGND VPWR VPWR sky130_fd_sc_hd__decap_4
XFILLER_104_680 VGND VGND VPWR VPWR sky130_fd_sc_hd__decap_8
XFILLER_49_222 VGND VGND VPWR VPWR sky130_fd_sc_hd__fill_2
XFILLER_64_258 VGND VGND VPWR VPWR sky130_fd_sc_hd__decap_3
XFILLER_18_642 VGND VGND VPWR VPWR sky130_fd_sc_hd__fill_2
XPHY_EDGE_ROW_111_Left_229 VGND VGND VPWR VPWR sky130_fd_sc_hd__decap_3
XTAP_TAPCELL_ROW_82_1237 VGND VPWR sky130_fd_sc_hd__tapvpwrvgnd_1
XFILLER_33_645 VGND VGND VPWR VPWR sky130_fd_sc_hd__decap_3
X_4790_ _0536_ _0534_ _0492_ _0494_ VGND VGND VPWR VPWR _0539_ sky130_fd_sc_hd__o211a_1
XFILLER_20_328 VPWR VGND VPWR VGND sky130_ef_sc_hd__decap_12
XFILLER_13_391 VGND VGND VPWR VPWR sky130_fd_sc_hd__fill_1
X_6460_ _1941_ _1973_ _1943_ VGND VGND VPWR VPWR _1981_ sky130_fd_sc_hd__o21ai_1
X_6391_ _1886_ net171 _1885_ VGND VGND VPWR VPWR _1915_ sky130_fd_sc_hd__a21oi_2
X_5411_ _1109_ _1111_ _1140_ VGND VGND VPWR VPWR _1141_ sky130_fd_sc_hd__o21a_1
Xoutput114 net114 VGND VGND VPWR VPWR result_data[68] sky130_fd_sc_hd__buf_2
XFILLER_99_111 VGND VGND VPWR VPWR sky130_fd_sc_hd__fill_1
Xoutput125 net125 VGND VGND VPWR VPWR result_data[78] sky130_fd_sc_hd__buf_2
X_8130_ _3504_ _3520_ _3519_ VGND VGND VPWR VPWR _3521_ sky130_fd_sc_hd__and3_1
X_5342_ _1044_ _1046_ _1073_ VGND VGND VPWR VPWR _1074_ sky130_fd_sc_hd__o21a_1
Xoutput103 net103 VGND VGND VPWR VPWR result_data[58] sky130_fd_sc_hd__buf_2
Xoutput136 net136 VGND VGND VPWR VPWR result_data[88] sky130_fd_sc_hd__buf_2
XTAP_TAPCELL_ROW_93_1366 VGND VPWR sky130_fd_sc_hd__tapvpwrvgnd_1
X_8061_ net483 net476 net310 net308 VGND VGND VPWR VPWR _3453_ sky130_fd_sc_hd__and4_1
Xoutput147 net147 VGND VGND VPWR VPWR result_data[98] sky130_fd_sc_hd__buf_2
X_5273_ _0973_ _1007_ VGND VGND VPWR VPWR _1008_ sky130_fd_sc_hd__nand2_1
X_7012_ _2477_ _2479_ VGND VGND VPWR VPWR _2480_ sky130_fd_sc_hd__nor2_1
XFILLER_68_575 VPWR VGND VPWR VGND sky130_ef_sc_hd__decap_12
XFILLER_83_512 VGND VGND VPWR VPWR sky130_fd_sc_hd__decap_3
XFILLER_55_225 VGND VGND VPWR VPWR sky130_fd_sc_hd__fill_2
XFILLER_46_19 VGND VGND VPWR VPWR sky130_fd_sc_hd__decap_8
XFILLER_55_258 VGND VGND VPWR VPWR sky130_fd_sc_hd__fill_1
X_8963_ clknet_leaf_58_clk _0075_ VGND VGND VPWR VPWR pe_accum\[3\]\[31\] sky130_fd_sc_hd__dfxtp_1
X_7914_ _3308_ _3309_ VGND VGND VPWR VPWR _3310_ sky130_fd_sc_hd__nor2_1
X_8894_ clknet_leaf_17_clk _0006_ VGND VGND VPWR VPWR pe_array\[0\].u_pe.weight_in\[6\]
+ sky130_fd_sc_hd__dfxtp_1
XTAP_TAPCELL_ROW_54_905 VGND VPWR sky130_fd_sc_hd__tapvpwrvgnd_1
X_7845_ net403 pe_array\[2\].u_pe.accum_reg\[2\] net219 _3243_ VGND VGND VPWR VPWR
+ _3244_ sky130_fd_sc_hd__o2bb2a_1
XFILLER_24_645 VGND VGND VPWR VPWR sky130_fd_sc_hd__fill_1
XFILLER_62_29 VPWR VGND VPWR VGND sky130_ef_sc_hd__decap_12
XFILLER_51_464 VGND VGND VPWR VPWR sky130_fd_sc_hd__decap_8
XTAP_TAPCELL_ROW_102_1473 VGND VPWR sky130_fd_sc_hd__tapvpwrvgnd_1
XTAP_TAPCELL_ROW_62_993 VGND VPWR sky130_fd_sc_hd__tapvpwrvgnd_1
XFILLER_23_177 VGND VGND VPWR VPWR sky130_fd_sc_hd__fill_1
X_7776_ net958 net221 _3197_ net374 VGND VGND VPWR VPWR _0349_ sky130_fd_sc_hd__o211a_1
XTAP_TAPCELL_ROW_34_662 VGND VPWR sky130_fd_sc_hd__tapvpwrvgnd_1
X_4988_ _0728_ _0729_ _0730_ VGND VGND VPWR VPWR _0732_ sky130_fd_sc_hd__a21oi_1
X_6727_ net430 _2205_ _2206_ VGND VGND VPWR VPWR _0291_ sky130_fd_sc_hd__nor3_1
X_6658_ net657 _2172_ VGND VGND VPWR VPWR _2173_ sky130_fd_sc_hd__xnor2_1
X_5609_ net1004 net387 VGND VGND VPWR VPWR _0150_ sky130_fd_sc_hd__and2_1
XFILLER_105_400 VGND VGND VPWR VPWR sky130_fd_sc_hd__fill_1
X_6589_ net198 _2105_ VGND VGND VPWR VPWR _2106_ sky130_fd_sc_hd__nor2_1
X_8328_ _3712_ _3711_ _3713_ VGND VGND VPWR VPWR _3714_ sky130_fd_sc_hd__and3_1
XFILLER_11_55 VGND VGND VPWR VPWR sky130_fd_sc_hd__fill_1
XFILLER_11_99 VPWR VGND VPWR VGND sky130_ef_sc_hd__decap_12
XFILLER_11_88 VGND VGND VPWR VPWR sky130_fd_sc_hd__decap_4
XFILLER_87_37 VGND VGND VPWR VPWR sky130_fd_sc_hd__fill_1
XFILLER_78_306 VGND VGND VPWR VPWR sky130_fd_sc_hd__fill_2
X_8259_ _3633_ _3646_ _3645_ VGND VGND VPWR VPWR _3647_ sky130_fd_sc_hd__and3_1
Xfanout330 pe_array\[1\].u_pe.weight_in\[4\] VGND VGND VPWR VPWR net330 sky130_fd_sc_hd__clkbuf_4
XTAP_TAPCELL_ROW_6_321 VGND VPWR sky130_fd_sc_hd__tapvpwrvgnd_1
Xfanout341 net342 VGND VGND VPWR VPWR net341 sky130_fd_sc_hd__clkbuf_2
Xfanout352 net353 VGND VGND VPWR VPWR net352 sky130_fd_sc_hd__buf_2
Xfanout363 net364 VGND VGND VPWR VPWR net363 sky130_fd_sc_hd__clkbuf_2
Xfanout374 net375 VGND VGND VPWR VPWR net374 sky130_fd_sc_hd__buf_1
Xfanout385 net386 VGND VGND VPWR VPWR net385 sky130_fd_sc_hd__clkbuf_2
XFILLER_86_372 VPWR VGND VPWR VGND sky130_ef_sc_hd__decap_12
XFILLER_59_575 VGND VGND VPWR VPWR sky130_fd_sc_hd__fill_1
Xfanout396 _4235_ VGND VGND VPWR VPWR net396 sky130_fd_sc_hd__buf_4
XFILLER_19_417 VGND VGND VPWR VPWR sky130_fd_sc_hd__fill_1
XFILLER_100_182 VGND VGND VPWR VPWR sky130_fd_sc_hd__fill_1
XFILLER_74_589 VGND VGND VPWR VPWR sky130_fd_sc_hd__decap_8
XFILLER_27_461 VGND VGND VPWR VPWR sky130_fd_sc_hd__fill_1
XTAP_TAPCELL_ROW_68_1070 VGND VPWR sky130_fd_sc_hd__tapvpwrvgnd_1
XFILLER_61_239 VGND VGND VPWR VPWR sky130_fd_sc_hd__fill_1
XFILLER_27_494 VGND VGND VPWR VPWR sky130_fd_sc_hd__fill_1
XFILLER_36_74 VGND VGND VPWR VPWR sky130_fd_sc_hd__decap_8
XFILLER_36_85 VGND VGND VPWR VPWR sky130_fd_sc_hd__decap_4
XFILLER_15_689 VGND VGND VPWR VPWR sky130_fd_sc_hd__decap_6
Xinput16 weight_din[3] VGND VGND VPWR VPWR net16 sky130_fd_sc_hd__buf_2
XFILLER_6_365 VGND VGND VPWR VPWR sky130_fd_sc_hd__decap_6
XFILLER_108_293 VPWR VGND VPWR VGND sky130_ef_sc_hd__decap_12
XFILLER_97_615 VGND VGND VPWR VPWR sky130_fd_sc_hd__fill_1
XFILLER_111_425 VGND VGND VPWR VPWR sky130_fd_sc_hd__fill_1
XFILLER_97_648 VGND VGND VPWR VPWR sky130_fd_sc_hd__decap_8
XFILLER_111_447 VGND VGND VPWR VPWR sky130_fd_sc_hd__fill_1
XFILLER_84_309 VPWR VGND VPWR VGND sky130_ef_sc_hd__decap_12
XFILLER_77_361 VGND VGND VPWR VPWR sky130_fd_sc_hd__decap_4
XFILLER_65_545 VPWR VGND VPWR VGND sky130_ef_sc_hd__decap_12
XFILLER_37_225 VPWR VGND VPWR VGND sky130_ef_sc_hd__decap_12
XFILLER_65_578 VPWR VGND VPWR VGND sky130_ef_sc_hd__decap_12
X_5960_ _1492_ _1493_ _1476_ VGND VGND VPWR VPWR _1496_ sky130_fd_sc_hd__a21oi_1
XFILLER_52_217 VGND VGND VPWR VPWR sky130_fd_sc_hd__fill_2
XFILLER_80_559 VGND VGND VPWR VPWR sky130_fd_sc_hd__fill_2
X_5891_ _1426_ _1427_ VGND VGND VPWR VPWR _1428_ sky130_fd_sc_hd__xor2_1
X_4911_ _0653_ _0654_ net286 VGND VGND VPWR VPWR _0657_ sky130_fd_sc_hd__o21ai_1
X_7630_ _3076_ _3077_ net273 VGND VGND VPWR VPWR _3079_ sky130_fd_sc_hd__o21a_1
X_4842_ _0587_ _0588_ _0538_ _0540_ VGND VGND VPWR VPWR _0590_ sky130_fd_sc_hd__o211ai_1
XTAP_TAPCELL_ROW_31_621 VGND VPWR sky130_fd_sc_hd__tapvpwrvgnd_1
X_4773_ pe_array\[3\].u_pe.accum_reg\[10\] net296 net438 VGND VGND VPWR VPWR _0522_
+ sky130_fd_sc_hd__and3_1
X_7561_ _2984_ _3011_ VGND VGND VPWR VPWR _3013_ sky130_fd_sc_hd__xnor2_1
X_6512_ _2028_ _2029_ VGND VGND VPWR VPWR _2032_ sky130_fd_sc_hd__xnor2_1
X_9300_ clknet_leaf_4_clk _0412_ VGND VGND VPWR VPWR pe_accum\[2\]\[10\] sky130_fd_sc_hd__dfxtp_1
XFILLER_20_169 VGND VGND VPWR VPWR sky130_fd_sc_hd__decap_3
X_7492_ net166 _2943_ VGND VGND VPWR VPWR _2946_ sky130_fd_sc_hd__xnor2_1
X_6443_ net177 _1963_ VGND VGND VPWR VPWR _1965_ sky130_fd_sc_hd__nor2_1
X_9231_ clknet_leaf_45_clk _0343_ VGND VGND VPWR VPWR pe_accum\[1\]\[17\] sky130_fd_sc_hd__dfxtp_1
X_6374_ net458 net360 pe_array\[0\].u_pe.accum_reg\[21\] VGND VGND VPWR VPWR _1898_
+ sky130_fd_sc_hd__a21oi_1
X_9162_ clknet_leaf_27_clk _0274_ VGND VGND VPWR VPWR pe_accum\[0\]\[16\] sky130_fd_sc_hd__dfxtp_1
X_8113_ _3501_ _3502_ VGND VGND VPWR VPWR _3504_ sky130_fd_sc_hd__xnor2_1
X_9093_ clknet_leaf_64_clk _0205_ VGND VGND VPWR VPWR net43 sky130_fd_sc_hd__dfxtp_1
X_5325_ _1055_ _1056_ VGND VGND VPWR VPWR _1058_ sky130_fd_sc_hd__xnor2_1
XFILLER_87_136 VPWR VGND VPWR VGND sky130_ef_sc_hd__decap_12
X_8044_ _3434_ _3435_ _3416_ VGND VGND VPWR VPWR _3437_ sky130_fd_sc_hd__a21o_1
X_5256_ _0987_ _0988_ net653 VGND VGND VPWR VPWR _0991_ sky130_fd_sc_hd__o21ai_1
XFILLER_87_169 VPWR VGND VPWR VGND sky130_ef_sc_hd__decap_12
XFILLER_96_681 VPWR VGND VPWR VGND sky130_ef_sc_hd__decap_12
XFILLER_68_361 VGND VGND VPWR VPWR sky130_fd_sc_hd__decap_3
XFILLER_56_512 VGND VGND VPWR VPWR sky130_fd_sc_hd__decap_4
X_5187_ _0924_ net414 VGND VGND VPWR VPWR _0033_ sky130_fd_sc_hd__nor2_1
XTAP_TAPCELL_ROW_39_721 VGND VPWR sky130_fd_sc_hd__tapvpwrvgnd_1
XFILLER_113_57 VPWR VGND VPWR VGND sky130_ef_sc_hd__decap_12
XFILLER_56_589 VGND VGND VPWR VPWR sky130_fd_sc_hd__decap_8
X_8946_ clknet_leaf_68_clk _0058_ VGND VGND VPWR VPWR pe_accum\[3\]\[14\] sky130_fd_sc_hd__dfxtp_1
XTAP_TAPCELL_ROW_104_1502 VGND VPWR sky130_fd_sc_hd__tapvpwrvgnd_1
XFILLER_71_559 VGND VGND VPWR VPWR sky130_fd_sc_hd__fill_1
XFILLER_43_239 VGND VGND VPWR VPWR sky130_fd_sc_hd__fill_1
X_8877_ net970 net213 _4219_ net384 VGND VGND VPWR VPWR _0428_ sky130_fd_sc_hd__o211a_1
XFILLER_24_453 VPWR VGND VPWR VGND sky130_ef_sc_hd__decap_12
X_7828_ _3217_ _3226_ VGND VGND VPWR VPWR _3228_ sky130_fd_sc_hd__xor2_1
XFILLER_51_261 VGND VGND VPWR VPWR sky130_fd_sc_hd__decap_4
XFILLER_11_125 VPWR VGND VPWR VGND sky130_ef_sc_hd__decap_12
X_7759_ net223 _2729_ VGND VGND VPWR VPWR _3189_ sky130_fd_sc_hd__nand2_1
XFILLER_11_169 VGND VGND VPWR VPWR sky130_fd_sc_hd__decap_6
XFILLER_22_54 VGND VGND VPWR VPWR sky130_fd_sc_hd__fill_2
XFILLER_3_302 VGND VGND VPWR VPWR sky130_fd_sc_hd__fill_1
XTAP_TAPCELL_ROW_115_1631 VGND VPWR sky130_fd_sc_hd__tapvpwrvgnd_1
XFILLER_0_3 VPWR VGND VPWR VGND sky130_ef_sc_hd__decap_12
XFILLER_3_357 VPWR VGND VPWR VGND sky130_ef_sc_hd__decap_12
XFILLER_66_309 VPWR VGND VPWR VGND sky130_ef_sc_hd__decap_12
Xfanout171 net172 VGND VGND VPWR VPWR net171 sky130_fd_sc_hd__buf_2
XFILLER_87_681 VGND VGND VPWR VPWR sky130_fd_sc_hd__decap_3
Xfanout160 _3699_ VGND VGND VPWR VPWR net160 sky130_fd_sc_hd__clkbuf_4
Xfanout182 _0718_ VGND VGND VPWR VPWR net182 sky130_fd_sc_hd__buf_2
XFILLER_47_523 VGND VGND VPWR VPWR sky130_fd_sc_hd__fill_1
Xfanout193 net194 VGND VGND VPWR VPWR net193 sky130_fd_sc_hd__buf_4
XFILLER_47_545 VPWR VGND VPWR VGND sky130_ef_sc_hd__decap_12
XTAP_TAPCELL_ROW_17_459 VGND VPWR sky130_fd_sc_hd__tapvpwrvgnd_1
XFILLER_15_475 VGND VGND VPWR VPWR sky130_fd_sc_hd__decap_8
XFILLER_42_283 VGND VGND VPWR VPWR sky130_fd_sc_hd__decap_4
XFILLER_7_641 VPWR VGND VPWR VGND sky130_ef_sc_hd__decap_12
XFILLER_7_685 VPWR VGND VPWR VGND sky130_ef_sc_hd__decap_12
XFILLER_6_162 VGND VGND VPWR VPWR sky130_fd_sc_hd__decap_8
XTAP_TAPCELL_ROW_90_1336 VGND VPWR sky130_fd_sc_hd__tapvpwrvgnd_1
X_6090_ _1609_ _1621_ _1622_ VGND VGND VPWR VPWR _1623_ sky130_fd_sc_hd__and3_1
XFILLER_69_125 VGND VGND VPWR VPWR sky130_fd_sc_hd__fill_2
X_5110_ _0815_ _0817_ _0848_ _0849_ VGND VGND VPWR VPWR _0850_ sky130_fd_sc_hd__o211ai_2
XFILLER_85_607 VGND VGND VPWR VPWR sky130_fd_sc_hd__fill_2
XFILLER_69_147 VGND VGND VPWR VPWR sky130_fd_sc_hd__fill_1
X_5041_ _0776_ _0782_ VGND VGND VPWR VPWR _0784_ sky130_fd_sc_hd__xor2_2
XFILLER_111_277 VGND VGND VPWR VPWR sky130_fd_sc_hd__decap_3
XFILLER_78_681 VPWR VGND VPWR VGND sky130_ef_sc_hd__decap_12
XFILLER_69_169 VGND VGND VPWR VPWR sky130_fd_sc_hd__decap_8
X_8800_ net155 _4170_ VGND VGND VPWR VPWR _4171_ sky130_fd_sc_hd__xnor2_1
XFILLER_38_589 VPWR VGND VPWR VGND sky130_ef_sc_hd__decap_12
X_8731_ net192 _4103_ VGND VGND VPWR VPWR _4104_ sky130_fd_sc_hd__and2_1
XFILLER_65_386 VGND VGND VPWR VPWR sky130_fd_sc_hd__decap_6
X_6992_ pe_array\[1\].u_pe.accum_reg\[9\] net449 net341 VGND VGND VPWR VPWR _2460_
+ sky130_fd_sc_hd__and3_4
X_5943_ net466 _1477_ _1478_ VGND VGND VPWR VPWR _1479_ sky130_fd_sc_hd__a21bo_1
XFILLER_53_559 VGND VGND VPWR VPWR sky130_fd_sc_hd__fill_1
X_8662_ net420 _4037_ VGND VGND VPWR VPWR _0395_ sky130_fd_sc_hd__nor2_1
X_5874_ _1410_ _1411_ VGND VGND VPWR VPWR _1412_ sky130_fd_sc_hd__nor2_1
X_8593_ _3939_ _3968_ _3969_ VGND VGND VPWR VPWR _3971_ sky130_fd_sc_hd__and3_1
X_4825_ _0569_ _0570_ net285 VGND VGND VPWR VPWR _0573_ sky130_fd_sc_hd__o21ai_1
X_7613_ _3062_ _3061_ VGND VGND VPWR VPWR _3063_ sky130_fd_sc_hd__and2b_1
XFILLER_21_478 VGND VGND VPWR VPWR sky130_fd_sc_hd__fill_2
X_7544_ _2965_ _2967_ _2994_ _2995_ VGND VGND VPWR VPWR _2996_ sky130_fd_sc_hd__o211a_1
X_4756_ net399 pe_array\[3\].u_pe.accum_reg\[9\] net257 _0505_ VGND VGND VPWR VPWR
+ _0506_ sky130_fd_sc_hd__o2bb2a_1
XFILLER_107_517 VGND VGND VPWR VPWR sky130_fd_sc_hd__decap_4
X_7475_ _2929_ _2926_ VGND VGND VPWR VPWR _2930_ sky130_fd_sc_hd__xnor2_2
X_4687_ _0436_ _0437_ VGND VGND VPWR VPWR _0438_ sky130_fd_sc_hd__and2b_2
X_6426_ _1895_ _1948_ _1947_ VGND VGND VPWR VPWR _1949_ sky130_fd_sc_hd__o21ba_1
X_9214_ clknet_leaf_31_clk _0326_ VGND VGND VPWR VPWR pe_accum\[1\]\[0\] sky130_fd_sc_hd__dfxtp_1
XFILLER_115_561 VPWR VGND VPWR VGND sky130_ef_sc_hd__decap_12
XFILLER_115_550 VGND VGND VPWR VPWR sky130_fd_sc_hd__decap_8
X_6357_ _1879_ _1880_ VGND VGND VPWR VPWR _1882_ sky130_fd_sc_hd__xnor2_1
X_9145_ clknet_leaf_20_clk _0257_ VGND VGND VPWR VPWR pe_array\[0\].u_pe.accum_reg\[31\]
+ sky130_fd_sc_hd__dfxtp_1
XFILLER_88_412 VGND VGND VPWR VPWR sky130_fd_sc_hd__decap_8
X_5308_ _1039_ _1040_ VGND VGND VPWR VPWR _1041_ sky130_fd_sc_hd__nor2_1
X_6288_ _1811_ _1812_ net706 VGND VGND VPWR VPWR _1815_ sky130_fd_sc_hd__o21ai_1
X_9076_ clknet_leaf_59_clk _0188_ VGND VGND VPWR VPWR net25 sky130_fd_sc_hd__dfxtp_1
XTAP_TAPCELL_ROW_110_1572 VGND VPWR sky130_fd_sc_hd__tapvpwrvgnd_1
X_8027_ net443 _3418_ _3419_ VGND VGND VPWR VPWR _3420_ sky130_fd_sc_hd__and3_4
X_5239_ _0944_ _0974_ VGND VGND VPWR VPWR _0975_ sky130_fd_sc_hd__nand2_1
XFILLER_29_501 VGND VGND VPWR VPWR sky130_fd_sc_hd__decap_3
XFILLER_83_161 VGND VGND VPWR VPWR sky130_fd_sc_hd__decap_6
XFILLER_44_526 VGND VGND VPWR VPWR sky130_fd_sc_hd__decap_6
X_8929_ clknet_leaf_60_clk _0041_ VGND VGND VPWR VPWR pe_array\[3\].u_pe.accum_reg\[29\]
+ sky130_fd_sc_hd__dfxtp_1
XTAP_TAPCELL_ROW_14_418 VGND VPWR sky130_fd_sc_hd__tapvpwrvgnd_1
XFILLER_12_412 VGND VGND VPWR VPWR sky130_fd_sc_hd__decap_8
XFILLER_24_250 VGND VGND VPWR VPWR sky130_fd_sc_hd__fill_2
XFILLER_12_445 VPWR VGND VPWR VGND sky130_ef_sc_hd__decap_12
XFILLER_33_31 VGND VGND VPWR VPWR sky130_fd_sc_hd__decap_6
XFILLER_12_489 VPWR VGND VPWR VGND sky130_ef_sc_hd__decap_12
XFILLER_3_154 VGND VGND VPWR VPWR sky130_fd_sc_hd__decap_3
XFILLER_4_699 VGND VGND VPWR VPWR sky130_fd_sc_hd__fill_1
XFILLER_3_165 VGND VGND VPWR VPWR sky130_fd_sc_hd__decap_3
XFILLER_94_404 VPWR VGND VPWR VGND sky130_ef_sc_hd__decap_12
XFILLER_67_629 VPWR VGND VPWR VGND sky130_ef_sc_hd__decap_12
XFILLER_58_83 VGND VGND VPWR VPWR sky130_fd_sc_hd__fill_1
XFILLER_75_673 VGND VGND VPWR VPWR sky130_fd_sc_hd__decap_4
XFILLER_90_610 VGND VGND VPWR VPWR sky130_fd_sc_hd__fill_1
XFILLER_90_676 VGND VGND VPWR VPWR sky130_fd_sc_hd__decap_8
XFILLER_50_518 VGND VGND VPWR VPWR sky130_fd_sc_hd__fill_2
X_4610_ _4371_ _4370_ _4333_ _4334_ VGND VGND VPWR VPWR _4373_ sky130_fd_sc_hd__a211o_1
XFILLER_90_92 VGND VGND VPWR VPWR sky130_fd_sc_hd__fill_1
X_5590_ net962 net375 VGND VGND VPWR VPWR _0131_ sky130_fd_sc_hd__and2_1
X_4541_ _4304_ _4303_ net303 net492 VGND VGND VPWR VPWR _4306_ sky130_fd_sc_hd__or4bb_4
Xhold416 pe_accum\[2\]\[21\] VGND VGND VPWR VPWR net931 sky130_fd_sc_hd__dlygate4sd3_1
Xhold405 pe_accum\[0\]\[29\] VGND VGND VPWR VPWR net920 sky130_fd_sc_hd__dlygate4sd3_1
Xhold427 pe_accum\[0\]\[30\] VGND VGND VPWR VPWR net942 sky130_fd_sc_hd__dlygate4sd3_1
X_7260_ _2660_ _2684_ _2683_ VGND VGND VPWR VPWR _2722_ sky130_fd_sc_hd__o21bai_1
X_4472_ net416 _4244_ VGND VGND VPWR VPWR _0008_ sky130_fd_sc_hd__nor2_1
Xhold438 pe_accum\[2\]\[5\] VGND VGND VPWR VPWR net953 sky130_fd_sc_hd__dlygate4sd3_1
X_6211_ _1739_ _1738_ VGND VGND VPWR VPWR _1741_ sky130_fd_sc_hd__xnor2_2
X_7191_ _2654_ VGND VGND VPWR VPWR _2655_ sky130_fd_sc_hd__inv_2
Xhold449 pe_accum\[1\]\[7\] VGND VGND VPWR VPWR net964 sky130_fd_sc_hd__dlygate4sd3_1
X_6142_ _1597_ _1635_ _1634_ VGND VGND VPWR VPWR _1674_ sky130_fd_sc_hd__a21boi_2
XFILLER_112_586 VGND VGND VPWR VPWR sky130_fd_sc_hd__fill_2
X_6073_ _1600_ _1605_ VGND VGND VPWR VPWR _1606_ sky130_fd_sc_hd__nand2_1
X_5024_ _0763_ _0764_ _0765_ VGND VGND VPWR VPWR _0767_ sky130_fd_sc_hd__a21o_1
XFILLER_38_342 VGND VGND VPWR VPWR sky130_fd_sc_hd__fill_1
XFILLER_54_19 VGND VGND VPWR VPWR sky130_fd_sc_hd__decap_8
X_6975_ _2404_ _2406_ VGND VGND VPWR VPWR _2443_ sky130_fd_sc_hd__nand2_1
X_8714_ _4087_ _4086_ VGND VGND VPWR VPWR _4088_ sky130_fd_sc_hd__xnor2_2
X_5926_ _1416_ _1462_ VGND VGND VPWR VPWR _1463_ sky130_fd_sc_hd__xor2_1
XFILLER_80_153 VPWR VGND VPWR VGND sky130_ef_sc_hd__decap_12
X_8645_ _4020_ _4019_ VGND VGND VPWR VPWR _4021_ sky130_fd_sc_hd__and2b_1
X_5857_ pe_array\[0\].u_pe.accum_reg\[7\] pe_array\[0\].u_pe.weight_in\[7\] VGND VGND
+ VPWR VPWR _1395_ sky130_fd_sc_hd__nand2_1
XFILLER_70_29 VGND VGND VPWR VPWR sky130_fd_sc_hd__decap_3
XFILLER_21_264 VPWR VGND VPWR VGND sky130_ef_sc_hd__decap_12
X_8576_ _3951_ _3952_ _3919_ _3920_ VGND VGND VPWR VPWR _3954_ sky130_fd_sc_hd__a211o_1
X_5788_ _1320_ _1326_ _1327_ VGND VGND VPWR VPWR _1328_ sky130_fd_sc_hd__nand3_1
X_4808_ net293 net460 _0437_ net578 VGND VGND VPWR VPWR _0556_ sky130_fd_sc_hd__a31o_1
X_7527_ _2942_ _2944_ _2978_ VGND VGND VPWR VPWR _2980_ sky130_fd_sc_hd__nor3_1
X_4739_ _0481_ _0487_ _0488_ VGND VGND VPWR VPWR _0489_ sky130_fd_sc_hd__nand3_1
X_7458_ _2911_ _2912_ VGND VGND VPWR VPWR _2913_ sky130_fd_sc_hd__nor2_1
XTAP_TAPCELL_ROW_112_1601 VGND VPWR sky130_fd_sc_hd__tapvpwrvgnd_1
X_6409_ net198 _1905_ _1903_ VGND VGND VPWR VPWR _1932_ sky130_fd_sc_hd__o21a_1
X_7389_ _2845_ _2846_ VGND VGND VPWR VPWR _2847_ sky130_fd_sc_hd__and2b_1
XFILLER_88_220 VGND VGND VPWR VPWR sky130_fd_sc_hd__decap_8
X_9128_ clknet_leaf_33_clk _0240_ VGND VGND VPWR VPWR pe_array\[0\].u_pe.accum_reg\[14\]
+ sky130_fd_sc_hd__dfxtp_1
XFILLER_49_607 VGND VGND VPWR VPWR sky130_fd_sc_hd__decap_8
X_9059_ clknet_leaf_7_clk _0171_ VGND VGND VPWR VPWR net133 sky130_fd_sc_hd__dfxtp_1
XFILLER_48_139 VGND VGND VPWR VPWR sky130_fd_sc_hd__fill_1
XFILLER_57_673 VPWR VGND VPWR VGND sky130_ef_sc_hd__decap_12
XFILLER_28_42 VGND VGND VPWR VPWR sky130_fd_sc_hd__decap_8
XTAP_TAPCELL_ROW_47_819 VGND VPWR sky130_fd_sc_hd__tapvpwrvgnd_1
XFILLER_84_481 VGND VGND VPWR VPWR sky130_fd_sc_hd__fill_1
XFILLER_56_172 VGND VGND VPWR VPWR sky130_fd_sc_hd__decap_6
XFILLER_72_643 VGND VGND VPWR VPWR sky130_fd_sc_hd__fill_1
XFILLER_71_164 VGND VGND VPWR VPWR sky130_fd_sc_hd__decap_4
XTAP_TAPCELL_ROW_27_576 VGND VPWR sky130_fd_sc_hd__tapvpwrvgnd_1
XFILLER_44_41 VPWR VGND VPWR VGND sky130_ef_sc_hd__decap_12
XFILLER_44_85 VPWR VGND VPWR VGND sky130_ef_sc_hd__decap_12
XFILLER_12_253 VGND VGND VPWR VPWR sky130_fd_sc_hd__decap_4
XFILLER_100_80 VGND VGND VPWR VPWR sky130_fd_sc_hd__decap_4
XFILLER_8_279 VGND VGND VPWR VPWR sky130_fd_sc_hd__decap_6
XFILLER_8_257 VGND VGND VPWR VPWR sky130_fd_sc_hd__fill_1
XTAP_TAPCELL_ROW_74_1139 VGND VPWR sky130_fd_sc_hd__tapvpwrvgnd_1
XFILLER_5_79 VGND VGND VPWR VPWR sky130_fd_sc_hd__fill_1
XFILLER_5_57 VPWR VGND VPWR VGND sky130_ef_sc_hd__decap_12
XFILLER_94_201 VGND VGND VPWR VPWR sky130_fd_sc_hd__fill_1
XFILLER_94_245 VGND VGND VPWR VPWR sky130_fd_sc_hd__decap_6
XFILLER_54_109 VGND VGND VPWR VPWR sky130_fd_sc_hd__decap_8
XFILLER_85_92 VPWR VGND VPWR VGND sky130_ef_sc_hd__decap_12
XFILLER_47_161 VGND VGND VPWR VPWR sky130_fd_sc_hd__decap_6
XTAP_TAPCELL_ROW_85_1279 VGND VPWR sky130_fd_sc_hd__tapvpwrvgnd_1
XTAP_TAPCELL_ROW_85_1268 VGND VPWR sky130_fd_sc_hd__tapvpwrvgnd_1
X_6760_ _2220_ _2233_ VGND VGND VPWR VPWR _2235_ sky130_fd_sc_hd__and2_1
X_5711_ pe_array\[0\].u_pe.accum_reg\[2\] net498 net357 VGND VGND VPWR VPWR _1254_
+ sky130_fd_sc_hd__and3_1
X_6691_ net913 net233 _1286_ net242 VGND VGND VPWR VPWR _0261_ sky130_fd_sc_hd__o2bb2ai_1
X_8430_ net161 _3782_ _3781_ VGND VGND VPWR VPWR _3813_ sky130_fd_sc_hd__o21bai_1
X_5642_ net1015 net371 VGND VGND VPWR VPWR _0183_ sky130_fd_sc_hd__and2_1
XFILLER_117_601 VPWR VGND VPWR VGND sky130_ef_sc_hd__decap_12
X_5573_ net915 net392 VGND VGND VPWR VPWR _0114_ sky130_fd_sc_hd__and2_1
X_8361_ _3743_ _3744_ net161 VGND VGND VPWR VPWR _3746_ sky130_fd_sc_hd__o21ai_1
XFILLER_117_645 VPWR VGND VPWR VGND sky130_ef_sc_hd__decap_12
X_7312_ _2731_ _2733_ _2770_ _2771_ VGND VGND VPWR VPWR _2772_ sky130_fd_sc_hd__o211a_1
X_4524_ _4287_ _4288_ _4267_ VGND VGND VPWR VPWR _4290_ sky130_fd_sc_hd__o21ai_1
XFILLER_116_155 VGND VGND VPWR VPWR sky130_fd_sc_hd__fill_1
X_8292_ net187 _3676_ _3678_ VGND VGND VPWR VPWR _3679_ sky130_fd_sc_hd__or3b_1
XFILLER_104_317 VGND VGND VPWR VPWR sky130_fd_sc_hd__fill_1
X_4455_ net12 VGND VGND VPWR VPWR _4236_ sky130_fd_sc_hd__inv_2
X_7243_ net266 _2702_ _2703_ VGND VGND VPWR VPWR _2705_ sky130_fd_sc_hd__or3_4
X_7174_ _2634_ _2635_ _2587_ _2588_ VGND VGND VPWR VPWR _2638_ sky130_fd_sc_hd__a211o_1
XFILLER_100_501 VGND VGND VPWR VPWR sky130_fd_sc_hd__fill_1
X_6125_ net642 _1654_ _1656_ VGND VGND VPWR VPWR _1657_ sky130_fd_sc_hd__or3b_4
X_6056_ _1589_ _1588_ VGND VGND VPWR VPWR _1590_ sky130_fd_sc_hd__and2b_1
XFILLER_100_589 VPWR VGND VPWR VGND sky130_ef_sc_hd__decap_12
X_5007_ pe_array\[3\].u_pe.accum_reg\[16\] net297 net433 VGND VGND VPWR VPWR _0750_
+ sky130_fd_sc_hd__and3_1
XFILLER_54_676 VPWR VGND VPWR VGND sky130_ef_sc_hd__decap_12
XFILLER_41_304 VGND VGND VPWR VPWR sky130_fd_sc_hd__decap_8
XFILLER_41_337 VGND VGND VPWR VPWR sky130_fd_sc_hd__decap_3
X_6958_ _2407_ _2425_ _2426_ VGND VGND VPWR VPWR _2427_ sky130_fd_sc_hd__nand3_2
X_5909_ _1442_ _1443_ _1444_ VGND VGND VPWR VPWR _1446_ sky130_fd_sc_hd__a21o_1
XTAP_TAPCELL_ROW_52_877 VGND VPWR sky130_fd_sc_hd__tapvpwrvgnd_1
XTAP_TAPCELL_ROW_24_546 VGND VPWR sky130_fd_sc_hd__tapvpwrvgnd_1
X_6889_ _2319_ _2358_ VGND VGND VPWR VPWR _2359_ sky130_fd_sc_hd__xnor2_1
X_8628_ _3968_ _4004_ VGND VGND VPWR VPWR _4005_ sky130_fd_sc_hd__or2_1
XFILLER_22_595 VGND VGND VPWR VPWR sky130_fd_sc_hd__decap_6
X_8559_ net159 _3906_ _3905_ VGND VGND VPWR VPWR _3938_ sky130_fd_sc_hd__a21o_1
Xrebuffer310 net827 VGND VGND VPWR VPWR net825 sky130_fd_sc_hd__dlygate4sd1_1
XFILLER_108_645 VGND VGND VPWR VPWR sky130_fd_sc_hd__decap_4
Xrebuffer354 _3561_ VGND VGND VPWR VPWR net869 sky130_fd_sc_hd__buf_6
XPHY_EDGE_ROW_15_Left_133 VGND VGND VPWR VPWR sky130_fd_sc_hd__decap_3
XFILLER_30_54 VGND VGND VPWR VPWR sky130_fd_sc_hd__decap_4
XFILLER_30_65 VPWR VGND VPWR VGND sky130_ef_sc_hd__decap_12
XFILLER_100_3 VPWR VGND VPWR VGND sky130_ef_sc_hd__decap_12
XFILLER_1_433 VPWR VGND VPWR VGND sky130_ef_sc_hd__decap_12
XFILLER_110_309 VPWR VGND VPWR VGND sky130_ef_sc_hd__decap_12
XFILLER_39_52 VGND VGND VPWR VPWR sky130_fd_sc_hd__decap_4
XPHY_EDGE_ROW_24_Left_142 VGND VGND VPWR VPWR sky130_fd_sc_hd__decap_3
XFILLER_44_153 VGND VGND VPWR VPWR sky130_fd_sc_hd__decap_4
XFILLER_44_164 VGND VGND VPWR VPWR sky130_fd_sc_hd__fill_2
XFILLER_44_197 VGND VGND VPWR VPWR sky130_fd_sc_hd__decap_6
XFILLER_71_50 VGND VGND VPWR VPWR sky130_fd_sc_hd__decap_6
XFILLER_13_573 VGND VGND VPWR VPWR sky130_fd_sc_hd__decap_4
XFILLER_13_584 VPWR VGND VPWR VGND sky130_ef_sc_hd__decap_12
XFILLER_9_566 VPWR VGND VPWR VGND sky130_ef_sc_hd__decap_12
XPHY_EDGE_ROW_33_Left_151 VGND VGND VPWR VPWR sky130_fd_sc_hd__decap_3
XFILLER_114_637 VGND VGND VPWR VPWR sky130_fd_sc_hd__decap_6
XFILLER_113_125 VGND VGND VPWR VPWR sky130_fd_sc_hd__decap_8
XFILLER_99_337 VGND VGND VPWR VPWR sky130_fd_sc_hd__decap_6
XFILLER_96_80 VGND VGND VPWR VPWR sky130_fd_sc_hd__decap_4
XFILLER_67_234 VGND VGND VPWR VPWR sky130_fd_sc_hd__decap_4
XFILLER_95_554 VGND VGND VPWR VPWR sky130_fd_sc_hd__fill_2
XPHY_EDGE_ROW_42_Left_160 VGND VGND VPWR VPWR sky130_fd_sc_hd__decap_3
X_7930_ _3297_ _3302_ _3296_ VGND VGND VPWR VPWR _3325_ sky130_fd_sc_hd__a21bo_1
XFILLER_55_418 VPWR VGND VPWR VGND sky130_ef_sc_hd__decap_12
X_7861_ _3239_ _3241_ VGND VGND VPWR VPWR _3259_ sky130_fd_sc_hd__and2_1
XFILLER_63_473 VGND VGND VPWR VPWR sky130_fd_sc_hd__decap_4
X_6812_ _2258_ _2260_ net1 net329 VGND VGND VPWR VPWR _2284_ sky130_fd_sc_hd__o211a_1
XFILLER_51_613 VGND VGND VPWR VPWR sky130_fd_sc_hd__decap_3
X_7792_ net981 net226 _3205_ net378 VGND VGND VPWR VPWR _0357_ sky130_fd_sc_hd__o211a_1
X_6743_ _2217_ _2218_ VGND VGND VPWR VPWR _2219_ sky130_fd_sc_hd__nor2_1
X_6674_ _2170_ _2171_ VGND VGND VPWR VPWR _2188_ sky130_fd_sc_hd__nor2_1
XTAP_TAPCELL_ROW_21_505 VGND VPWR sky130_fd_sc_hd__tapvpwrvgnd_1
XTAP_TAPCELL_ROW_98_1426 VGND VPWR sky130_fd_sc_hd__tapvpwrvgnd_1
X_8413_ net401 pe_array\[2\].u_pe.accum_reg\[17\] net217 _3796_ VGND VGND VPWR VPWR
+ _3797_ sky130_fd_sc_hd__o2bb2a_4
X_5625_ net996 net380 VGND VGND VPWR VPWR _0166_ sky130_fd_sc_hd__and2_1
X_5556_ net896 net391 VGND VGND VPWR VPWR _0097_ sky130_fd_sc_hd__and2_1
X_8344_ _3728_ _3729_ VGND VGND VPWR VPWR _3730_ sky130_fd_sc_hd__xor2_2
X_8275_ _3581_ _3629_ _3632_ VGND VGND VPWR VPWR _3662_ sky130_fd_sc_hd__a21o_1
X_5487_ net253 _0553_ VGND VGND VPWR VPWR _1204_ sky130_fd_sc_hd__nand2_1
X_4507_ _4251_ _4259_ _4272_ VGND VGND VPWR VPWR _4274_ sky130_fd_sc_hd__a21oi_1
XFILLER_104_125 VGND VGND VPWR VPWR sky130_fd_sc_hd__decap_6
XFILLER_104_114 VGND VGND VPWR VPWR sky130_fd_sc_hd__fill_1
X_7226_ _2650_ _2687_ _2688_ VGND VGND VPWR VPWR _2689_ sky130_fd_sc_hd__or3_4
XFILLER_104_169 VGND VGND VPWR VPWR sky130_fd_sc_hd__decap_4
Xfanout512 net515 VGND VGND VPWR VPWR net512 sky130_fd_sc_hd__buf_2
Xfanout501 net502 VGND VGND VPWR VPWR net501 sky130_fd_sc_hd__buf_8
X_7157_ _2579_ _2580_ _2578_ VGND VGND VPWR VPWR _2621_ sky130_fd_sc_hd__a21oi_1
XFILLER_100_353 VGND VGND VPWR VPWR sky130_fd_sc_hd__decap_8
X_6108_ net347 net345 net455 VGND VGND VPWR VPWR _1640_ sky130_fd_sc_hd__o21ai_1
X_7088_ _2502_ _2509_ _2508_ VGND VGND VPWR VPWR _2554_ sky130_fd_sc_hd__a21bo_1
XFILLER_86_598 VGND VGND VPWR VPWR sky130_fd_sc_hd__decap_6
X_6039_ _1569_ _1570_ net656 VGND VGND VPWR VPWR _1573_ sky130_fd_sc_hd__o21ai_1
XTAP_TAPCELL_ROW_57_936 VGND VPWR sky130_fd_sc_hd__tapvpwrvgnd_1
XFILLER_18_109 VGND VGND VPWR VPWR sky130_fd_sc_hd__fill_2
XTAP_TAPCELL_ROW_29_605 VGND VPWR sky130_fd_sc_hd__tapvpwrvgnd_1
XTAP_TAPCELL_ROW_107_1533 VGND VPWR sky130_fd_sc_hd__tapvpwrvgnd_1
XFILLER_92_27 VGND VGND VPWR VPWR sky130_fd_sc_hd__fill_1
Xrebuffer72 net502 VGND VGND VPWR VPWR net587 sky130_fd_sc_hd__dlygate4sd1_1
XTAP_TAPCELL_ROW_1_263 VGND VPWR sky130_fd_sc_hd__tapvpwrvgnd_1
XFILLER_42_613 VGND VGND VPWR VPWR sky130_fd_sc_hd__decap_6
Xrebuffer83 _3898_ VGND VGND VPWR VPWR net598 sky130_fd_sc_hd__dlymetal6s4s_1
XFILLER_81_281 VGND VGND VPWR VPWR sky130_fd_sc_hd__fill_1
Xrebuffer94 _1497_ VGND VGND VPWR VPWR net609 sky130_fd_sc_hd__buf_1
XFILLER_54_495 VPWR VGND VPWR VGND sky130_ef_sc_hd__decap_12
XFILLER_54_484 VGND VGND VPWR VPWR sky130_fd_sc_hd__decap_8
XFILLER_26_197 VGND VGND VPWR VPWR sky130_fd_sc_hd__decap_3
XTAP_TAPCELL_ROW_37_693 VGND VPWR sky130_fd_sc_hd__tapvpwrvgnd_1
XFILLER_42_635 VGND VGND VPWR VPWR sky130_fd_sc_hd__fill_1
XFILLER_10_510 VGND VGND VPWR VPWR sky130_fd_sc_hd__fill_1
Xrebuffer140 _1641_ VGND VGND VPWR VPWR net655 sky130_fd_sc_hd__dlygate4sd1_1
XFILLER_6_503 VGND VGND VPWR VPWR sky130_fd_sc_hd__decap_4
Xrebuffer162 _3604_ VGND VGND VPWR VPWR net677 sky130_fd_sc_hd__buf_1
XFILLER_108_475 VGND VGND VPWR VPWR sky130_fd_sc_hd__fill_1
XFILLER_108_497 VGND VGND VPWR VPWR sky130_fd_sc_hd__fill_2
XTAP_TAPCELL_ROW_71_1109 VGND VPWR sky130_fd_sc_hd__tapvpwrvgnd_1
XFILLER_111_629 VPWR VGND VPWR VGND sky130_ef_sc_hd__decap_12
XTAP_TAPCELL_ROW_9_363 VGND VPWR sky130_fd_sc_hd__tapvpwrvgnd_1
XTAP_TAPCELL_ROW_82_1238 VGND VPWR sky130_fd_sc_hd__tapvpwrvgnd_1
XFILLER_60_410 VGND VGND VPWR VPWR sky130_fd_sc_hd__fill_1
XFILLER_17_186 VGND VGND VPWR VPWR sky130_fd_sc_hd__decap_3
XFILLER_32_101 VGND VGND VPWR VPWR sky130_fd_sc_hd__decap_3
XFILLER_32_112 VGND VGND VPWR VPWR sky130_fd_sc_hd__fill_1
X_6390_ net158 _1913_ VGND VGND VPWR VPWR _1914_ sky130_fd_sc_hd__xnor2_1
XFILLER_63_3 VPWR VGND VPWR VGND sky130_ef_sc_hd__decap_12
X_5410_ net627 _1139_ VGND VGND VPWR VPWR _1140_ sky130_fd_sc_hd__xnor2_1
Xoutput115 net115 VGND VGND VPWR VPWR result_data[69] sky130_fd_sc_hd__buf_2
XFILLER_114_401 VGND VGND VPWR VPWR sky130_fd_sc_hd__fill_2
X_5341_ net689 _1072_ VGND VGND VPWR VPWR _1073_ sky130_fd_sc_hd__xnor2_1
Xoutput104 net104 VGND VGND VPWR VPWR result_data[59] sky130_fd_sc_hd__buf_2
Xoutput137 net137 VGND VGND VPWR VPWR result_data[89] sky130_fd_sc_hd__buf_2
XTAP_TAPCELL_ROW_93_1367 VGND VPWR sky130_fd_sc_hd__tapvpwrvgnd_1
Xoutput126 net126 VGND VGND VPWR VPWR result_data[79] sky130_fd_sc_hd__buf_2
X_8060_ net493 _4238_ VGND VGND VPWR VPWR _3452_ sky130_fd_sc_hd__or2_1
Xoutput148 net148 VGND VGND VPWR VPWR result_data[99] sky130_fd_sc_hd__buf_2
XFILLER_114_467 VGND VGND VPWR VPWR sky130_fd_sc_hd__fill_1
X_5272_ _1004_ _1005_ VGND VGND VPWR VPWR _1007_ sky130_fd_sc_hd__xnor2_1
X_7011_ net522 _2476_ _2443_ VGND VGND VPWR VPWR _2479_ sky130_fd_sc_hd__a21oi_1
XFILLER_95_362 VGND VGND VPWR VPWR sky130_fd_sc_hd__decap_6
XFILLER_68_587 VGND VGND VPWR VPWR sky130_fd_sc_hd__fill_1
X_8962_ clknet_leaf_58_clk _0074_ VGND VGND VPWR VPWR pe_accum\[3\]\[30\] sky130_fd_sc_hd__dfxtp_1
XFILLER_28_407 VGND VGND VPWR VPWR sky130_fd_sc_hd__fill_1
X_7913_ net512 net310 _3274_ _3277_ VGND VGND VPWR VPWR _3309_ sky130_fd_sc_hd__a211oi_1
XFILLER_102_15 VPWR VGND VPWR VGND sky130_ef_sc_hd__decap_12
X_8893_ clknet_leaf_0_clk _0005_ VGND VGND VPWR VPWR pe_array\[0\].u_pe.weight_in\[5\]
+ sky130_fd_sc_hd__dfxtp_1
XTAP_TAPCELL_ROW_54_906 VGND VPWR sky130_fd_sc_hd__tapvpwrvgnd_1
X_7844_ _3241_ _3242_ VGND VGND VPWR VPWR _3243_ sky130_fd_sc_hd__nand2_1
XFILLER_63_281 VGND VGND VPWR VPWR sky130_fd_sc_hd__decap_6
XFILLER_62_19 VGND VGND VPWR VPWR sky130_fd_sc_hd__decap_8
XFILLER_63_292 VGND VGND VPWR VPWR sky130_fd_sc_hd__decap_8
X_7775_ _2957_ net221 VGND VGND VPWR VPWR _3197_ sky130_fd_sc_hd__nand2_2
XTAP_TAPCELL_ROW_62_994 VGND VPWR sky130_fd_sc_hd__tapvpwrvgnd_1
X_6726_ net507 pe_array\[1\].u_pe.tap_count\[1\] pe_array\[1\].u_pe.tap_count\[0\]
+ VGND VGND VPWR VPWR _2206_ sky130_fd_sc_hd__and3_1
XFILLER_23_167 VGND VGND VPWR VPWR sky130_fd_sc_hd__fill_1
XTAP_TAPCELL_ROW_34_663 VGND VPWR sky130_fd_sc_hd__tapvpwrvgnd_1
X_4987_ _0728_ _0729_ _0730_ VGND VGND VPWR VPWR _0731_ sky130_fd_sc_hd__and3_1
XTAP_TAPCELL_ROW_102_1474 VGND VPWR sky130_fd_sc_hd__tapvpwrvgnd_1
X_6657_ _2162_ _2169_ VGND VGND VPWR VPWR _2172_ sky130_fd_sc_hd__xnor2_1
X_6588_ _2102_ _2103_ VGND VGND VPWR VPWR _2105_ sky130_fd_sc_hd__xnor2_1
X_5608_ net981 net378 VGND VGND VPWR VPWR _0149_ sky130_fd_sc_hd__and2_1
X_8327_ net189 _3678_ _3676_ VGND VGND VPWR VPWR _3713_ sky130_fd_sc_hd__a21o_1
X_5539_ net18 _1226_ _1227_ net329 VGND VGND VPWR VPWR _0082_ sky130_fd_sc_hd__a22o_1
XFILLER_117_294 VGND VGND VPWR VPWR sky130_fd_sc_hd__decap_3
X_8258_ _3642_ _3643_ _3644_ VGND VGND VPWR VPWR _3646_ sky130_fd_sc_hd__a21o_1
Xfanout320 net321 VGND VGND VPWR VPWR net320 sky130_fd_sc_hd__clkbuf_2
X_8189_ net401 pe_array\[2\].u_pe.accum_reg\[11\] net217 _3578_ VGND VGND VPWR VPWR
+ _3579_ sky130_fd_sc_hd__o2bb2a_1
XFILLER_59_521 VGND VGND VPWR VPWR sky130_fd_sc_hd__fill_2
Xfanout331 pe_array\[1\].u_pe.weight_in\[4\] VGND VGND VPWR VPWR net331 sky130_fd_sc_hd__clkbuf_2
XTAP_TAPCELL_ROW_6_322 VGND VPWR sky130_fd_sc_hd__tapvpwrvgnd_1
X_7209_ _2632_ _2633_ _2670_ _2671_ VGND VGND VPWR VPWR _2672_ sky130_fd_sc_hd__o211a_1
XFILLER_101_651 VGND VGND VPWR VPWR sky130_fd_sc_hd__decap_4
Xfanout353 pe_array\[0\].u_pe.weight_in\[2\] VGND VGND VPWR VPWR net353 sky130_fd_sc_hd__buf_2
Xfanout342 net343 VGND VGND VPWR VPWR net342 sky130_fd_sc_hd__buf_2
Xfanout364 net369 VGND VGND VPWR VPWR net364 sky130_fd_sc_hd__buf_1
Xfanout375 net396 VGND VGND VPWR VPWR net375 sky130_fd_sc_hd__buf_2
Xfanout386 net388 VGND VGND VPWR VPWR net386 sky130_fd_sc_hd__dlymetal6s2s_1
XFILLER_101_684 VPWR VGND VPWR VGND sky130_ef_sc_hd__decap_12
XFILLER_101_673 VGND VGND VPWR VPWR sky130_fd_sc_hd__decap_6
XFILLER_86_384 VGND VGND VPWR VPWR sky130_fd_sc_hd__decap_4
XFILLER_86_351 VPWR VGND VPWR VGND sky130_ef_sc_hd__decap_12
Xfanout397 net398 VGND VGND VPWR VPWR net397 sky130_fd_sc_hd__buf_2
XFILLER_46_259 VGND VGND VPWR VPWR sky130_fd_sc_hd__fill_1
XTAP_TAPCELL_ROW_68_1071 VGND VPWR sky130_fd_sc_hd__tapvpwrvgnd_1
XFILLER_42_421 VGND VGND VPWR VPWR sky130_fd_sc_hd__decap_4
XFILLER_52_41 VPWR VGND VPWR VGND sky130_ef_sc_hd__decap_12
XFILLER_14_167 VGND VGND VPWR VPWR sky130_fd_sc_hd__fill_1
XFILLER_52_85 VPWR VGND VPWR VGND sky130_ef_sc_hd__decap_12
Xinput17 weight_din[4] VGND VGND VPWR VPWR net17 sky130_fd_sc_hd__clkbuf_2
XFILLER_108_261 VGND VGND VPWR VPWR sky130_fd_sc_hd__decap_6
XFILLER_96_104 VGND VGND VPWR VPWR sky130_fd_sc_hd__fill_1
XFILLER_35_7 VGND VGND VPWR VPWR sky130_fd_sc_hd__fill_1
XFILLER_77_93 VGND VGND VPWR VPWR sky130_fd_sc_hd__fill_2
XFILLER_65_513 VGND VGND VPWR VPWR sky130_fd_sc_hd__fill_1
XFILLER_65_557 VGND VGND VPWR VPWR sky130_fd_sc_hd__decap_3
XFILLER_37_237 VGND VGND VPWR VPWR sky130_fd_sc_hd__decap_8
XFILLER_52_207 VGND VGND VPWR VPWR sky130_fd_sc_hd__decap_3
XFILLER_80_538 VGND VGND VPWR VPWR sky130_fd_sc_hd__decap_6
XFILLER_80_527 VGND VGND VPWR VPWR sky130_fd_sc_hd__fill_1
X_5890_ net580 _4232_ VGND VGND VPWR VPWR _1427_ sky130_fd_sc_hd__nor2_1
XFILLER_18_484 VGND VGND VPWR VPWR sky130_fd_sc_hd__decap_4
X_4910_ net286 _0653_ _0654_ VGND VGND VPWR VPWR _0656_ sky130_fd_sc_hd__or3_4
XFILLER_33_410 VGND VGND VPWR VPWR sky130_fd_sc_hd__decap_3
XFILLER_45_281 VGND VGND VPWR VPWR sky130_fd_sc_hd__decap_6
X_4841_ _0540_ _0538_ _0587_ _0588_ VGND VGND VPWR VPWR _0589_ sky130_fd_sc_hd__a211o_4
X_4772_ net301 net629 VGND VGND VPWR VPWR _0521_ sky130_fd_sc_hd__nand2_1
XTAP_TAPCELL_ROW_31_622 VGND VPWR sky130_fd_sc_hd__tapvpwrvgnd_1
X_7560_ _2984_ _3011_ VGND VGND VPWR VPWR _3012_ sky130_fd_sc_hd__nand2_1
X_6511_ _2030_ VGND VGND VPWR VPWR _2031_ sky130_fd_sc_hd__inv_2
X_7491_ _2700_ _2943_ VGND VGND VPWR VPWR _2945_ sky130_fd_sc_hd__nor2_1
X_6442_ net177 _1963_ VGND VGND VPWR VPWR _1964_ sky130_fd_sc_hd__and2_1
X_9230_ clknet_leaf_45_clk _0342_ VGND VGND VPWR VPWR pe_accum\[1\]\[16\] sky130_fd_sc_hd__dfxtp_1
X_9161_ clknet_leaf_29_clk _0273_ VGND VGND VPWR VPWR pe_accum\[0\]\[15\] sky130_fd_sc_hd__dfxtp_1
XTAP_TAPCELL_ROW_11_390 VGND VPWR sky130_fd_sc_hd__tapvpwrvgnd_1
X_6373_ net431 _1897_ VGND VGND VPWR VPWR _0246_ sky130_fd_sc_hd__nor2_1
X_8112_ _3502_ _3501_ VGND VGND VPWR VPWR _3503_ sky130_fd_sc_hd__nand2b_1
XFILLER_88_616 VGND VGND VPWR VPWR sky130_fd_sc_hd__fill_1
X_9092_ clknet_leaf_64_clk _0204_ VGND VGND VPWR VPWR net42 sky130_fd_sc_hd__dfxtp_1
X_5324_ _1056_ _1055_ VGND VGND VPWR VPWR _1057_ sky130_fd_sc_hd__and2b_1
X_8043_ _3416_ _3434_ _3435_ VGND VGND VPWR VPWR _3436_ sky130_fd_sc_hd__nand3_1
X_5255_ net653 _0987_ _0988_ VGND VGND VPWR VPWR _0990_ sky130_fd_sc_hd__or3_1
XFILLER_87_148 VGND VGND VPWR VPWR sky130_fd_sc_hd__decap_6
XFILLER_57_19 VPWR VGND VPWR VGND sky130_ef_sc_hd__decap_12
X_5186_ net398 pe_array\[3\].u_pe.accum_reg\[21\] net255 _0923_ VGND VGND VPWR VPWR
+ _0924_ sky130_fd_sc_hd__o2bb2a_4
XFILLER_96_693 VGND VGND VPWR VPWR sky130_fd_sc_hd__decap_6
XFILLER_68_384 VGND VGND VPWR VPWR sky130_fd_sc_hd__fill_1
XTAP_TAPCELL_ROW_39_722 VGND VPWR sky130_fd_sc_hd__tapvpwrvgnd_1
XFILLER_113_69 VPWR VGND VPWR VGND sky130_ef_sc_hd__decap_12
XFILLER_71_505 VGND VGND VPWR VPWR sky130_fd_sc_hd__decap_8
X_8945_ clknet_leaf_63_clk _0057_ VGND VGND VPWR VPWR pe_accum\[3\]\[13\] sky130_fd_sc_hd__dfxtp_1
X_8876_ net212 _4061_ VGND VGND VPWR VPWR _4219_ sky130_fd_sc_hd__nand2_2
XTAP_TAPCELL_ROW_104_1503 VGND VPWR sky130_fd_sc_hd__tapvpwrvgnd_1
XFILLER_83_387 VGND VGND VPWR VPWR sky130_fd_sc_hd__decap_4
XFILLER_24_421 VPWR VGND VPWR VGND sky130_ef_sc_hd__decap_12
X_7827_ _3226_ VGND VGND VPWR VPWR _3227_ sky130_fd_sc_hd__inv_2
XFILLER_51_273 VGND VGND VPWR VPWR sky130_fd_sc_hd__decap_6
XFILLER_24_465 VGND VGND VPWR VPWR sky130_fd_sc_hd__fill_1
XFILLER_8_609 VPWR VGND VPWR VGND sky130_ef_sc_hd__decap_12
X_7758_ net940 net223 _3188_ net372 VGND VGND VPWR VPWR _0340_ sky130_fd_sc_hd__o211a_1
X_6709_ net244 _1920_ net236 net941 VGND VGND VPWR VPWR _0279_ sky130_fd_sc_hd__a2bb2o_1
XFILLER_11_159 VGND VGND VPWR VPWR sky130_fd_sc_hd__decap_8
XFILLER_7_108 VGND VGND VPWR VPWR sky130_fd_sc_hd__decap_4
X_7689_ net426 _3136_ VGND VGND VPWR VPWR _0323_ sky130_fd_sc_hd__nor2_1
XFILLER_20_682 VGND VGND VPWR VPWR sky130_fd_sc_hd__fill_1
XFILLER_98_15 VPWR VGND VPWR VGND sky130_ef_sc_hd__decap_12
XTAP_TAPCELL_ROW_115_1632 VGND VPWR sky130_fd_sc_hd__tapvpwrvgnd_1
XFILLER_98_37 VGND VGND VPWR VPWR sky130_fd_sc_hd__fill_1
XFILLER_105_242 VPWR VGND VPWR VGND sky130_ef_sc_hd__decap_12
XFILLER_3_369 VGND VGND VPWR VPWR sky130_fd_sc_hd__fill_1
XFILLER_78_126 VGND VGND VPWR VPWR sky130_fd_sc_hd__fill_1
XFILLER_105_297 VGND VGND VPWR VPWR sky130_fd_sc_hd__fill_1
XFILLER_78_137 VGND VGND VPWR VPWR sky130_fd_sc_hd__decap_3
Xfanout172 _1716_ VGND VGND VPWR VPWR net172 sky130_fd_sc_hd__clkbuf_4
XFILLER_93_118 VGND VGND VPWR VPWR sky130_fd_sc_hd__decap_8
Xfanout161 net164 VGND VGND VPWR VPWR net161 sky130_fd_sc_hd__clkbuf_2
Xfanout183 net185 VGND VGND VPWR VPWR net183 sky130_fd_sc_hd__buf_4
Xfanout194 _2543_ VGND VGND VPWR VPWR net194 sky130_fd_sc_hd__buf_6
XFILLER_47_535 VGND VGND VPWR VPWR sky130_fd_sc_hd__fill_1
XFILLER_74_365 VGND VGND VPWR VPWR sky130_fd_sc_hd__decap_4
XFILLER_47_557 VGND VGND VPWR VPWR sky130_fd_sc_hd__decap_3
XFILLER_103_91 VGND VGND VPWR VPWR sky130_fd_sc_hd__decap_8
XFILLER_63_51 VGND VGND VPWR VPWR sky130_fd_sc_hd__decap_4
XFILLER_27_292 VGND VGND VPWR VPWR sky130_fd_sc_hd__decap_4
XFILLER_97_9 VGND VGND VPWR VPWR sky130_fd_sc_hd__fill_1
XFILLER_15_465 VGND VGND VPWR VPWR sky130_fd_sc_hd__fill_1
XFILLER_42_240 VPWR VGND VPWR VGND sky130_ef_sc_hd__decap_12
XPHY_EDGE_ROW_7_Left_125 VGND VGND VPWR VPWR sky130_fd_sc_hd__decap_3
XFILLER_7_653 VPWR VGND VPWR VGND sky130_ef_sc_hd__decap_12
XFILLER_7_697 VGND VGND VPWR VPWR sky130_fd_sc_hd__decap_3
XTAP_TAPCELL_ROW_90_1337 VGND VPWR sky130_fd_sc_hd__tapvpwrvgnd_1
XFILLER_97_446 VGND VGND VPWR VPWR sky130_fd_sc_hd__fill_2
X_5040_ _0776_ _0782_ VGND VGND VPWR VPWR _0783_ sky130_fd_sc_hd__and2b_2
XFILLER_84_129 VGND VGND VPWR VPWR sky130_fd_sc_hd__fill_1
XFILLER_78_693 VGND VGND VPWR VPWR sky130_fd_sc_hd__decap_6
XFILLER_93_652 VGND VGND VPWR VPWR sky130_fd_sc_hd__fill_1
XFILLER_53_505 VGND VGND VPWR VPWR sky130_fd_sc_hd__decap_4
X_6991_ _2457_ _2458_ VGND VGND VPWR VPWR _2459_ sky130_fd_sc_hd__xor2_1
XFILLER_38_557 VGND VGND VPWR VPWR sky130_fd_sc_hd__decap_3
X_8730_ _4100_ _4101_ VGND VGND VPWR VPWR _4103_ sky130_fd_sc_hd__xor2_1
X_5942_ net614 net352 net351 net466 VGND VGND VPWR VPWR _1478_ sky130_fd_sc_hd__a22o_1
XFILLER_25_207 VGND VGND VPWR VPWR sky130_fd_sc_hd__decap_4
XFILLER_80_335 VPWR VGND VPWR VGND sky130_ef_sc_hd__decap_12
XFILLER_18_292 VPWR VGND VPWR VGND sky130_ef_sc_hd__decap_12
X_8661_ net402 pe_array\[2\].u_pe.accum_reg\[25\] net218 _4036_ VGND VGND VPWR VPWR
+ _4037_ sky130_fd_sc_hd__o2bb2a_4
X_5873_ _1313_ _1372_ _1371_ VGND VGND VPWR VPWR _1411_ sky130_fd_sc_hd__a21oi_1
X_8592_ _3968_ _3969_ _3939_ VGND VGND VPWR VPWR _3970_ sky130_fd_sc_hd__a21oi_1
XFILLER_21_446 VGND VGND VPWR VPWR sky130_fd_sc_hd__fill_2
X_4824_ net285 _0569_ _0570_ VGND VGND VPWR VPWR _0572_ sky130_fd_sc_hd__or3_4
X_7612_ net170 _3032_ _3030_ VGND VGND VPWR VPWR _3062_ sky130_fd_sc_hd__a21oi_1
XTAP_TAPCELL_ROW_44_780 VGND VPWR sky130_fd_sc_hd__tapvpwrvgnd_1
X_4755_ _0468_ _0504_ VGND VGND VPWR VPWR _0505_ sky130_fd_sc_hd__xnor2_1
X_7543_ _2992_ _2993_ net271 VGND VGND VPWR VPWR _2995_ sky130_fd_sc_hd__o21ai_1
X_9213_ clknet_leaf_40_clk _0325_ VGND VGND VPWR VPWR pe_array\[1\].u_pe.accum_reg\[31\]
+ sky130_fd_sc_hd__dfxtp_1
X_7474_ _2872_ _2900_ _2877_ _2928_ VGND VGND VPWR VPWR _2929_ sky130_fd_sc_hd__o31a_1
X_4686_ net307 net304 net438 VGND VGND VPWR VPWR _0437_ sky130_fd_sc_hd__o21a_4
X_6425_ _1891_ _1918_ VGND VGND VPWR VPWR _1948_ sky130_fd_sc_hd__or2_1
X_6356_ _1880_ _1879_ VGND VGND VPWR VPWR _1881_ sky130_fd_sc_hd__and2b_1
X_9144_ clknet_leaf_20_clk _0256_ VGND VGND VPWR VPWR pe_array\[0\].u_pe.accum_reg\[30\]
+ sky130_fd_sc_hd__dfxtp_1
XFILLER_115_573 VPWR VGND VPWR VGND sky130_ef_sc_hd__decap_12
XFILLER_102_201 VGND VGND VPWR VPWR sky130_fd_sc_hd__fill_1
XFILLER_68_29 VGND VGND VPWR VPWR sky130_fd_sc_hd__fill_1
XFILLER_0_317 VGND VGND VPWR VPWR sky130_fd_sc_hd__fill_1
X_9075_ clknet_leaf_59_clk _0187_ VGND VGND VPWR VPWR net24 sky130_fd_sc_hd__dfxtp_1
X_5307_ pe_array\[3\].u_pe.accum_reg\[26\] _0520_ VGND VGND VPWR VPWR _1040_ sky130_fd_sc_hd__nor2_1
XFILLER_102_245 VGND VGND VPWR VPWR sky130_fd_sc_hd__fill_2
X_6287_ _1811_ net280 _1812_ VGND VGND VPWR VPWR _1814_ sky130_fd_sc_hd__or3_4
X_8026_ net322 net324 VGND VGND VPWR VPWR _3419_ sky130_fd_sc_hd__or2_4
XTAP_TAPCELL_ROW_110_1573 VGND VPWR sky130_fd_sc_hd__tapvpwrvgnd_1
XFILLER_69_671 VGND VGND VPWR VPWR sky130_fd_sc_hd__fill_1
X_5238_ _0971_ _0972_ VGND VGND VPWR VPWR _0974_ sky130_fd_sc_hd__xnor2_1
XFILLER_69_693 VGND VGND VPWR VPWR sky130_fd_sc_hd__decap_3
X_5169_ _0904_ _0905_ _0873_ _0874_ VGND VGND VPWR VPWR _0907_ sky130_fd_sc_hd__a211o_1
XFILLER_83_140 VGND VGND VPWR VPWR sky130_fd_sc_hd__fill_2
XFILLER_56_365 VPWR VGND VPWR VGND sky130_ef_sc_hd__decap_12
XFILLER_83_173 VGND VGND VPWR VPWR sky130_fd_sc_hd__fill_2
XFILLER_71_302 VPWR VGND VPWR VGND sky130_ef_sc_hd__decap_12
XFILLER_17_55 VGND VGND VPWR VPWR sky130_fd_sc_hd__fill_1
XFILLER_83_195 VGND VGND VPWR VPWR sky130_fd_sc_hd__decap_8
XFILLER_71_346 VGND VGND VPWR VPWR sky130_fd_sc_hd__decap_4
XTAP_TAPCELL_ROW_65_1030 VGND VPWR sky130_fd_sc_hd__tapvpwrvgnd_1
X_8928_ clknet_leaf_60_clk _0040_ VGND VGND VPWR VPWR pe_array\[3\].u_pe.accum_reg\[28\]
+ sky130_fd_sc_hd__dfxtp_1
XFILLER_17_77 VGND VGND VPWR VPWR sky130_fd_sc_hd__fill_2
X_8859_ net994 net211 _4210_ net380 VGND VGND VPWR VPWR _0419_ sky130_fd_sc_hd__o211a_1
XTAP_TAPCELL_ROW_14_419 VGND VPWR sky130_fd_sc_hd__tapvpwrvgnd_1
XFILLER_12_457 VGND VGND VPWR VPWR sky130_fd_sc_hd__decap_8
XFILLER_4_601 VPWR VGND VPWR VGND sky130_ef_sc_hd__decap_12
XFILLER_4_645 VPWR VGND VPWR VGND sky130_ef_sc_hd__decap_12
XTAP_TAPCELL_ROW_76_1170 VGND VPWR sky130_fd_sc_hd__tapvpwrvgnd_1
XFILLER_94_416 VGND VGND VPWR VPWR sky130_fd_sc_hd__fill_1
XFILLER_59_192 VGND VGND VPWR VPWR sky130_fd_sc_hd__decap_3
XFILLER_47_365 VPWR VGND VPWR VGND sky130_ef_sc_hd__decap_12
XFILLER_74_173 VGND VGND VPWR VPWR sky130_fd_sc_hd__fill_1
XFILLER_74_61 VGND VGND VPWR VPWR sky130_fd_sc_hd__decap_4
XFILLER_15_262 VGND VGND VPWR VPWR sky130_fd_sc_hd__decap_8
XTAP_TAPCELL_ROW_41_750 VGND VPWR sky130_fd_sc_hd__tapvpwrvgnd_1
Xclkbuf_leaf_10_clk clknet_3_5__leaf_clk VGND VGND VPWR VPWR clknet_leaf_10_clk sky130_fd_sc_hd__clkbuf_8
X_4540_ _4303_ _4304_ net303 net492 VGND VGND VPWR VPWR _4305_ sky130_fd_sc_hd__and4bb_1
Xhold406 pe_accum\[2\]\[25\] VGND VGND VPWR VPWR net921 sky130_fd_sc_hd__dlygate4sd3_1
XFILLER_7_461 VGND VGND VPWR VPWR sky130_fd_sc_hd__decap_6
X_4471_ net257 net507 pe_array\[3\].u_pe.tap_count\[0\] VGND VGND VPWR VPWR _4244_
+ sky130_fd_sc_hd__mux2_1
Xhold417 pe_accum\[1\]\[29\] VGND VGND VPWR VPWR net932 sky130_fd_sc_hd__dlygate4sd3_1
X_6210_ _1738_ _1739_ VGND VGND VPWR VPWR _1740_ sky130_fd_sc_hd__nand2b_1
Xhold428 pe_accum\[3\]\[10\] VGND VGND VPWR VPWR net943 sky130_fd_sc_hd__dlygate4sd3_1
X_7190_ _2652_ _2653_ VGND VGND VPWR VPWR _2654_ sky130_fd_sc_hd__nand2b_1
Xhold439 pe_accum\[3\]\[15\] VGND VGND VPWR VPWR net954 sky130_fd_sc_hd__dlygate4sd3_1
X_6141_ _1670_ _1672_ VGND VGND VPWR VPWR _1673_ sky130_fd_sc_hd__nand2_1
XFILLER_97_221 VGND VGND VPWR VPWR sky130_fd_sc_hd__decap_3
X_6072_ _1603_ _1604_ VGND VGND VPWR VPWR _1605_ sky130_fd_sc_hd__xor2_1
XFILLER_85_449 VPWR VGND VPWR VGND sky130_ef_sc_hd__decap_12
XFILLER_57_129 VPWR VGND VPWR VGND sky130_ef_sc_hd__decap_12
X_5023_ _0763_ _0764_ _0765_ VGND VGND VPWR VPWR _0766_ sky130_fd_sc_hd__nand3_1
XFILLER_38_321 VGND VGND VPWR VPWR sky130_fd_sc_hd__decap_6
XFILLER_26_505 VPWR VGND VPWR VGND sky130_ef_sc_hd__decap_12
X_6974_ _2435_ _2436_ _2438_ VGND VGND VPWR VPWR _2442_ sky130_fd_sc_hd__o21a_1
X_8713_ _4059_ _4057_ VGND VGND VPWR VPWR _4087_ sky130_fd_sc_hd__nor2_2
XFILLER_110_15 VPWR VGND VPWR VGND sky130_ef_sc_hd__decap_12
X_5925_ _1459_ _1460_ VGND VGND VPWR VPWR _1462_ sky130_fd_sc_hd__xnor2_1
X_8644_ net191 _3991_ _3989_ VGND VGND VPWR VPWR _4020_ sky130_fd_sc_hd__a21oi_1
X_5856_ net612 net356 VGND VGND VPWR VPWR _1394_ sky130_fd_sc_hd__nand2_1
XFILLER_21_210 VPWR VGND VPWR VGND sky130_ef_sc_hd__decap_12
X_4807_ _0510_ _0512_ _0509_ VGND VGND VPWR VPWR _0555_ sky130_fd_sc_hd__a21oi_1
XPHY_EDGE_ROW_3_Right_3 VGND VGND VPWR VPWR sky130_fd_sc_hd__decap_3
X_8575_ _3919_ _3920_ _3951_ _3952_ VGND VGND VPWR VPWR _3953_ sky130_fd_sc_hd__o211ai_2
X_5787_ _1324_ _1325_ _1294_ _1295_ VGND VGND VPWR VPWR _1327_ sky130_fd_sc_hd__a211o_1
XFILLER_21_276 VGND VGND VPWR VPWR sky130_fd_sc_hd__decap_4
X_7526_ _2942_ _2944_ _2978_ VGND VGND VPWR VPWR _2979_ sky130_fd_sc_hd__o21a_1
X_4738_ _0485_ _0486_ _0443_ _0444_ VGND VGND VPWR VPWR _0488_ sky130_fd_sc_hd__o211ai_2
XFILLER_107_337 VPWR VGND VPWR VGND sky130_ef_sc_hd__decap_12
X_7457_ _2909_ _2910_ net196 VGND VGND VPWR VPWR _2912_ sky130_fd_sc_hd__a21oi_1
X_4669_ _4429_ _4430_ VGND VGND VPWR VPWR _4431_ sky130_fd_sc_hd__or2_1
X_6408_ _1929_ _1930_ VGND VGND VPWR VPWR _1931_ sky130_fd_sc_hd__nor2_1
XTAP_TAPCELL_ROW_112_1602 VGND VPWR sky130_fd_sc_hd__tapvpwrvgnd_1
X_9127_ clknet_leaf_32_clk _0239_ VGND VGND VPWR VPWR pe_array\[0\].u_pe.accum_reg\[13\]
+ sky130_fd_sc_hd__dfxtp_1
XFILLER_1_615 VGND VGND VPWR VPWR sky130_fd_sc_hd__fill_1
X_7388_ _2814_ _2843_ _2844_ VGND VGND VPWR VPWR _2846_ sky130_fd_sc_hd__nand3_1
XFILLER_115_381 VGND VGND VPWR VPWR sky130_fd_sc_hd__decap_8
XFILLER_103_521 VPWR VGND VPWR VGND sky130_ef_sc_hd__decap_12
X_6339_ _1863_ _1864_ _1832_ VGND VGND VPWR VPWR _1865_ sky130_fd_sc_hd__a21oi_1
X_9058_ clknet_leaf_5_clk _0170_ VGND VGND VPWR VPWR net132 sky130_fd_sc_hd__dfxtp_1
XFILLER_76_416 VGND VGND VPWR VPWR sky130_fd_sc_hd__decap_4
XFILLER_0_169 VGND VGND VPWR VPWR sky130_fd_sc_hd__fill_2
XFILLER_48_107 VPWR VGND VPWR VGND sky130_ef_sc_hd__decap_12
X_8009_ net403 pe_array\[2\].u_pe.accum_reg\[7\] net219 _3402_ VGND VGND VPWR VPWR
+ _3403_ sky130_fd_sc_hd__o2bb2a_1
XFILLER_29_332 VGND VGND VPWR VPWR sky130_fd_sc_hd__fill_1
Xclkbuf_leaf_68_clk clknet_3_1__leaf_clk VGND VGND VPWR VPWR clknet_leaf_68_clk sky130_fd_sc_hd__clkbuf_8
XFILLER_57_685 VPWR VGND VPWR VGND sky130_ef_sc_hd__decap_12
XFILLER_17_505 VGND VGND VPWR VPWR sky130_fd_sc_hd__decap_3
XPHY_EDGE_ROW_88_Left_206 VGND VGND VPWR VPWR sky130_fd_sc_hd__decap_3
XFILLER_71_121 VGND VGND VPWR VPWR sky130_fd_sc_hd__decap_4
XTAP_TAPCELL_ROW_27_577 VGND VPWR sky130_fd_sc_hd__tapvpwrvgnd_1
XFILLER_44_53 VPWR VGND VPWR VGND sky130_ef_sc_hd__decap_12
XFILLER_44_97 VPWR VGND VPWR VGND sky130_ef_sc_hd__decap_12
XFILLER_60_41 VPWR VGND VPWR VGND sky130_ef_sc_hd__decap_12
XFILLER_12_298 VGND VGND VPWR VPWR sky130_fd_sc_hd__decap_8
XFILLER_60_85 VGND VGND VPWR VPWR sky130_fd_sc_hd__decap_3
XPHY_EDGE_ROW_97_Left_215 VGND VGND VPWR VPWR sky130_fd_sc_hd__decap_3
XFILLER_113_318 VPWR VGND VPWR VGND sky130_ef_sc_hd__decap_12
XFILLER_5_69 VGND VGND VPWR VPWR sky130_fd_sc_hd__fill_1
XFILLER_4_475 VGND VGND VPWR VPWR sky130_fd_sc_hd__fill_1
XFILLER_67_449 VGND VGND VPWR VPWR sky130_fd_sc_hd__decap_6
Xclkbuf_leaf_59_clk clknet_3_0__leaf_clk VGND VGND VPWR VPWR clknet_leaf_59_clk sky130_fd_sc_hd__clkbuf_8
XFILLER_48_641 VGND VGND VPWR VPWR sky130_fd_sc_hd__decap_3
XFILLER_82_419 VGND VGND VPWR VPWR sky130_fd_sc_hd__fill_1
XTAP_TAPCELL_ROW_85_1269 VGND VPWR sky130_fd_sc_hd__tapvpwrvgnd_1
X_5710_ net496 net357 pe_array\[0\].u_pe.accum_reg\[2\] VGND VGND VPWR VPWR _1253_
+ sky130_fd_sc_hd__a21oi_1
XFILLER_50_327 VPWR VGND VPWR VGND sky130_ef_sc_hd__decap_12
XFILLER_16_571 VGND VGND VPWR VPWR sky130_fd_sc_hd__fill_1
XFILLER_16_593 VGND VGND VPWR VPWR sky130_fd_sc_hd__fill_1
X_6690_ net898 net233 _1266_ net242 VGND VGND VPWR VPWR _0260_ sky130_fd_sc_hd__o2bb2ai_1
XFILLER_93_3 VGND VGND VPWR VPWR sky130_fd_sc_hd__decap_4
XFILLER_43_390 VGND VGND VPWR VPWR sky130_fd_sc_hd__fill_2
X_5641_ net988 net371 VGND VGND VPWR VPWR _0182_ sky130_fd_sc_hd__and2_1
X_5572_ net912 net392 VGND VGND VPWR VPWR _0113_ sky130_fd_sc_hd__and2_1
X_8360_ net161 _3743_ _3744_ VGND VGND VPWR VPWR _3745_ sky130_fd_sc_hd__or3_1
XFILLER_117_613 VGND VGND VPWR VPWR sky130_fd_sc_hd__decap_3
X_8291_ _3674_ _3675_ _3635_ _3636_ VGND VGND VPWR VPWR _3678_ sky130_fd_sc_hd__a211o_1
X_7311_ _2767_ _2768_ net266 VGND VGND VPWR VPWR _2771_ sky130_fd_sc_hd__o21ai_1
X_4523_ _4267_ _4287_ _4288_ VGND VGND VPWR VPWR _4289_ sky130_fd_sc_hd__or3_4
XFILLER_117_657 VPWR VGND VPWR VGND sky130_ef_sc_hd__decap_12
X_7242_ net266 _2702_ _2703_ VGND VGND VPWR VPWR _2704_ sky130_fd_sc_hd__nor3_1
X_4454_ net422 VGND VGND VPWR VPWR _4235_ sky130_fd_sc_hd__inv_2
XFILLER_98_530 VGND VGND VPWR VPWR sky130_fd_sc_hd__fill_2
X_7173_ _2587_ _2588_ _2634_ _2635_ VGND VGND VPWR VPWR _2637_ sky130_fd_sc_hd__o211ai_1
XFILLER_105_15 VPWR VGND VPWR VGND sky130_ef_sc_hd__decap_12
X_6124_ _1652_ _1653_ _1610_ _1612_ VGND VGND VPWR VPWR _1656_ sky130_fd_sc_hd__a211o_1
X_6055_ _1541_ _1543_ VGND VGND VPWR VPWR _1589_ sky130_fd_sc_hd__nor2_1
X_5006_ net415 _0749_ VGND VGND VPWR VPWR _0027_ sky130_fd_sc_hd__nor2_1
XFILLER_54_622 VPWR VGND VPWR VGND sky130_ef_sc_hd__decap_12
XFILLER_81_430 VPWR VGND VPWR VGND sky130_ef_sc_hd__decap_12
XFILLER_54_688 VGND VGND VPWR VPWR sky130_fd_sc_hd__decap_4
XFILLER_53_165 VGND VGND VPWR VPWR sky130_fd_sc_hd__decap_3
XFILLER_26_357 VGND VGND VPWR VPWR sky130_fd_sc_hd__decap_6
XFILLER_26_379 VGND VGND VPWR VPWR sky130_fd_sc_hd__fill_1
X_6957_ _2422_ _2423_ _2424_ VGND VGND VPWR VPWR _2426_ sky130_fd_sc_hd__a21o_1
XTAP_TAPCELL_ROW_62_1000 VGND VPWR sky130_fd_sc_hd__tapvpwrvgnd_1
XTAP_TAPCELL_ROW_24_536 VGND VPWR sky130_fd_sc_hd__tapvpwrvgnd_1
XFILLER_41_327 VGND VGND VPWR VPWR sky130_fd_sc_hd__fill_1
X_5908_ _1442_ _1443_ _1444_ VGND VGND VPWR VPWR _1445_ sky130_fd_sc_hd__nand3_1
XTAP_TAPCELL_ROW_52_878 VGND VPWR sky130_fd_sc_hd__tapvpwrvgnd_1
XFILLER_14_45 VGND VGND VPWR VPWR sky130_fd_sc_hd__decap_4
XFILLER_14_23 VGND VGND VPWR VPWR sky130_fd_sc_hd__fill_2
XTAP_TAPCELL_ROW_24_547 VGND VPWR sky130_fd_sc_hd__tapvpwrvgnd_1
X_6888_ _2356_ _2357_ VGND VGND VPWR VPWR _2358_ sky130_fd_sc_hd__nor2_1
X_8627_ _4001_ _4002_ VGND VGND VPWR VPWR _4004_ sky130_fd_sc_hd__xor2_1
X_5839_ _1376_ _1377_ VGND VGND VPWR VPWR _1378_ sky130_fd_sc_hd__xnor2_1
XFILLER_14_56 VPWR VGND VPWR VGND sky130_ef_sc_hd__decap_12
XFILLER_22_574 VPWR VGND VPWR VGND sky130_ef_sc_hd__decap_12
X_8558_ _3934_ _3935_ net155 VGND VGND VPWR VPWR _3937_ sky130_fd_sc_hd__o21ai_1
Xrebuffer311 net827 VGND VGND VPWR VPWR net826 sky130_fd_sc_hd__dlymetal6s2s_1
X_7509_ _2926_ _2928_ _2955_ _2961_ _2954_ VGND VGND VPWR VPWR _2962_ sky130_fd_sc_hd__o311a_1
XFILLER_30_11 VPWR VGND VPWR VGND sky130_ef_sc_hd__decap_12
X_8489_ _3838_ _3840_ VGND VGND VPWR VPWR _3870_ sky130_fd_sc_hd__nand2_1
XFILLER_30_77 VGND VGND VPWR VPWR sky130_fd_sc_hd__decap_6
XFILLER_107_189 VPWR VGND VPWR VGND sky130_ef_sc_hd__decap_12
XFILLER_1_445 VGND VGND VPWR VPWR sky130_fd_sc_hd__decap_3
XFILLER_76_224 VPWR VGND VPWR VGND sky130_ef_sc_hd__decap_12
XFILLER_76_268 VGND VGND VPWR VPWR sky130_fd_sc_hd__decap_3
XFILLER_76_279 VGND VGND VPWR VPWR sky130_fd_sc_hd__fill_1
XFILLER_45_600 VPWR VGND VPWR VGND sky130_ef_sc_hd__decap_12
XFILLER_17_335 VGND VGND VPWR VPWR sky130_fd_sc_hd__fill_1
XFILLER_71_84 VGND VGND VPWR VPWR sky130_fd_sc_hd__fill_1
XFILLER_9_578 VGND VGND VPWR VPWR sky130_fd_sc_hd__decap_6
XFILLER_9_545 VGND VGND VPWR VPWR sky130_fd_sc_hd__decap_4
XFILLER_13_596 VGND VGND VPWR VPWR sky130_fd_sc_hd__fill_2
XFILLER_36_600 VGND VGND VPWR VPWR sky130_fd_sc_hd__fill_1
XFILLER_48_460 VGND VGND VPWR VPWR sky130_fd_sc_hd__decap_3
X_7860_ _3231_ _3257_ VGND VGND VPWR VPWR _3258_ sky130_fd_sc_hd__xnor2_1
X_6811_ net430 _2283_ VGND VGND VPWR VPWR _0298_ sky130_fd_sc_hd__nor2_1
X_7791_ net226 _3172_ VGND VGND VPWR VPWR _3205_ sky130_fd_sc_hd__nand2_1
XFILLER_50_124 VPWR VGND VPWR VGND sky130_ef_sc_hd__decap_12
X_6742_ net511 net337 _2215_ _2216_ VGND VGND VPWR VPWR _2218_ sky130_fd_sc_hd__o2bb2a_1
X_6673_ net172 _2176_ _2174_ VGND VGND VPWR VPWR _2187_ sky130_fd_sc_hd__a21o_1
XTAP_TAPCELL_ROW_21_506 VGND VPWR sky130_fd_sc_hd__tapvpwrvgnd_1
XTAP_TAPCELL_ROW_98_1427 VGND VPWR sky130_fd_sc_hd__tapvpwrvgnd_1
X_8412_ _3795_ _3794_ VGND VGND VPWR VPWR _3796_ sky130_fd_sc_hd__xnor2_2
X_5624_ net990 net380 VGND VGND VPWR VPWR _0165_ sky130_fd_sc_hd__and2_1
XFILLER_31_393 VGND VGND VPWR VPWR sky130_fd_sc_hd__decap_4
X_8343_ _3695_ _3696_ _3693_ VGND VGND VPWR VPWR _3729_ sky130_fd_sc_hd__o21ai_2
X_5555_ net892 net391 VGND VGND VPWR VPWR _0096_ sky130_fd_sc_hd__and2_1
X_8274_ net419 _3661_ VGND VGND VPWR VPWR _0383_ sky130_fd_sc_hd__nor2_1
X_5486_ net930 net250 _1203_ net365 VGND VGND VPWR VPWR _0053_ sky130_fd_sc_hd__o211a_1
X_4506_ _4251_ _4259_ _4272_ VGND VGND VPWR VPWR _4273_ sky130_fd_sc_hd__and3_1
X_7225_ _2685_ _2686_ _2646_ _2648_ VGND VGND VPWR VPWR _2688_ sky130_fd_sc_hd__a211oi_1
Xfanout513 net515 VGND VGND VPWR VPWR net513 sky130_fd_sc_hd__buf_2
X_7156_ _2620_ net425 VGND VGND VPWR VPWR _0306_ sky130_fd_sc_hd__nor2_1
Xfanout502 net503 VGND VGND VPWR VPWR net502 sky130_fd_sc_hd__buf_8
XFILLER_113_671 VGND VGND VPWR VPWR sky130_fd_sc_hd__fill_1
XFILLER_86_533 VPWR VGND VPWR VGND sky130_ef_sc_hd__decap_12
X_6107_ _1603_ _1604_ _1602_ VGND VGND VPWR VPWR _1639_ sky130_fd_sc_hd__a21oi_1
XFILLER_76_29 VGND VGND VPWR VPWR sky130_fd_sc_hd__decap_6
XFILLER_58_224 VGND VGND VPWR VPWR sky130_fd_sc_hd__fill_2
X_7087_ _2550_ _2551_ net197 VGND VGND VPWR VPWR _2553_ sky130_fd_sc_hd__a21o_1
X_6038_ net278 _1569_ _1570_ VGND VGND VPWR VPWR _1572_ sky130_fd_sc_hd__or3_1
XTAP_TAPCELL_ROW_57_937 VGND VPWR sky130_fd_sc_hd__tapvpwrvgnd_1
XFILLER_27_600 VGND VGND VPWR VPWR sky130_fd_sc_hd__fill_1
XTAP_TAPCELL_ROW_29_606 VGND VPWR sky130_fd_sc_hd__tapvpwrvgnd_1
XTAP_TAPCELL_ROW_107_1534 VGND VPWR sky130_fd_sc_hd__tapvpwrvgnd_1
Xrebuffer73 net587 VGND VGND VPWR VPWR net588 sky130_fd_sc_hd__dlygate4sd1_1
XFILLER_54_441 VPWR VGND VPWR VGND sky130_ef_sc_hd__decap_12
XTAP_TAPCELL_ROW_1_264 VGND VPWR sky130_fd_sc_hd__tapvpwrvgnd_1
Xrebuffer62 _4370_ VGND VGND VPWR VPWR net577 sky130_fd_sc_hd__dlymetal6s2s_1
Xrebuffer40 net556 VGND VGND VPWR VPWR net555 sky130_fd_sc_hd__dlygate4sd1_1
Xrebuffer95 _1974_ VGND VGND VPWR VPWR net610 sky130_fd_sc_hd__dlygate4sd1_1
Xrebuffer84 _3901_ VGND VGND VPWR VPWR net599 sky130_fd_sc_hd__buf_1
XFILLER_81_271 VGND VGND VPWR VPWR sky130_fd_sc_hd__decap_4
X_7989_ net485 net312 net310 net497 VGND VGND VPWR VPWR _3383_ sky130_fd_sc_hd__a22oi_1
XFILLER_54_474 VGND VGND VPWR VPWR sky130_fd_sc_hd__fill_2
XTAP_TAPCELL_ROW_37_694 VGND VPWR sky130_fd_sc_hd__tapvpwrvgnd_1
XFILLER_41_113 VGND VGND VPWR VPWR sky130_fd_sc_hd__decap_6
XFILLER_25_55 VGND VGND VPWR VPWR sky130_fd_sc_hd__fill_1
XFILLER_41_135 VGND VGND VPWR VPWR sky130_fd_sc_hd__decap_4
XFILLER_25_99 VPWR VGND VPWR VGND sky130_ef_sc_hd__decap_12
XFILLER_10_533 VGND VGND VPWR VPWR sky130_fd_sc_hd__fill_1
Xrebuffer130 _0540_ VGND VGND VPWR VPWR net645 sky130_fd_sc_hd__dlymetal6s4s_1
XFILLER_108_421 VGND VGND VPWR VPWR sky130_fd_sc_hd__decap_6
Xrebuffer163 _3600_ VGND VGND VPWR VPWR net678 sky130_fd_sc_hd__buf_6
Xrebuffer174 _0568_ VGND VGND VPWR VPWR net689 sky130_fd_sc_hd__dlygate4sd1_1
XFILLER_41_87 VGND VGND VPWR VPWR sky130_fd_sc_hd__decap_6
XTAP_TAPCELL_ROW_9_364 VGND VPWR sky130_fd_sc_hd__tapvpwrvgnd_1
XFILLER_110_107 VGND VGND VPWR VPWR sky130_fd_sc_hd__fill_2
XFILLER_89_382 VGND VGND VPWR VPWR sky130_fd_sc_hd__decap_6
XFILLER_2_15 VPWR VGND VPWR VGND sky130_ef_sc_hd__decap_12
XFILLER_77_555 VGND VGND VPWR VPWR sky130_fd_sc_hd__decap_4
XFILLER_92_503 VPWR VGND VPWR VGND sky130_ef_sc_hd__decap_12
XFILLER_77_588 VGND VGND VPWR VPWR sky130_fd_sc_hd__fill_2
XFILLER_49_279 VGND VGND VPWR VPWR sky130_fd_sc_hd__fill_1
XFILLER_64_249 VGND VGND VPWR VPWR sky130_fd_sc_hd__decap_3
XFILLER_64_227 VGND VGND VPWR VPWR sky130_fd_sc_hd__fill_1
XFILLER_57_290 VPWR VGND VPWR VGND sky130_ef_sc_hd__decap_12
XFILLER_17_154 VPWR VGND VPWR VGND sky130_ef_sc_hd__decap_12
XFILLER_33_614 VGND VGND VPWR VPWR sky130_fd_sc_hd__fill_2
XTAP_TAPCELL_ROW_82_1239 VGND VPWR sky130_fd_sc_hd__tapvpwrvgnd_1
XFILLER_82_83 VGND VGND VPWR VPWR sky130_fd_sc_hd__fill_1
XFILLER_82_72 VGND VGND VPWR VPWR sky130_fd_sc_hd__fill_1
XFILLER_13_393 VPWR VGND VPWR VGND sky130_ef_sc_hd__decap_12
Xoutput116 net116 VGND VGND VPWR VPWR result_data[6] sky130_fd_sc_hd__buf_2
Xoutput105 net105 VGND VGND VPWR VPWR result_data[5] sky130_fd_sc_hd__buf_2
X_5340_ _1069_ _1070_ VGND VGND VPWR VPWR _1072_ sky130_fd_sc_hd__xor2_1
Xoutput149 net149 VGND VGND VPWR VPWR result_data[9] sky130_fd_sc_hd__buf_2
Xoutput138 net138 VGND VGND VPWR VPWR result_data[8] sky130_fd_sc_hd__buf_2
Xoutput127 net127 VGND VGND VPWR VPWR result_data[7] sky130_fd_sc_hd__buf_2
XFILLER_99_113 VGND VGND VPWR VPWR sky130_fd_sc_hd__fill_1
XTAP_TAPCELL_ROW_93_1368 VGND VPWR sky130_fd_sc_hd__tapvpwrvgnd_1
X_5271_ _1005_ _1004_ VGND VGND VPWR VPWR _1006_ sky130_fd_sc_hd__and2b_1
XFILLER_87_308 VPWR VGND VPWR VGND sky130_ef_sc_hd__decap_12
X_7010_ _2443_ _2475_ _2476_ VGND VGND VPWR VPWR _2478_ sky130_fd_sc_hd__nand3_2
XFILLER_83_503 VGND VGND VPWR VPWR sky130_fd_sc_hd__fill_1
XFILLER_55_205 VGND VGND VPWR VPWR sky130_fd_sc_hd__fill_1
X_8961_ clknet_leaf_58_clk _0073_ VGND VGND VPWR VPWR pe_accum\[3\]\[29\] sky130_fd_sc_hd__dfxtp_1
XFILLER_28_419 VGND VGND VPWR VPWR sky130_fd_sc_hd__fill_1
X_7912_ _3274_ _3277_ net512 net310 VGND VGND VPWR VPWR _3308_ sky130_fd_sc_hd__o211a_1
XFILLER_102_27 VGND VGND VPWR VPWR sky130_fd_sc_hd__fill_1
X_8892_ clknet_leaf_17_clk _0004_ VGND VGND VPWR VPWR pe_array\[0\].u_pe.weight_in\[4\]
+ sky130_fd_sc_hd__dfxtp_1
XTAP_TAPCELL_ROW_54_907 VGND VPWR sky130_fd_sc_hd__tapvpwrvgnd_1
XFILLER_36_452 VGND VGND VPWR VPWR sky130_fd_sc_hd__fill_1
X_7843_ _3217_ _3227_ _3239_ _3240_ VGND VGND VPWR VPWR _3242_ sky130_fd_sc_hd__a22o_1
XFILLER_91_591 VPWR VGND VPWR VGND sky130_ef_sc_hd__decap_12
XFILLER_51_400 VPWR VGND VPWR VGND sky130_ef_sc_hd__decap_12
XFILLER_23_113 VGND VGND VPWR VPWR sky130_fd_sc_hd__decap_4
X_7774_ net960 net221 _3196_ net373 VGND VGND VPWR VPWR _0348_ sky130_fd_sc_hd__o211a_1
XFILLER_23_135 VPWR VGND VPWR VGND sky130_ef_sc_hd__decap_12
X_4986_ net744 _0696_ _0694_ VGND VGND VPWR VPWR _0730_ sky130_fd_sc_hd__a21o_1
XTAP_TAPCELL_ROW_62_995 VGND VPWR sky130_fd_sc_hd__tapvpwrvgnd_1
X_6725_ net507 pe_array\[1\].u_pe.tap_count\[0\] net1031 VGND VGND VPWR VPWR _2205_
+ sky130_fd_sc_hd__a21oi_1
XFILLER_51_488 VPWR VGND VPWR VGND sky130_ef_sc_hd__decap_12
XTAP_TAPCELL_ROW_34_664 VGND VPWR sky130_fd_sc_hd__tapvpwrvgnd_1
XTAP_TAPCELL_ROW_102_1475 VGND VPWR sky130_fd_sc_hd__tapvpwrvgnd_1
X_6656_ _2167_ _2168_ net657 _2162_ VGND VGND VPWR VPWR _2171_ sky130_fd_sc_hd__o211a_1
X_6587_ _2102_ _2103_ VGND VGND VPWR VPWR _2104_ sky130_fd_sc_hd__and2_1
X_5607_ net955 net379 VGND VGND VPWR VPWR _0148_ sky130_fd_sc_hd__and2_1
X_8326_ _3709_ _3710_ net190 VGND VGND VPWR VPWR _3712_ sky130_fd_sc_hd__a21o_1
X_5538_ net17 _1226_ _1227_ net330 VGND VGND VPWR VPWR _0081_ sky130_fd_sc_hd__a22o_1
XFILLER_11_57 VGND VGND VPWR VPWR sky130_fd_sc_hd__decap_8
XFILLER_117_273 VGND VGND VPWR VPWR sky130_fd_sc_hd__decap_6
XFILLER_105_413 VGND VGND VPWR VPWR sky130_fd_sc_hd__decap_8
X_8257_ _3642_ _3643_ _3644_ VGND VGND VPWR VPWR _3645_ sky130_fd_sc_hd__nand3_1
X_7208_ _2667_ _2668_ net267 VGND VGND VPWR VPWR _2671_ sky130_fd_sc_hd__o21ai_1
X_5469_ net254 _4260_ VGND VGND VPWR VPWR _1195_ sky130_fd_sc_hd__nand2_1
X_8188_ _3576_ _3577_ VGND VGND VPWR VPWR _3578_ sky130_fd_sc_hd__xor2_2
Xfanout321 pe_array\[2\].u_pe.weight_in\[2\] VGND VGND VPWR VPWR net321 sky130_fd_sc_hd__buf_2
Xfanout310 net311 VGND VGND VPWR VPWR net310 sky130_fd_sc_hd__buf_2
Xfanout332 pe_array\[1\].u_pe.weight_in\[3\] VGND VGND VPWR VPWR net332 sky130_fd_sc_hd__buf_2
XTAP_TAPCELL_ROW_6_323 VGND VPWR sky130_fd_sc_hd__tapvpwrvgnd_1
XFILLER_113_490 VGND VGND VPWR VPWR sky130_fd_sc_hd__decap_8
Xfanout354 net355 VGND VGND VPWR VPWR net354 sky130_fd_sc_hd__clkbuf_2
Xfanout343 pe_array\[1\].u_pe.weight_in\[0\] VGND VGND VPWR VPWR net343 sky130_fd_sc_hd__buf_2
Xfanout365 net369 VGND VGND VPWR VPWR net365 sky130_fd_sc_hd__clkbuf_2
X_7139_ _2599_ _2601_ _2555_ _2557_ VGND VGND VPWR VPWR _2604_ sky130_fd_sc_hd__o211a_1
Xfanout387 net388 VGND VGND VPWR VPWR net387 sky130_fd_sc_hd__buf_2
XFILLER_101_663 VGND VGND VPWR VPWR sky130_fd_sc_hd__decap_8
XFILLER_86_363 VGND VGND VPWR VPWR sky130_fd_sc_hd__fill_1
Xfanout398 net405 VGND VGND VPWR VPWR net398 sky130_fd_sc_hd__clkbuf_2
Xfanout376 net379 VGND VGND VPWR VPWR net376 sky130_fd_sc_hd__clkbuf_2
XFILLER_74_558 VGND VGND VPWR VPWR sky130_fd_sc_hd__decap_4
XFILLER_46_238 VGND VGND VPWR VPWR sky130_fd_sc_hd__fill_2
XFILLER_46_249 VGND VGND VPWR VPWR sky130_fd_sc_hd__decap_3
XTAP_TAPCELL_ROW_68_1072 VGND VPWR sky130_fd_sc_hd__tapvpwrvgnd_1
XPHY_EDGE_ROW_61_Left_179 VGND VGND VPWR VPWR sky130_fd_sc_hd__decap_3
XFILLER_42_411 VGND VGND VPWR VPWR sky130_fd_sc_hd__decap_8
XFILLER_42_466 VGND VGND VPWR VPWR sky130_fd_sc_hd__fill_1
XFILLER_52_53 VPWR VGND VPWR VGND sky130_ef_sc_hd__decap_12
Xinput18 weight_din[5] VGND VGND VPWR VPWR net18 sky130_fd_sc_hd__clkbuf_2
XFILLER_52_97 VGND VGND VPWR VPWR sky130_fd_sc_hd__decap_8
XFILLER_108_251 VGND VGND VPWR VPWR sky130_fd_sc_hd__fill_1
XPHY_EDGE_ROW_70_Left_188 VGND VGND VPWR VPWR sky130_fd_sc_hd__decap_3
XFILLER_97_617 VPWR VGND VPWR VGND sky130_ef_sc_hd__decap_12
XFILLER_111_405 VGND VGND VPWR VPWR sky130_fd_sc_hd__fill_1
XFILLER_96_149 VGND VGND VPWR VPWR sky130_fd_sc_hd__decap_6
XFILLER_92_300 VGND VGND VPWR VPWR sky130_fd_sc_hd__decap_8
XFILLER_80_517 VGND VGND VPWR VPWR sky130_fd_sc_hd__fill_2
XFILLER_73_580 VPWR VGND VPWR VGND sky130_ef_sc_hd__decap_12
XFILLER_33_433 VPWR VGND VPWR VGND sky130_ef_sc_hd__decap_12
XFILLER_33_455 VGND VGND VPWR VPWR sky130_fd_sc_hd__decap_8
X_4840_ _0585_ _0586_ _0514_ _0516_ VGND VGND VPWR VPWR _0588_ sky130_fd_sc_hd__o211a_1
XFILLER_21_617 VGND VGND VPWR VPWR sky130_fd_sc_hd__decap_8
X_6510_ _2029_ _2028_ VGND VGND VPWR VPWR _2030_ sky130_fd_sc_hd__and2b_1
XFILLER_20_138 VGND VGND VPWR VPWR sky130_fd_sc_hd__fill_2
X_4771_ net301 net437 VGND VGND VPWR VPWR _0520_ sky130_fd_sc_hd__and2_2
XTAP_TAPCELL_ROW_31_623 VGND VPWR sky130_fd_sc_hd__tapvpwrvgnd_1
XFILLER_20_149 VGND VGND VPWR VPWR sky130_fd_sc_hd__fill_1
X_7490_ _2700_ _2943_ VGND VGND VPWR VPWR _2944_ sky130_fd_sc_hd__and2_1
X_6441_ _1960_ _1961_ VGND VGND VPWR VPWR _1963_ sky130_fd_sc_hd__xnor2_1
X_6372_ net411 pe_array\[0\].u_pe.accum_reg\[20\] net240 _1896_ VGND VGND VPWR VPWR
+ _1897_ sky130_fd_sc_hd__o2bb2a_1
X_9160_ clknet_leaf_30_clk _0272_ VGND VGND VPWR VPWR pe_accum\[0\]\[14\] sky130_fd_sc_hd__dfxtp_1
XTAP_TAPCELL_ROW_11_391 VGND VPWR sky130_fd_sc_hd__tapvpwrvgnd_1
XTAP_TAPCELL_ROW_11_380 VGND VPWR sky130_fd_sc_hd__tapvpwrvgnd_1
X_8111_ _3452_ _3454_ _3453_ VGND VGND VPWR VPWR _3502_ sky130_fd_sc_hd__o21ba_1
X_5323_ net181 _1028_ _1026_ VGND VGND VPWR VPWR _1056_ sky130_fd_sc_hd__a21oi_1
XFILLER_114_243 VGND VGND VPWR VPWR sky130_fd_sc_hd__decap_8
X_9091_ clknet_leaf_64_clk _0203_ VGND VGND VPWR VPWR net41 sky130_fd_sc_hd__dfxtp_1
XFILLER_87_127 VGND VGND VPWR VPWR sky130_fd_sc_hd__decap_6
X_8042_ _3431_ _3432_ _3433_ VGND VGND VPWR VPWR _3435_ sky130_fd_sc_hd__a21o_1
X_5254_ net653 _0987_ _0988_ VGND VGND VPWR VPWR _0989_ sky130_fd_sc_hd__nor3_1
X_5185_ _0922_ _0921_ VGND VGND VPWR VPWR _0923_ sky130_fd_sc_hd__xnor2_2
XFILLER_28_205 VGND VGND VPWR VPWR sky130_fd_sc_hd__fill_2
XFILLER_113_15 VPWR VGND VPWR VGND sky130_ef_sc_hd__decap_12
XFILLER_56_547 VGND VGND VPWR VPWR sky130_fd_sc_hd__decap_6
XTAP_TAPCELL_ROW_39_723 VGND VPWR sky130_fd_sc_hd__tapvpwrvgnd_1
XFILLER_73_19 VGND VGND VPWR VPWR sky130_fd_sc_hd__decap_3
XFILLER_56_569 VPWR VGND VPWR VGND sky130_ef_sc_hd__decap_12
XFILLER_56_558 VGND VGND VPWR VPWR sky130_fd_sc_hd__decap_6
X_8944_ clknet_leaf_68_clk _0056_ VGND VGND VPWR VPWR pe_accum\[3\]\[12\] sky130_fd_sc_hd__dfxtp_1
X_8875_ net921 _3215_ _4218_ net384 VGND VGND VPWR VPWR _0427_ sky130_fd_sc_hd__o211a_1
XTAP_TAPCELL_ROW_104_1504 VGND VPWR sky130_fd_sc_hd__tapvpwrvgnd_1
XFILLER_71_539 VPWR VGND VPWR VGND sky130_ef_sc_hd__decap_12
X_7826_ _3224_ _3225_ VGND VGND VPWR VPWR _3226_ sky130_fd_sc_hd__or2_1
XTAP_TAPCELL_ROW_19_480 VGND VPWR sky130_fd_sc_hd__tapvpwrvgnd_1
XFILLER_24_477 VGND VGND VPWR VPWR sky130_fd_sc_hd__decap_8
XFILLER_12_639 VGND VGND VPWR VPWR sky130_fd_sc_hd__fill_2
X_7757_ net223 _2695_ VGND VGND VPWR VPWR _3188_ sky130_fd_sc_hd__nand2_1
X_4969_ _0675_ _0634_ _0674_ VGND VGND VPWR VPWR _0714_ sky130_fd_sc_hd__a21oi_4
X_6708_ net914 net236 _1896_ net244 VGND VGND VPWR VPWR _0278_ sky130_fd_sc_hd__o2bb2ai_1
X_7688_ net408 pe_array\[1\].u_pe.accum_reg\[29\] net232 _3135_ VGND VGND VPWR VPWR
+ _3136_ sky130_fd_sc_hd__o2bb2a_4
X_6639_ _2119_ _2154_ VGND VGND VPWR VPWR _2155_ sky130_fd_sc_hd__nor2_1
XFILLER_22_45 VGND VGND VPWR VPWR sky130_fd_sc_hd__fill_1
XFILLER_22_67 VGND VGND VPWR VPWR sky130_fd_sc_hd__fill_1
XTAP_TAPCELL_ROW_115_1633 VGND VPWR sky130_fd_sc_hd__tapvpwrvgnd_1
XFILLER_98_27 VGND VGND VPWR VPWR sky130_fd_sc_hd__fill_1
X_9289_ clknet_leaf_13_clk _0401_ VGND VGND VPWR VPWR pe_array\[2\].u_pe.accum_reg\[31\]
+ sky130_fd_sc_hd__dfxtp_1
X_8309_ _3659_ _3657_ _3655_ VGND VGND VPWR VPWR _3696_ sky130_fd_sc_hd__a21boi_4
XFILLER_105_254 VGND VGND VPWR VPWR sky130_fd_sc_hd__decap_4
XFILLER_79_617 VPWR VGND VPWR VGND sky130_ef_sc_hd__decap_12
XFILLER_78_105 VGND VGND VPWR VPWR sky130_fd_sc_hd__decap_6
XPHY_EDGE_ROW_110_Right_110 VGND VGND VPWR VPWR sky130_fd_sc_hd__decap_3
Xfanout162 net164 VGND VGND VPWR VPWR net162 sky130_fd_sc_hd__buf_4
XFILLER_87_661 VGND VGND VPWR VPWR sky130_fd_sc_hd__decap_8
Xfanout173 net174 VGND VGND VPWR VPWR net173 sky130_fd_sc_hd__buf_8
XFILLER_47_31 VPWR VGND VPWR VGND sky130_ef_sc_hd__decap_12
XFILLER_59_385 VGND VGND VPWR VPWR sky130_fd_sc_hd__decap_6
Xfanout195 net197 VGND VGND VPWR VPWR net195 sky130_fd_sc_hd__buf_2
Xfanout184 net185 VGND VGND VPWR VPWR net184 sky130_fd_sc_hd__clkbuf_2
XFILLER_74_377 VPWR VGND VPWR VGND sky130_ef_sc_hd__decap_12
XFILLER_62_517 VGND VGND VPWR VPWR sky130_fd_sc_hd__decap_4
XFILLER_30_447 VPWR VGND VPWR VGND sky130_ef_sc_hd__decap_12
XFILLER_10_160 VGND VGND VPWR VPWR sky130_fd_sc_hd__decap_8
XFILLER_7_610 VGND VGND VPWR VPWR sky130_fd_sc_hd__decap_6
XFILLER_7_665 VGND VGND VPWR VPWR sky130_fd_sc_hd__decap_6
XFILLER_109_571 VPWR VGND VPWR VGND sky130_ef_sc_hd__decap_12
XFILLER_6_197 VGND VGND VPWR VPWR sky130_fd_sc_hd__fill_2
XTAP_TAPCELL_ROW_90_1338 VGND VPWR sky130_fd_sc_hd__tapvpwrvgnd_1
XFILLER_84_108 VGND VGND VPWR VPWR sky130_fd_sc_hd__decap_8
XPHY_EDGE_ROW_108_Left_226 VGND VGND VPWR VPWR sky130_fd_sc_hd__decap_3
XFILLER_19_3 VPWR VGND VPWR VGND sky130_ef_sc_hd__decap_12
XFILLER_65_344 VGND VGND VPWR VPWR sky130_fd_sc_hd__fill_1
X_6990_ net874 net330 VGND VGND VPWR VPWR _2458_ sky130_fd_sc_hd__nand2_1
XFILLER_80_325 VGND VGND VPWR VPWR sky130_fd_sc_hd__fill_1
X_5941_ net454 net352 net350 VGND VGND VPWR VPWR _1477_ sky130_fd_sc_hd__and3_4
XFILLER_53_539 VPWR VGND VPWR VGND sky130_ef_sc_hd__decap_12
XFILLER_80_347 VGND VGND VPWR VPWR sky130_fd_sc_hd__fill_2
X_8660_ _4035_ _4034_ VGND VGND VPWR VPWR _4036_ sky130_fd_sc_hd__nand2_2
X_5872_ _1349_ _1409_ VGND VGND VPWR VPWR _1410_ sky130_fd_sc_hd__xnor2_1
XFILLER_61_561 VGND VGND VPWR VPWR sky130_fd_sc_hd__decap_6
XTAP_TAPCELL_ROW_16_450 VGND VPWR sky130_fd_sc_hd__tapvpwrvgnd_1
X_8591_ _3965_ _3966_ _3967_ VGND VGND VPWR VPWR _3969_ sky130_fd_sc_hd__a21o_1
X_4823_ net286 _0569_ _0570_ VGND VGND VPWR VPWR _0571_ sky130_fd_sc_hd__nor3_1
X_7611_ net156 _3060_ VGND VGND VPWR VPWR _3061_ sky130_fd_sc_hd__xnor2_1
XTAP_TAPCELL_ROW_44_781 VGND VPWR sky130_fd_sc_hd__tapvpwrvgnd_1
XPHY_EDGE_ROW_117_Left_235 VGND VGND VPWR VPWR sky130_fd_sc_hd__decap_3
X_4754_ _0503_ _0461_ VGND VGND VPWR VPWR _0504_ sky130_fd_sc_hd__xnor2_2
X_7542_ net271 _2992_ _2993_ VGND VGND VPWR VPWR _2994_ sky130_fd_sc_hd__or3_1
X_7473_ _2869_ _2899_ _2927_ VGND VGND VPWR VPWR _2928_ sky130_fd_sc_hd__o21ai_1
X_9212_ clknet_leaf_40_clk _0324_ VGND VGND VPWR VPWR pe_array\[1\].u_pe.accum_reg\[30\]
+ sky130_fd_sc_hd__dfxtp_1
X_4685_ net307 net304 net438 VGND VGND VPWR VPWR _0436_ sky130_fd_sc_hd__and3_4
XFILLER_108_15 VPWR VGND VPWR VGND sky130_ef_sc_hd__decap_12
X_6424_ _1889_ _1917_ _1946_ VGND VGND VPWR VPWR _1947_ sky130_fd_sc_hd__o21a_1
X_6355_ _1848_ _1850_ VGND VGND VPWR VPWR _1880_ sky130_fd_sc_hd__and2_1
X_9143_ clknet_leaf_20_clk _0255_ VGND VGND VPWR VPWR pe_array\[0\].u_pe.accum_reg\[29\]
+ sky130_fd_sc_hd__dfxtp_1
XFILLER_115_585 VPWR VGND VPWR VGND sky130_ef_sc_hd__decap_12
X_6286_ net706 _1811_ _1812_ VGND VGND VPWR VPWR _1813_ sky130_fd_sc_hd__nor3_1
XFILLER_88_425 VGND VGND VPWR VPWR sky130_fd_sc_hd__fill_1
XFILLER_0_307 VGND VGND VPWR VPWR sky130_fd_sc_hd__fill_1
X_9074_ clknet_leaf_52_clk _0186_ VGND VGND VPWR VPWR net23 sky130_fd_sc_hd__dfxtp_1
X_5306_ pe_array\[3\].u_pe.accum_reg\[26\] net301 net437 VGND VGND VPWR VPWR _1039_
+ sky130_fd_sc_hd__and3_1
X_8025_ net443 net322 net324 VGND VGND VPWR VPWR _3418_ sky130_fd_sc_hd__nand3_4
X_5237_ _0972_ _0971_ VGND VGND VPWR VPWR _0973_ sky130_fd_sc_hd__and2b_1
XTAP_TAPCELL_ROW_110_1574 VGND VPWR sky130_fd_sc_hd__tapvpwrvgnd_1
XFILLER_84_620 VPWR VGND VPWR VGND sky130_ef_sc_hd__decap_12
XFILLER_84_29 VGND VGND VPWR VPWR sky130_fd_sc_hd__decap_3
X_5168_ _0873_ _0874_ _0904_ _0905_ VGND VGND VPWR VPWR _0906_ sky130_fd_sc_hd__o211a_1
X_5099_ _0774_ _0809_ _0810_ VGND VGND VPWR VPWR _0840_ sky130_fd_sc_hd__o21a_1
XFILLER_71_314 VPWR VGND VPWR VGND sky130_ef_sc_hd__decap_12
XFILLER_56_377 VGND VGND VPWR VPWR sky130_fd_sc_hd__fill_2
X_8927_ clknet_leaf_60_clk _0039_ VGND VGND VPWR VPWR pe_array\[3\].u_pe.accum_reg\[27\]
+ sky130_fd_sc_hd__dfxtp_1
XTAP_TAPCELL_ROW_65_1031 VGND VPWR sky130_fd_sc_hd__tapvpwrvgnd_1
XFILLER_37_591 VGND VGND VPWR VPWR sky130_fd_sc_hd__decap_4
X_8858_ _3796_ net211 VGND VGND VPWR VPWR _4210_ sky130_fd_sc_hd__nand2_1
X_8789_ _4127_ _4128_ _4159_ VGND VGND VPWR VPWR _4160_ sky130_fd_sc_hd__o21ai_1
X_7809_ net421 _3211_ _3212_ VGND VGND VPWR VPWR _0367_ sky130_fd_sc_hd__nor3_1
XFILLER_4_613 VPWR VGND VPWR VGND sky130_ef_sc_hd__decap_12
XTAP_TAPCELL_ROW_76_1160 VGND VPWR sky130_fd_sc_hd__tapvpwrvgnd_1
XFILLER_4_657 VPWR VGND VPWR VGND sky130_ef_sc_hd__decap_12
XTAP_TAPCELL_ROW_76_1171 VGND VPWR sky130_fd_sc_hd__tapvpwrvgnd_1
XFILLER_106_596 VGND VGND VPWR VPWR sky130_fd_sc_hd__decap_8
XFILLER_79_447 VGND VGND VPWR VPWR sky130_fd_sc_hd__fill_1
XFILLER_67_609 VGND VGND VPWR VPWR sky130_fd_sc_hd__decap_6
XFILLER_58_41 VPWR VGND VPWR VGND sky130_ef_sc_hd__decap_12
XFILLER_58_85 VPWR VGND VPWR VGND sky130_ef_sc_hd__decap_12
XFILLER_75_653 VGND VGND VPWR VPWR sky130_fd_sc_hd__decap_3
XFILLER_74_141 VPWR VGND VPWR VGND sky130_ef_sc_hd__decap_12
XFILLER_47_344 VGND VGND VPWR VPWR sky130_fd_sc_hd__decap_8
XFILLER_47_377 VPWR VGND VPWR VGND sky130_ef_sc_hd__decap_12
XFILLER_62_347 VGND VGND VPWR VPWR sky130_fd_sc_hd__fill_1
XFILLER_62_325 VGND VGND VPWR VPWR sky130_fd_sc_hd__fill_2
XTAP_TAPCELL_ROW_41_740 VGND VPWR sky130_fd_sc_hd__tapvpwrvgnd_1
XTAP_TAPCELL_ROW_41_751 VGND VPWR sky130_fd_sc_hd__tapvpwrvgnd_1
Xhold418 pe_accum\[3\]\[11\] VGND VGND VPWR VPWR net933 sky130_fd_sc_hd__dlygate4sd3_1
Xhold407 pe_accum\[1\]\[21\] VGND VGND VPWR VPWR net922 sky130_fd_sc_hd__dlygate4sd3_1
X_4470_ net507 _4242_ VGND VGND VPWR VPWR _4243_ sky130_fd_sc_hd__nand2_1
Xhold429 pe_accum\[3\]\[6\] VGND VGND VPWR VPWR net944 sky130_fd_sc_hd__dlygate4sd3_1
X_6140_ _1671_ VGND VGND VPWR VPWR _1672_ sky130_fd_sc_hd__inv_2
X_6071_ net872 _4232_ VGND VGND VPWR VPWR _1604_ sky130_fd_sc_hd__nor2_1
XFILLER_97_299 VGND VGND VPWR VPWR sky130_fd_sc_hd__fill_1
X_5022_ net184 _0732_ _0731_ VGND VGND VPWR VPWR _0765_ sky130_fd_sc_hd__o21bai_1
XFILLER_65_141 VGND VGND VPWR VPWR sky130_fd_sc_hd__decap_6
XTAP_TAPCELL_ROW_49_840 VGND VPWR sky130_fd_sc_hd__tapvpwrvgnd_1
XFILLER_53_325 VGND VGND VPWR VPWR sky130_fd_sc_hd__decap_6
X_6973_ net424 _2441_ VGND VGND VPWR VPWR _0302_ sky130_fd_sc_hd__nor2_1
X_8712_ _4055_ _4084_ VGND VGND VPWR VPWR _4086_ sky130_fd_sc_hd__xnor2_1
X_5924_ _1459_ _1460_ VGND VGND VPWR VPWR _1461_ sky130_fd_sc_hd__or2_1
XFILLER_53_369 VGND VGND VPWR VPWR sky130_fd_sc_hd__decap_8
XFILLER_0_81 VGND VGND VPWR VPWR sky130_fd_sc_hd__decap_3
XFILLER_110_27 VGND VGND VPWR VPWR sky130_fd_sc_hd__fill_1
X_8643_ net187 _4018_ VGND VGND VPWR VPWR _4019_ sky130_fd_sc_hd__xnor2_1
X_5855_ net644 net357 VGND VGND VPWR VPWR _1393_ sky130_fd_sc_hd__and2_2
XFILLER_21_222 VGND VGND VPWR VPWR sky130_fd_sc_hd__fill_2
X_4806_ net416 _0554_ VGND VGND VPWR VPWR _0022_ sky130_fd_sc_hd__nor2_1
X_8574_ _3948_ _3949_ net573 VGND VGND VPWR VPWR _3952_ sky130_fd_sc_hd__o21ai_1
X_5786_ _1294_ _1295_ _1324_ _1325_ VGND VGND VPWR VPWR _1326_ sky130_fd_sc_hd__o211ai_2
XFILLER_21_288 VGND VGND VPWR VPWR sky130_fd_sc_hd__fill_2
X_7525_ _2700_ _2976_ VGND VGND VPWR VPWR _2978_ sky130_fd_sc_hd__xnor2_1
X_4737_ _0443_ _0444_ _0485_ _0486_ VGND VGND VPWR VPWR _0487_ sky130_fd_sc_hd__a211o_1
XFILLER_107_305 VPWR VGND VPWR VGND sky130_ef_sc_hd__decap_12
X_7456_ net196 _2909_ _2910_ VGND VGND VPWR VPWR _2911_ sky130_fd_sc_hd__and3_1
X_4668_ _4427_ _4428_ VGND VGND VPWR VPWR _4430_ sky130_fd_sc_hd__and2_1
XFILLER_107_349 VGND VGND VPWR VPWR sky130_fd_sc_hd__fill_1
X_6407_ _1927_ _1928_ net202 VGND VGND VPWR VPWR _1930_ sky130_fd_sc_hd__a21oi_1
XTAP_TAPCELL_ROW_112_1603 VGND VPWR sky130_fd_sc_hd__tapvpwrvgnd_1
X_9126_ clknet_leaf_33_clk _0238_ VGND VGND VPWR VPWR pe_array\[0\].u_pe.accum_reg\[12\]
+ sky130_fd_sc_hd__dfxtp_1
X_7387_ _2843_ _2844_ _2814_ VGND VGND VPWR VPWR _2845_ sky130_fd_sc_hd__a21oi_1
X_4599_ net493 net294 VGND VGND VPWR VPWR _4362_ sky130_fd_sc_hd__nand2_1
XFILLER_103_533 VGND VGND VPWR VPWR sky130_fd_sc_hd__decap_8
X_6338_ _1860_ _1861_ _1862_ VGND VGND VPWR VPWR _1864_ sky130_fd_sc_hd__a21o_1
XFILLER_0_126 VGND VGND VPWR VPWR sky130_fd_sc_hd__decap_8
X_6269_ _1794_ _1795_ _1796_ VGND VGND VPWR VPWR _1797_ sky130_fd_sc_hd__nand3_1
XFILLER_88_266 VPWR VGND VPWR VGND sky130_ef_sc_hd__decap_12
X_9057_ clknet_leaf_5_clk _0169_ VGND VGND VPWR VPWR net131 sky130_fd_sc_hd__dfxtp_1
X_8008_ _3361_ _3401_ VGND VGND VPWR VPWR _3402_ sky130_fd_sc_hd__xnor2_1
XFILLER_76_439 VGND VGND VPWR VPWR sky130_fd_sc_hd__fill_2
XFILLER_48_119 VGND VGND VPWR VPWR sky130_fd_sc_hd__fill_1
XFILLER_57_697 VGND VGND VPWR VPWR sky130_fd_sc_hd__decap_3
XFILLER_17_528 VPWR VGND VPWR VGND sky130_ef_sc_hd__decap_12
XFILLER_84_494 VGND VGND VPWR VPWR sky130_fd_sc_hd__decap_8
XFILLER_72_645 VGND VGND VPWR VPWR sky130_fd_sc_hd__decap_4
XTAP_TAPCELL_ROW_27_578 VGND VPWR sky130_fd_sc_hd__tapvpwrvgnd_1
XFILLER_12_211 VGND VGND VPWR VPWR sky130_fd_sc_hd__decap_3
XFILLER_44_65 VPWR VGND VPWR VGND sky130_ef_sc_hd__decap_12
XFILLER_40_531 VGND VGND VPWR VPWR sky130_fd_sc_hd__fill_1
XFILLER_8_215 VGND VGND VPWR VPWR sky130_fd_sc_hd__fill_1
XFILLER_60_53 VPWR VGND VPWR VGND sky130_ef_sc_hd__decap_12
XFILLER_5_15 VPWR VGND VPWR VGND sky130_ef_sc_hd__decap_12
XFILLER_4_421 VPWR VGND VPWR VGND sky130_ef_sc_hd__decap_12
XFILLER_79_255 VGND VGND VPWR VPWR sky130_fd_sc_hd__fill_1
XFILLER_82_409 VGND VGND VPWR VPWR sky130_fd_sc_hd__decap_6
XPHY_EDGE_ROW_13_Right_13 VGND VGND VPWR VPWR sky130_fd_sc_hd__decap_3
XFILLER_75_472 VGND VGND VPWR VPWR sky130_fd_sc_hd__fill_1
XTAP_TAPCELL_ROW_46_810 VGND VPWR sky130_fd_sc_hd__tapvpwrvgnd_1
XFILLER_75_483 VPWR VGND VPWR VGND sky130_ef_sc_hd__decap_12
XFILLER_35_325 VGND VGND VPWR VPWR sky130_fd_sc_hd__decap_8
XFILLER_35_358 VGND VGND VPWR VPWR sky130_fd_sc_hd__decap_6
XFILLER_50_339 VPWR VGND VPWR VGND sky130_ef_sc_hd__decap_12
X_5640_ net1002 net387 VGND VGND VPWR VPWR _0181_ sky130_fd_sc_hd__and2_1
XFILLER_86_3 VGND VGND VPWR VPWR sky130_fd_sc_hd__fill_1
X_5571_ net899 net393 VGND VGND VPWR VPWR _0112_ sky130_fd_sc_hd__and2_1
XPHY_EDGE_ROW_22_Right_22 VGND VGND VPWR VPWR sky130_fd_sc_hd__decap_3
X_8290_ _3635_ _3636_ _3674_ _3675_ VGND VGND VPWR VPWR _3677_ sky130_fd_sc_hd__o211ai_1
X_7310_ net266 _2767_ _2768_ VGND VGND VPWR VPWR _2770_ sky130_fd_sc_hd__or3_4
X_4522_ _4282_ _4283_ _4286_ VGND VGND VPWR VPWR _4288_ sky130_fd_sc_hd__a21oi_1
XFILLER_117_669 VGND VGND VPWR VPWR sky130_fd_sc_hd__decap_3
X_7241_ pe_array\[1\].u_pe.accum_reg\[15\] net446 net338 VGND VGND VPWR VPWR _2703_
+ sky130_fd_sc_hd__and3_1
XFILLER_7_292 VGND VGND VPWR VPWR sky130_fd_sc_hd__fill_2
XFILLER_7_281 VGND VGND VPWR VPWR sky130_fd_sc_hd__decap_8
X_4453_ pe_array\[1\].u_pe.weight_in\[7\] VGND VGND VPWR VPWR _4234_ sky130_fd_sc_hd__inv_2
X_7172_ _2587_ _2588_ _2634_ _2635_ VGND VGND VPWR VPWR _2636_ sky130_fd_sc_hd__o211a_1
XFILLER_98_564 VGND VGND VPWR VPWR sky130_fd_sc_hd__fill_1
X_6123_ _1610_ _1612_ _1652_ _1653_ VGND VGND VPWR VPWR _1655_ sky130_fd_sc_hd__o211ai_1
XFILLER_112_363 VGND VGND VPWR VPWR sky130_fd_sc_hd__fill_1
XFILLER_105_27 VPWR VGND VPWR VGND sky130_ef_sc_hd__decap_12
X_6054_ _1586_ _1587_ VGND VGND VPWR VPWR _1588_ sky130_fd_sc_hd__nor2_1
XPHY_EDGE_ROW_31_Right_31 VGND VGND VPWR VPWR sky130_fd_sc_hd__decap_3
X_5005_ net398 pe_array\[3\].u_pe.accum_reg\[15\] net256 _0748_ VGND VGND VPWR VPWR
+ _0749_ sky130_fd_sc_hd__o2bb2a_4
XFILLER_66_461 VGND VGND VPWR VPWR sky130_fd_sc_hd__decap_6
XFILLER_54_645 VGND VGND VPWR VPWR sky130_fd_sc_hd__decap_8
XFILLER_54_634 VGND VGND VPWR VPWR sky130_fd_sc_hd__decap_8
XFILLER_53_111 VGND VGND VPWR VPWR sky130_fd_sc_hd__fill_1
XFILLER_14_509 VGND VGND VPWR VPWR sky130_fd_sc_hd__decap_6
X_6956_ _2422_ _2423_ _2424_ VGND VGND VPWR VPWR _2425_ sky130_fd_sc_hd__nand3_2
X_5907_ _1394_ _1396_ _1395_ VGND VGND VPWR VPWR _1444_ sky130_fd_sc_hd__o21ai_1
XTAP_TAPCELL_ROW_62_1001 VGND VPWR sky130_fd_sc_hd__tapvpwrvgnd_1
XTAP_TAPCELL_ROW_24_537 VGND VPWR sky130_fd_sc_hd__tapvpwrvgnd_1
X_6887_ net492 net487 net331 net329 VGND VGND VPWR VPWR _2357_ sky130_fd_sc_hd__and4_1
X_8626_ _4002_ _4001_ VGND VGND VPWR VPWR _4003_ sky130_fd_sc_hd__and2b_1
X_5838_ _1284_ _1308_ _1341_ _1340_ VGND VGND VPWR VPWR _1377_ sky130_fd_sc_hd__o31a_1
XTAP_TAPCELL_ROW_52_879 VGND VPWR sky130_fd_sc_hd__tapvpwrvgnd_1
XFILLER_14_68 VGND VGND VPWR VPWR sky130_fd_sc_hd__decap_8
XFILLER_22_586 VGND VGND VPWR VPWR sky130_fd_sc_hd__fill_2
XPHY_EDGE_ROW_40_Right_40 VGND VGND VPWR VPWR sky130_fd_sc_hd__decap_3
X_8557_ net155 _3934_ _3935_ VGND VGND VPWR VPWR _3936_ sky130_fd_sc_hd__or3_4
X_5769_ _1284_ _1308_ VGND VGND VPWR VPWR _1310_ sky130_fd_sc_hd__and2_1
Xrebuffer312 _3568_ VGND VGND VPWR VPWR net827 sky130_fd_sc_hd__buf_1
Xrebuffer356 net475 VGND VGND VPWR VPWR net871 sky130_fd_sc_hd__dlygate4sd1_1
X_7508_ _2923_ _2953_ _2925_ VGND VGND VPWR VPWR _2961_ sky130_fd_sc_hd__o21ai_1
XFILLER_30_23 VGND VGND VPWR VPWR sky130_fd_sc_hd__fill_2
XFILLER_107_135 VGND VGND VPWR VPWR sky130_fd_sc_hd__fill_1
XFILLER_107_113 VGND VGND VPWR VPWR sky130_fd_sc_hd__decap_3
X_8488_ net176 _3868_ VGND VGND VPWR VPWR _3869_ sky130_fd_sc_hd__xnor2_1
X_7439_ _2892_ _2893_ VGND VGND VPWR VPWR _2895_ sky130_fd_sc_hd__xnor2_1
XTAP_TAPCELL_ROW_73_1130 VGND VPWR sky130_fd_sc_hd__tapvpwrvgnd_1
XFILLER_89_575 VGND VGND VPWR VPWR sky130_fd_sc_hd__decap_4
X_9109_ clknet_leaf_1_clk _0221_ VGND VGND VPWR VPWR pe_array\[2\].u_pe.weight_in\[7\]
+ sky130_fd_sc_hd__dfxtp_1
XFILLER_76_236 VGND VGND VPWR VPWR sky130_fd_sc_hd__decap_8
XFILLER_29_152 VPWR VGND VPWR VGND sky130_ef_sc_hd__decap_12
XFILLER_45_612 VGND VGND VPWR VPWR sky130_fd_sc_hd__decap_4
XFILLER_55_31 VPWR VGND VPWR VGND sky130_ef_sc_hd__decap_12
XFILLER_29_174 VGND VGND VPWR VPWR sky130_fd_sc_hd__decap_3
XFILLER_72_475 VGND VGND VPWR VPWR sky130_fd_sc_hd__fill_1
XFILLER_111_81 VPWR VGND VPWR VGND sky130_ef_sc_hd__decap_12
XFILLER_13_520 VPWR VGND VPWR VGND sky130_ef_sc_hd__decap_12
XFILLER_25_391 VGND VGND VPWR VPWR sky130_fd_sc_hd__fill_1
XFILLER_40_350 VPWR VGND VPWR VGND sky130_ef_sc_hd__decap_12
XFILLER_113_138 VGND VGND VPWR VPWR sky130_fd_sc_hd__fill_1
XFILLER_96_71 VGND VGND VPWR VPWR sky130_fd_sc_hd__fill_2
XFILLER_95_523 VGND VGND VPWR VPWR sky130_fd_sc_hd__fill_1
XFILLER_67_225 VGND VGND VPWR VPWR sky130_fd_sc_hd__decap_3
XFILLER_67_214 VGND VGND VPWR VPWR sky130_fd_sc_hd__decap_8
XFILLER_67_269 VGND VGND VPWR VPWR sky130_fd_sc_hd__decap_8
XFILLER_36_612 VGND VGND VPWR VPWR sky130_fd_sc_hd__fill_1
XFILLER_35_111 VGND VGND VPWR VPWR sky130_fd_sc_hd__fill_1
X_6810_ net412 pe_array\[1\].u_pe.accum_reg\[4\] net231 _2282_ VGND VGND VPWR VPWR
+ _2283_ sky130_fd_sc_hd__o2bb2a_1
XFILLER_35_144 VGND VGND VPWR VPWR sky130_fd_sc_hd__fill_1
XFILLER_90_261 VGND VGND VPWR VPWR sky130_fd_sc_hd__fill_2
X_7790_ net955 net226 _3204_ net379 VGND VGND VPWR VPWR _0356_ sky130_fd_sc_hd__o211a_1
XFILLER_35_188 VGND VGND VPWR VPWR sky130_fd_sc_hd__decap_4
X_6741_ _2215_ _2216_ net511 net337 VGND VGND VPWR VPWR _2217_ sky130_fd_sc_hd__and4bb_1
XFILLER_50_136 VGND VGND VPWR VPWR sky130_fd_sc_hd__decap_4
X_6672_ net394 _2186_ VGND VGND VPWR VPWR _0256_ sky130_fd_sc_hd__and2_1
XTAP_TAPCELL_ROW_21_507 VGND VPWR sky130_fd_sc_hd__tapvpwrvgnd_1
XTAP_TAPCELL_ROW_98_1428 VGND VPWR sky130_fd_sc_hd__tapvpwrvgnd_1
X_8411_ _3767_ _3759_ _3757_ VGND VGND VPWR VPWR _3795_ sky130_fd_sc_hd__a21boi_4
X_5623_ net987 net382 VGND VGND VPWR VPWR _0164_ sky130_fd_sc_hd__and2_1
X_8342_ _3726_ _3727_ VGND VGND VPWR VPWR _3728_ sky130_fd_sc_hd__nand2_1
X_5554_ net1010 net393 VGND VGND VPWR VPWR _0095_ sky130_fd_sc_hd__and2_1
XFILLER_117_477 VGND VGND VPWR VPWR sky130_fd_sc_hd__fill_2
XFILLER_117_455 VGND VGND VPWR VPWR sky130_fd_sc_hd__decap_3
XFILLER_105_617 VPWR VGND VPWR VGND sky130_ef_sc_hd__decap_12
X_8273_ net401 pe_array\[2\].u_pe.accum_reg\[13\] net217 _3660_ VGND VGND VPWR VPWR
+ _3661_ sky130_fd_sc_hd__o2bb2a_1
X_5485_ net253 _0505_ VGND VGND VPWR VPWR _1203_ sky130_fd_sc_hd__nand2_1
X_4505_ _4270_ _4271_ VGND VGND VPWR VPWR _4272_ sky130_fd_sc_hd__nor2_1
XFILLER_116_15 VPWR VGND VPWR VGND sky130_ef_sc_hd__decap_12
X_7224_ _2646_ _2648_ _2685_ _2686_ VGND VGND VPWR VPWR _2687_ sky130_fd_sc_hd__o211a_1
Xfanout514 net515 VGND VGND VPWR VPWR net514 sky130_fd_sc_hd__dlymetal6s2s_1
Xfanout503 net2 VGND VGND VPWR VPWR net503 sky130_fd_sc_hd__buf_8
X_7155_ net407 pe_array\[1\].u_pe.accum_reg\[12\] net229 _2619_ VGND VGND VPWR VPWR
+ _2620_ sky130_fd_sc_hd__o2bb2a_4
X_6106_ net430 _1638_ VGND VGND VPWR VPWR _0238_ sky130_fd_sc_hd__nor2_1
XFILLER_86_545 VGND VGND VPWR VPWR sky130_fd_sc_hd__decap_6
X_7086_ net194 _2549_ _2551_ VGND VGND VPWR VPWR _2552_ sky130_fd_sc_hd__or3b_4
XFILLER_86_589 VGND VGND VPWR VPWR sky130_fd_sc_hd__decap_3
X_6037_ net656 _1569_ _1570_ VGND VGND VPWR VPWR _1571_ sky130_fd_sc_hd__nor3_1
XFILLER_73_206 VGND VGND VPWR VPWR sky130_fd_sc_hd__decap_8
XTAP_TAPCELL_ROW_29_607 VGND VPWR sky130_fd_sc_hd__tapvpwrvgnd_1
XTAP_TAPCELL_ROW_57_938 VGND VPWR sky130_fd_sc_hd__tapvpwrvgnd_1
XFILLER_26_111 VGND VGND VPWR VPWR sky130_fd_sc_hd__decap_4
Xrebuffer30 _4380_ VGND VGND VPWR VPWR net545 sky130_fd_sc_hd__buf_2
XTAP_TAPCELL_ROW_107_1535 VGND VPWR sky130_fd_sc_hd__tapvpwrvgnd_1
XFILLER_92_29 VGND VGND VPWR VPWR sky130_fd_sc_hd__fill_1
XFILLER_66_291 VPWR VGND VPWR VGND sky130_ef_sc_hd__decap_12
XFILLER_54_453 VPWR VGND VPWR VGND sky130_ef_sc_hd__decap_12
XTAP_TAPCELL_ROW_1_265 VGND VPWR sky130_fd_sc_hd__tapvpwrvgnd_1
Xrebuffer41 net557 VGND VGND VPWR VPWR net556 sky130_fd_sc_hd__dlygate4sd1_1
Xrebuffer63 net740 VGND VGND VPWR VPWR net578 sky130_fd_sc_hd__buf_4
Xrebuffer96 net615 VGND VGND VPWR VPWR net611 sky130_fd_sc_hd__buf_6
Xrebuffer85 _3890_ VGND VGND VPWR VPWR net600 sky130_fd_sc_hd__clkbuf_2
X_7988_ net497 pe_array\[2\].u_pe.weight_in\[4\] _3336_ _3335_ VGND VGND VPWR VPWR
+ _3382_ sky130_fd_sc_hd__a31o_1
Xrebuffer74 net502 VGND VGND VPWR VPWR net589 sky130_fd_sc_hd__dlygate4sd1_1
XTAP_TAPCELL_ROW_37_695 VGND VPWR sky130_fd_sc_hd__tapvpwrvgnd_1
X_6939_ net464 net334 net332 net874 VGND VGND VPWR VPWR _2408_ sky130_fd_sc_hd__a22oi_1
XFILLER_41_169 VPWR VGND VPWR VGND sky130_ef_sc_hd__decap_12
X_8609_ net263 _3984_ _3985_ VGND VGND VPWR VPWR _3986_ sky130_fd_sc_hd__nor3_1
XFILLER_10_578 VGND VGND VPWR VPWR sky130_fd_sc_hd__decap_4
XFILLER_10_556 VGND VGND VPWR VPWR sky130_fd_sc_hd__fill_2
Xrebuffer131 _0525_ VGND VGND VPWR VPWR net646 sky130_fd_sc_hd__dlymetal6s2s_1
XFILLER_41_55 VGND VGND VPWR VPWR sky130_fd_sc_hd__fill_1
XFILLER_108_477 VPWR VGND VPWR VGND sky130_ef_sc_hd__decap_12
Xrebuffer175 net689 VGND VGND VPWR VPWR net690 sky130_fd_sc_hd__dlygate4sd1_1
XFILLER_111_609 VGND VGND VPWR VPWR sky130_fd_sc_hd__decap_6
XTAP_TAPCELL_ROW_9_365 VGND VPWR sky130_fd_sc_hd__tapvpwrvgnd_1
XFILLER_1_298 VGND VGND VPWR VPWR sky130_fd_sc_hd__decap_4
XFILLER_2_27 VGND VGND VPWR VPWR sky130_fd_sc_hd__fill_1
XFILLER_92_515 VGND VGND VPWR VPWR sky130_fd_sc_hd__decap_6
XFILLER_18_645 VPWR VGND VPWR VGND sky130_ef_sc_hd__decap_12
XFILLER_45_420 VGND VGND VPWR VPWR sky130_fd_sc_hd__decap_4
XFILLER_17_144 VGND VGND VPWR VPWR sky130_fd_sc_hd__decap_3
XFILLER_45_431 VPWR VGND VPWR VGND sky130_ef_sc_hd__decap_12
XFILLER_45_453 VGND VGND VPWR VPWR sky130_fd_sc_hd__fill_2
XFILLER_17_166 VGND VGND VPWR VPWR sky130_fd_sc_hd__fill_2
XFILLER_33_626 VGND VGND VPWR VPWR sky130_fd_sc_hd__fill_2
XFILLER_17_199 VGND VGND VPWR VPWR sky130_fd_sc_hd__decap_8
Xoutput106 net106 VGND VGND VPWR VPWR result_data[60] sky130_fd_sc_hd__buf_2
Xoutput117 net117 VGND VGND VPWR VPWR result_data[70] sky130_fd_sc_hd__buf_2
Xoutput139 net139 VGND VGND VPWR VPWR result_data[90] sky130_fd_sc_hd__buf_2
Xoutput128 net128 VGND VGND VPWR VPWR result_data[80] sky130_fd_sc_hd__buf_2
X_5270_ net179 _0970_ _0969_ VGND VGND VPWR VPWR _1005_ sky130_fd_sc_hd__a21oi_1
XFILLER_102_609 VGND VGND VPWR VPWR sky130_fd_sc_hd__fill_1
XFILLER_99_169 VGND VGND VPWR VPWR sky130_fd_sc_hd__decap_4
XTAP_TAPCELL_ROW_93_1369 VGND VPWR sky130_fd_sc_hd__tapvpwrvgnd_1
XFILLER_49_3 VPWR VGND VPWR VGND sky130_ef_sc_hd__decap_12
XFILLER_68_512 VGND VGND VPWR VPWR sky130_fd_sc_hd__fill_2
XFILLER_68_589 VPWR VGND VPWR VGND sky130_ef_sc_hd__decap_12
X_8960_ clknet_leaf_60_clk _0072_ VGND VGND VPWR VPWR pe_accum\[3\]\[28\] sky130_fd_sc_hd__dfxtp_1
X_7911_ _3303_ _3304_ _3290_ VGND VGND VPWR VPWR _3307_ sky130_fd_sc_hd__a21o_1
XFILLER_70_209 VGND VGND VPWR VPWR sky130_fd_sc_hd__decap_6
X_8891_ clknet_leaf_17_clk _0003_ VGND VGND VPWR VPWR pe_array\[0\].u_pe.weight_in\[3\]
+ sky130_fd_sc_hd__dfxtp_1
XFILLER_48_291 VGND VGND VPWR VPWR sky130_fd_sc_hd__fill_1
X_7842_ _3217_ _3227_ _3239_ _3240_ VGND VGND VPWR VPWR _3241_ sky130_fd_sc_hd__nand4_1
XFILLER_51_412 VPWR VGND VPWR VGND sky130_ef_sc_hd__decap_12
XFILLER_24_604 VPWR VGND VPWR VGND sky130_ef_sc_hd__decap_12
XFILLER_36_475 VGND VGND VPWR VPWR sky130_fd_sc_hd__fill_1
X_7773_ _2930_ net221 VGND VGND VPWR VPWR _3196_ sky130_fd_sc_hd__nand2_1
XFILLER_23_147 VGND VGND VPWR VPWR sky130_fd_sc_hd__decap_6
X_4985_ _0726_ _0727_ net744 VGND VGND VPWR VPWR _0729_ sky130_fd_sc_hd__a21o_1
X_6724_ net424 _2204_ VGND VGND VPWR VPWR _0290_ sky130_fd_sc_hd__nor2_1
XTAP_TAPCELL_ROW_34_665 VGND VPWR sky130_fd_sc_hd__tapvpwrvgnd_1
XTAP_TAPCELL_ROW_102_1476 VGND VPWR sky130_fd_sc_hd__tapvpwrvgnd_1
XTAP_TAPCELL_ROW_62_996 VGND VPWR sky130_fd_sc_hd__tapvpwrvgnd_1
X_6655_ _2162_ _2169_ _1681_ _1682_ VGND VGND VPWR VPWR _2170_ sky130_fd_sc_hd__and4b_1
X_6586_ _2064_ _2066_ VGND VGND VPWR VPWR _2103_ sky130_fd_sc_hd__or2_1
X_5606_ net932 net378 VGND VGND VPWR VPWR _0147_ sky130_fd_sc_hd__and2_1
X_8325_ net187 _3708_ _3710_ VGND VGND VPWR VPWR _3711_ sky130_fd_sc_hd__or3b_4
X_5537_ net16 _1226_ _1227_ net332 VGND VGND VPWR VPWR _0080_ sky130_fd_sc_hd__a22o_1
X_8256_ net189 _3599_ _3597_ VGND VGND VPWR VPWR _3644_ sky130_fd_sc_hd__a21o_1
X_5468_ net988 net251 _1194_ net371 VGND VGND VPWR VPWR _0044_ sky130_fd_sc_hd__o211a_1
X_7207_ net266 _2667_ _2668_ VGND VGND VPWR VPWR _2670_ sky130_fd_sc_hd__or3_4
X_8187_ _3531_ _3534_ VGND VGND VPWR VPWR _3577_ sky130_fd_sc_hd__nor2_1
Xfanout322 pe_array\[2\].u_pe.weight_in\[1\] VGND VGND VPWR VPWR net322 sky130_fd_sc_hd__buf_2
Xfanout311 pe_array\[2\].u_pe.weight_in\[5\] VGND VGND VPWR VPWR net311 sky130_fd_sc_hd__clkbuf_4
Xfanout300 net301 VGND VGND VPWR VPWR net300 sky130_fd_sc_hd__buf_4
XTAP_TAPCELL_ROW_6_324 VGND VPWR sky130_fd_sc_hd__tapvpwrvgnd_1
X_5399_ _1127_ _1128_ VGND VGND VPWR VPWR _1129_ sky130_fd_sc_hd__nor2_1
Xfanout355 pe_array\[0\].u_pe.weight_in\[1\] VGND VGND VPWR VPWR net355 sky130_fd_sc_hd__clkbuf_2
XFILLER_59_534 VGND VGND VPWR VPWR sky130_fd_sc_hd__decap_3
Xfanout344 pe_array\[0\].u_pe.weight_in\[6\] VGND VGND VPWR VPWR net344 sky130_fd_sc_hd__buf_2
Xfanout333 pe_array\[1\].u_pe.weight_in\[3\] VGND VGND VPWR VPWR net333 sky130_fd_sc_hd__clkbuf_2
Xfanout366 net369 VGND VGND VPWR VPWR net366 sky130_fd_sc_hd__buf_1
X_7138_ _2602_ VGND VGND VPWR VPWR _2603_ sky130_fd_sc_hd__inv_2
Xfanout388 net389 VGND VGND VPWR VPWR net388 sky130_fd_sc_hd__dlymetal6s2s_1
Xfanout399 net405 VGND VGND VPWR VPWR net399 sky130_fd_sc_hd__buf_2
X_7069_ _2533_ _2534_ VGND VGND VPWR VPWR _2535_ sky130_fd_sc_hd__nor2_1
Xfanout377 net379 VGND VGND VPWR VPWR net377 sky130_fd_sc_hd__buf_1
XFILLER_46_217 VGND VGND VPWR VPWR sky130_fd_sc_hd__decap_4
XTAP_TAPCELL_ROW_68_1073 VGND VPWR sky130_fd_sc_hd__tapvpwrvgnd_1
XFILLER_54_261 VGND VGND VPWR VPWR sky130_fd_sc_hd__fill_2
XFILLER_15_615 VGND VGND VPWR VPWR sky130_fd_sc_hd__fill_1
XFILLER_36_99 VGND VGND VPWR VPWR sky130_fd_sc_hd__fill_2
XFILLER_14_147 VPWR VGND VPWR VGND sky130_ef_sc_hd__decap_12
XFILLER_52_65 VPWR VGND VPWR VGND sky130_ef_sc_hd__decap_12
Xinput19 weight_din[6] VGND VGND VPWR VPWR net19 sky130_fd_sc_hd__clkbuf_2
XFILLER_22_180 VGND VGND VPWR VPWR sky130_fd_sc_hd__fill_1
XFILLER_6_335 VGND VGND VPWR VPWR sky130_fd_sc_hd__decap_3
XFILLER_6_346 VPWR VGND VPWR VGND sky130_ef_sc_hd__decap_12
XFILLER_2_541 VGND VGND VPWR VPWR sky130_fd_sc_hd__fill_1
XFILLER_77_73 VGND VGND VPWR VPWR sky130_fd_sc_hd__decap_3
XFILLER_2_585 VGND VGND VPWR VPWR sky130_fd_sc_hd__decap_3
XFILLER_18_475 VGND VGND VPWR VPWR sky130_fd_sc_hd__fill_1
XFILLER_73_592 VGND VGND VPWR VPWR sky130_fd_sc_hd__decap_4
XFILLER_33_445 VGND VGND VPWR VPWR sky130_fd_sc_hd__decap_3
XFILLER_20_117 VGND VGND VPWR VPWR sky130_fd_sc_hd__fill_1
XTAP_TAPCELL_ROW_31_624 VGND VPWR sky130_fd_sc_hd__tapvpwrvgnd_1
X_4770_ net531 _0518_ VGND VGND VPWR VPWR _0519_ sky130_fd_sc_hd__xnor2_1
X_6440_ _1961_ _1960_ VGND VGND VPWR VPWR _1962_ sky130_fd_sc_hd__and2b_1
X_6371_ _1891_ _1895_ VGND VGND VPWR VPWR _1896_ sky130_fd_sc_hd__xnor2_1
XTAP_TAPCELL_ROW_11_381 VGND VPWR sky130_fd_sc_hd__tapvpwrvgnd_1
X_8110_ _3494_ _3499_ VGND VGND VPWR VPWR _3501_ sky130_fd_sc_hd__xnor2_1
X_5322_ net181 _1054_ VGND VGND VPWR VPWR _1055_ sky130_fd_sc_hd__xor2_1
X_9090_ clknet_leaf_64_clk _0202_ VGND VGND VPWR VPWR net40 sky130_fd_sc_hd__dfxtp_1
XFILLER_87_106 VGND VGND VPWR VPWR sky130_fd_sc_hd__fill_2
X_8041_ _3431_ _3432_ _3433_ VGND VGND VPWR VPWR _3434_ sky130_fd_sc_hd__nand3_1
X_5253_ pe_array\[3\].u_pe.accum_reg\[24\] _0520_ VGND VGND VPWR VPWR _0988_ sky130_fd_sc_hd__nor2_1
XFILLER_96_640 VGND VGND VPWR VPWR sky130_fd_sc_hd__decap_4
X_5184_ _0898_ _0894_ _0892_ VGND VGND VPWR VPWR _0922_ sky130_fd_sc_hd__a21oi_4
XFILLER_56_504 VGND VGND VPWR VPWR sky130_fd_sc_hd__decap_4
XFILLER_3_81 VGND VGND VPWR VPWR sky130_fd_sc_hd__decap_8
XFILLER_113_27 VPWR VGND VPWR VGND sky130_ef_sc_hd__decap_12
XFILLER_110_483 VGND VGND VPWR VPWR sky130_fd_sc_hd__fill_1
XTAP_TAPCELL_ROW_39_724 VGND VPWR sky130_fd_sc_hd__tapvpwrvgnd_1
X_8943_ clknet_leaf_61_clk _0055_ VGND VGND VPWR VPWR pe_accum\[3\]\[11\] sky130_fd_sc_hd__dfxtp_1
X_8874_ net212 _4036_ VGND VGND VPWR VPWR _4218_ sky130_fd_sc_hd__nand2_2
XTAP_TAPCELL_ROW_104_1505 VGND VPWR sky130_fd_sc_hd__tapvpwrvgnd_1
XFILLER_24_401 VGND VGND VPWR VPWR sky130_fd_sc_hd__decap_8
XFILLER_36_250 VGND VGND VPWR VPWR sky130_fd_sc_hd__fill_2
X_7825_ _3221_ _3223_ pe_array\[2\].u_pe.accum_reg\[1\] VGND VGND VPWR VPWR _3225_
+ sky130_fd_sc_hd__a21oi_1
XFILLER_51_220 VGND VGND VPWR VPWR sky130_fd_sc_hd__decap_4
XTAP_TAPCELL_ROW_19_481 VGND VPWR sky130_fd_sc_hd__tapvpwrvgnd_1
X_7756_ net962 net223 _3187_ net372 VGND VGND VPWR VPWR _0339_ sky130_fd_sc_hd__o211a_1
X_4968_ net686 _0711_ VGND VGND VPWR VPWR _0713_ sky130_fd_sc_hd__xnor2_4
X_6707_ net909 net237 _1869_ net245 VGND VGND VPWR VPWR _0277_ sky130_fd_sc_hd__o2bb2ai_1
X_4899_ net291 net289 net436 VGND VGND VPWR VPWR _0645_ sky130_fd_sc_hd__o21a_1
X_7687_ _3133_ _3134_ VGND VGND VPWR VPWR _3135_ sky130_fd_sc_hd__xnor2_2
X_6638_ _2152_ _2153_ VGND VGND VPWR VPWR _2154_ sky130_fd_sc_hd__nor2_1
XTAP_TAPCELL_ROW_115_1634 VGND VPWR sky130_fd_sc_hd__tapvpwrvgnd_1
X_6569_ _2057_ _2085_ VGND VGND VPWR VPWR _2087_ sky130_fd_sc_hd__xor2_1
X_8308_ _3693_ _3694_ VGND VGND VPWR VPWR _3695_ sky130_fd_sc_hd__nand2_2
X_9288_ clknet_leaf_9_clk _0400_ VGND VGND VPWR VPWR pe_array\[2\].u_pe.accum_reg\[30\]
+ sky130_fd_sc_hd__dfxtp_1
XFILLER_105_266 VPWR VGND VPWR VGND sky130_ef_sc_hd__decap_12
XFILLER_79_629 VPWR VGND VPWR VGND sky130_ef_sc_hd__decap_12
X_8239_ net462 _4238_ VGND VGND VPWR VPWR _3627_ sky130_fd_sc_hd__nor2_1
Xfanout163 net164 VGND VGND VPWR VPWR net163 sky130_fd_sc_hd__dlymetal6s2s_1
Xfanout174 net175 VGND VGND VPWR VPWR net174 sky130_fd_sc_hd__buf_8
Xfanout196 net197 VGND VGND VPWR VPWR net196 sky130_fd_sc_hd__buf_2
Xfanout185 _0687_ VGND VGND VPWR VPWR net185 sky130_fd_sc_hd__clkbuf_4
XFILLER_47_43 VPWR VGND VPWR VGND sky130_ef_sc_hd__decap_12
XFILLER_47_515 VGND VGND VPWR VPWR sky130_fd_sc_hd__decap_8
XFILLER_74_356 VGND VGND VPWR VPWR sky130_fd_sc_hd__decap_8
XFILLER_74_389 VGND VGND VPWR VPWR sky130_fd_sc_hd__decap_4
XFILLER_70_562 VGND VGND VPWR VPWR sky130_fd_sc_hd__fill_1
XPHY_EDGE_ROW_69_Right_69 VGND VGND VPWR VPWR sky130_fd_sc_hd__decap_3
XFILLER_63_75 VGND VGND VPWR VPWR sky130_fd_sc_hd__fill_1
XFILLER_42_253 VPWR VGND VPWR VGND sky130_ef_sc_hd__decap_12
XFILLER_8_15 VPWR VGND VPWR VGND sky130_ef_sc_hd__decap_12
XFILLER_42_297 VGND VGND VPWR VPWR sky130_fd_sc_hd__fill_1
XFILLER_30_459 VGND VGND VPWR VPWR sky130_fd_sc_hd__fill_1
XFILLER_11_662 VGND VGND VPWR VPWR sky130_fd_sc_hd__fill_1
XFILLER_11_695 VGND VGND VPWR VPWR sky130_fd_sc_hd__fill_1
XFILLER_6_121 VGND VGND VPWR VPWR sky130_fd_sc_hd__fill_1
XFILLER_109_583 VPWR VGND VPWR VGND sky130_ef_sc_hd__decap_12
XPHY_EDGE_ROW_78_Right_78 VGND VGND VPWR VPWR sky130_fd_sc_hd__decap_3
XTAP_TAPCELL_ROW_90_1339 VGND VPWR sky130_fd_sc_hd__tapvpwrvgnd_1
XTAP_TAPCELL_ROW_90_1328 VGND VPWR sky130_fd_sc_hd__tapvpwrvgnd_1
XFILLER_69_117 VGND VGND VPWR VPWR sky130_fd_sc_hd__decap_8
XFILLER_69_106 VGND VGND VPWR VPWR sky130_fd_sc_hd__decap_6
XFILLER_69_139 VGND VGND VPWR VPWR sky130_fd_sc_hd__decap_8
XFILLER_65_334 VGND VGND VPWR VPWR sky130_fd_sc_hd__fill_2
X_5940_ _1466_ _1474_ VGND VGND VPWR VPWR _1476_ sky130_fd_sc_hd__xnor2_1
XFILLER_18_250 VGND VGND VPWR VPWR sky130_fd_sc_hd__fill_2
XPHY_EDGE_ROW_87_Right_87 VGND VGND VPWR VPWR sky130_fd_sc_hd__decap_3
XFILLER_46_581 VGND VGND VPWR VPWR sky130_fd_sc_hd__decap_6
X_5871_ _1406_ _1407_ VGND VGND VPWR VPWR _1409_ sky130_fd_sc_hd__xnor2_1
XTAP_TAPCELL_ROW_16_440 VGND VPWR sky130_fd_sc_hd__tapvpwrvgnd_1
XTAP_TAPCELL_ROW_16_451 VGND VPWR sky130_fd_sc_hd__tapvpwrvgnd_1
X_7610_ _3057_ _3058_ VGND VGND VPWR VPWR _3060_ sky130_fd_sc_hd__xnor2_1
X_8590_ _3965_ _3966_ _3967_ VGND VGND VPWR VPWR _3968_ sky130_fd_sc_hd__nand3_1
X_4822_ pe_array\[3\].u_pe.accum_reg\[11\] net297 net434 VGND VGND VPWR VPWR _0570_
+ sky130_fd_sc_hd__and3_4
XFILLER_33_286 VGND VGND VPWR VPWR sky130_fd_sc_hd__fill_1
XTAP_TAPCELL_ROW_44_782 VGND VPWR sky130_fd_sc_hd__tapvpwrvgnd_1
X_7541_ pe_array\[1\].u_pe.accum_reg\[25\] _2367_ VGND VGND VPWR VPWR _2993_ sky130_fd_sc_hd__nor2_1
X_4753_ _0501_ _0500_ VGND VGND VPWR VPWR _0503_ sky130_fd_sc_hd__xnor2_2
X_7472_ _2869_ _2899_ _2871_ VGND VGND VPWR VPWR _2927_ sky130_fd_sc_hd__a21o_1
X_6423_ _1890_ _1863_ _1917_ _1889_ VGND VGND VPWR VPWR _1946_ sky130_fd_sc_hd__a2bb2o_4
X_4684_ _4435_ _4443_ VGND VGND VPWR VPWR _0435_ sky130_fd_sc_hd__xnor2_1
X_9211_ clknet_leaf_41_clk _0323_ VGND VGND VPWR VPWR pe_array\[1\].u_pe.accum_reg\[29\]
+ sky130_fd_sc_hd__dfxtp_1
XPHY_EDGE_ROW_96_Right_96 VGND VGND VPWR VPWR sky130_fd_sc_hd__decap_3
XFILLER_115_520 VGND VGND VPWR VPWR sky130_fd_sc_hd__decap_6
XFILLER_108_27 VGND VGND VPWR VPWR sky130_fd_sc_hd__fill_1
X_9142_ clknet_leaf_22_clk _0254_ VGND VGND VPWR VPWR pe_array\[0\].u_pe.accum_reg\[28\]
+ sky130_fd_sc_hd__dfxtp_1
X_6354_ net198 _1878_ VGND VGND VPWR VPWR _1879_ sky130_fd_sc_hd__xnor2_1
X_6285_ net455 net359 pe_array\[0\].u_pe.accum_reg\[18\] VGND VGND VPWR VPWR _1812_
+ sky130_fd_sc_hd__a21oi_1
X_9073_ clknet_leaf_52_clk _0185_ VGND VGND VPWR VPWR net148 sky130_fd_sc_hd__dfxtp_1
X_5305_ _1038_ net416 VGND VGND VPWR VPWR _0037_ sky130_fd_sc_hd__nor2_1
XFILLER_115_597 VPWR VGND VPWR VGND sky130_ef_sc_hd__decap_12
XFILLER_88_437 VGND VGND VPWR VPWR sky130_fd_sc_hd__fill_1
X_8024_ net443 net322 net324 VGND VGND VPWR VPWR _3417_ sky130_fd_sc_hd__and3_4
X_5236_ net179 _0941_ _0940_ VGND VGND VPWR VPWR _0972_ sky130_fd_sc_hd__a21oi_1
XTAP_TAPCELL_ROW_110_1575 VGND VPWR sky130_fd_sc_hd__tapvpwrvgnd_1
XFILLER_84_632 VGND VGND VPWR VPWR sky130_fd_sc_hd__decap_3
XFILLER_84_19 VGND VGND VPWR VPWR sky130_fd_sc_hd__decap_4
XFILLER_69_673 VPWR VGND VPWR VGND sky130_ef_sc_hd__decap_12
X_5167_ _0901_ _0902_ net284 VGND VGND VPWR VPWR _0905_ sky130_fd_sc_hd__o21ai_1
XFILLER_68_194 VGND VGND VPWR VPWR sky130_fd_sc_hd__fill_2
XFILLER_56_334 VGND VGND VPWR VPWR sky130_fd_sc_hd__fill_1
X_5098_ _0838_ _0807_ VGND VGND VPWR VPWR _0839_ sky130_fd_sc_hd__xor2_4
XFILLER_29_559 VGND VGND VPWR VPWR sky130_fd_sc_hd__fill_1
XFILLER_84_698 VGND VGND VPWR VPWR sky130_fd_sc_hd__fill_2
X_8926_ clknet_leaf_61_clk _0038_ VGND VGND VPWR VPWR pe_array\[3\].u_pe.accum_reg\[26\]
+ sky130_fd_sc_hd__dfxtp_1
XFILLER_16_209 VGND VGND VPWR VPWR sky130_fd_sc_hd__fill_1
XFILLER_71_337 VGND VGND VPWR VPWR sky130_fd_sc_hd__fill_2
XFILLER_71_326 VGND VGND VPWR VPWR sky130_fd_sc_hd__fill_1
XFILLER_17_57 VPWR VGND VPWR VGND sky130_ef_sc_hd__decap_12
XFILLER_24_220 VGND VGND VPWR VPWR sky130_fd_sc_hd__decap_3
X_8857_ net996 net210 _4209_ net380 VGND VGND VPWR VPWR _0418_ sky130_fd_sc_hd__o211a_1
XTAP_TAPCELL_ROW_65_1032 VGND VPWR sky130_fd_sc_hd__tapvpwrvgnd_1
X_8788_ net264 _4158_ VGND VGND VPWR VPWR _4159_ sky130_fd_sc_hd__xnor2_1
X_7808_ net508 pe_array\[2\].u_pe.tap_count\[1\] pe_array\[2\].u_pe.tap_count\[0\]
+ VGND VGND VPWR VPWR _3212_ sky130_fd_sc_hd__and3_1
XFILLER_52_584 VGND VGND VPWR VPWR sky130_fd_sc_hd__decap_4
X_7739_ net224 _2315_ VGND VGND VPWR VPWR _3179_ sky130_fd_sc_hd__nand2_1
XFILLER_8_419 VGND VGND VPWR VPWR sky130_fd_sc_hd__fill_1
XFILLER_116_3 VPWR VGND VPWR VGND sky130_ef_sc_hd__decap_12
XFILLER_4_625 VPWR VGND VPWR VGND sky130_ef_sc_hd__decap_12
XFILLER_106_531 VGND VGND VPWR VPWR sky130_fd_sc_hd__fill_1
XFILLER_3_113 VGND VGND VPWR VPWR sky130_fd_sc_hd__decap_6
XTAP_TAPCELL_ROW_76_1161 VGND VPWR sky130_fd_sc_hd__tapvpwrvgnd_1
XFILLER_4_669 VPWR VGND VPWR VGND sky130_ef_sc_hd__decap_12
XFILLER_3_179 VGND VGND VPWR VPWR sky130_fd_sc_hd__fill_2
XFILLER_58_53 VPWR VGND VPWR VGND sky130_ef_sc_hd__decap_12
XFILLER_87_481 VGND VGND VPWR VPWR sky130_fd_sc_hd__fill_2
XFILLER_58_97 VPWR VGND VPWR VGND sky130_ef_sc_hd__decap_12
XFILLER_47_334 VGND VGND VPWR VPWR sky130_fd_sc_hd__fill_2
XFILLER_90_602 VGND VGND VPWR VPWR sky130_fd_sc_hd__decap_8
XFILLER_74_153 VPWR VGND VPWR VGND sky130_ef_sc_hd__decap_12
XFILLER_47_389 VGND VGND VPWR VPWR sky130_fd_sc_hd__decap_3
XFILLER_74_186 VGND VGND VPWR VPWR sky130_fd_sc_hd__decap_4
XFILLER_74_85 VPWR VGND VPWR VGND sky130_ef_sc_hd__decap_12
XFILLER_43_551 VGND VGND VPWR VPWR sky130_fd_sc_hd__fill_2
XFILLER_30_201 VGND VGND VPWR VPWR sky130_fd_sc_hd__fill_1
XFILLER_43_595 VPWR VGND VPWR VGND sky130_ef_sc_hd__decap_12
XTAP_TAPCELL_ROW_13_410 VGND VPWR sky130_fd_sc_hd__tapvpwrvgnd_1
XTAP_TAPCELL_ROW_41_741 VGND VPWR sky130_fd_sc_hd__tapvpwrvgnd_1
XFILLER_7_441 VGND VGND VPWR VPWR sky130_fd_sc_hd__decap_6
Xhold408 pe_accum\[3\]\[3\] VGND VGND VPWR VPWR net923 sky130_fd_sc_hd__dlygate4sd3_1
Xhold419 pe_accum\[3\]\[7\] VGND VGND VPWR VPWR net934 sky130_fd_sc_hd__dlygate4sd3_1
XFILLER_112_501 VGND VGND VPWR VPWR sky130_fd_sc_hd__fill_2
XFILLER_31_3 VGND VGND VPWR VPWR sky130_fd_sc_hd__decap_3
X_6070_ _1601_ _1602_ VGND VGND VPWR VPWR _1603_ sky130_fd_sc_hd__nor2_1
XFILLER_112_589 VPWR VGND VPWR VGND sky130_ef_sc_hd__decap_12
X_5021_ _0761_ _0762_ net184 VGND VGND VPWR VPWR _0764_ sky130_fd_sc_hd__o21ai_1
XFILLER_66_643 VGND VGND VPWR VPWR sky130_fd_sc_hd__fill_1
XTAP_TAPCELL_ROW_49_841 VGND VPWR sky130_fd_sc_hd__tapvpwrvgnd_1
XFILLER_26_529 VGND VGND VPWR VPWR sky130_fd_sc_hd__decap_3
XFILLER_38_378 VGND VGND VPWR VPWR sky130_fd_sc_hd__fill_2
X_8711_ _4055_ _4084_ VGND VGND VPWR VPWR _4085_ sky130_fd_sc_hd__nand2_1
XFILLER_80_123 VPWR VGND VPWR VGND sky130_ef_sc_hd__decap_12
XFILLER_80_112 VGND VGND VPWR VPWR sky130_fd_sc_hd__fill_1
X_6972_ net406 pe_array\[1\].u_pe.accum_reg\[8\] net231 _2440_ VGND VGND VPWR VPWR
+ _2441_ sky130_fd_sc_hd__o2bb2a_1
X_5923_ _1380_ _1413_ _1412_ VGND VGND VPWR VPWR _1460_ sky130_fd_sc_hd__a21oi_1
X_8642_ _4016_ _4017_ VGND VGND VPWR VPWR _4018_ sky130_fd_sc_hd__nor2_1
X_5854_ _1352_ _1391_ VGND VGND VPWR VPWR _1392_ sky130_fd_sc_hd__xnor2_1
X_8573_ net262 _3948_ _3949_ VGND VGND VPWR VPWR _3951_ sky130_fd_sc_hd__or3_1
X_4805_ net399 pe_array\[3\].u_pe.accum_reg\[10\] net255 _0553_ VGND VGND VPWR VPWR
+ _0554_ sky130_fd_sc_hd__o2bb2a_1
X_5785_ _1321_ _1322_ net480 net355 VGND VGND VPWR VPWR _1325_ sky130_fd_sc_hd__a2bb2o_1
X_7524_ _2701_ _2976_ VGND VGND VPWR VPWR _2977_ sky130_fd_sc_hd__nor2_1
X_4736_ _0483_ _0484_ net287 VGND VGND VPWR VPWR _0486_ sky130_fd_sc_hd__o21a_1
XFILLER_107_317 VPWR VGND VPWR VGND sky130_ef_sc_hd__decap_12
X_7455_ _2907_ _2908_ _2881_ _2882_ VGND VGND VPWR VPWR _2910_ sky130_fd_sc_hd__a211o_1
X_4667_ _4427_ _4428_ VGND VGND VPWR VPWR _4429_ sky130_fd_sc_hd__nor2_1
X_6406_ net202 _1927_ _1928_ VGND VGND VPWR VPWR _1929_ sky130_fd_sc_hd__and3_1
X_7386_ _2840_ _2841_ _2842_ VGND VGND VPWR VPWR _2844_ sky130_fd_sc_hd__a21o_1
XFILLER_115_350 VPWR VGND VPWR VGND sky130_ef_sc_hd__decap_12
X_6337_ _1860_ _1861_ _1862_ VGND VGND VPWR VPWR _1863_ sky130_fd_sc_hd__nand3_2
X_9125_ clknet_3_7__leaf_clk _0237_ VGND VGND VPWR VPWR pe_array\[0\].u_pe.accum_reg\[11\]
+ sky130_fd_sc_hd__dfxtp_1
XFILLER_1_617 VPWR VGND VPWR VGND sky130_ef_sc_hd__decap_12
X_4598_ _4354_ _4359_ VGND VGND VPWR VPWR _4361_ sky130_fd_sc_hd__xnor2_1
X_6268_ net173 _1764_ _1763_ VGND VGND VPWR VPWR _1796_ sky130_fd_sc_hd__o21bai_1
X_9056_ clknet_leaf_5_clk _0168_ VGND VGND VPWR VPWR net130 sky130_fd_sc_hd__dfxtp_1
XFILLER_88_278 VPWR VGND VPWR VGND sky130_ef_sc_hd__decap_12
X_8007_ _3399_ _3400_ VGND VGND VPWR VPWR _3401_ sky130_fd_sc_hd__and2b_1
X_6199_ net200 _1693_ _1691_ VGND VGND VPWR VPWR _1729_ sky130_fd_sc_hd__a21o_1
XFILLER_76_429 VGND VGND VPWR VPWR sky130_fd_sc_hd__fill_1
X_5219_ pe_array\[3\].u_pe.accum_reg\[23\] net296 net434 VGND VGND VPWR VPWR _0955_
+ sky130_fd_sc_hd__and3_1
XFILLER_84_440 VGND VGND VPWR VPWR sky130_fd_sc_hd__decap_3
XFILLER_72_613 VPWR VGND VPWR VGND sky130_ef_sc_hd__decap_12
XFILLER_29_378 VPWR VGND VPWR VGND sky130_ef_sc_hd__decap_12
XFILLER_56_197 VGND VGND VPWR VPWR sky130_fd_sc_hd__decap_3
X_8909_ clknet_leaf_55_clk _0021_ VGND VGND VPWR VPWR pe_array\[3\].u_pe.accum_reg\[9\]
+ sky130_fd_sc_hd__dfxtp_1
XFILLER_71_189 VGND VGND VPWR VPWR sky130_fd_sc_hd__decap_6
XTAP_TAPCELL_ROW_27_579 VGND VPWR sky130_fd_sc_hd__tapvpwrvgnd_1
XFILLER_44_77 VGND VGND VPWR VPWR sky130_fd_sc_hd__decap_6
XFILLER_12_234 VPWR VGND VPWR VGND sky130_ef_sc_hd__decap_12
XFILLER_12_278 VGND VGND VPWR VPWR sky130_fd_sc_hd__fill_1
XFILLER_60_65 VPWR VGND VPWR VGND sky130_ef_sc_hd__decap_12
XFILLER_5_27 VPWR VGND VPWR VGND sky130_ef_sc_hd__decap_12
XFILLER_4_433 VPWR VGND VPWR VGND sky130_ef_sc_hd__decap_12
XFILLER_109_81 VGND VGND VPWR VPWR sky130_fd_sc_hd__decap_8
XFILLER_106_350 VGND VGND VPWR VPWR sky130_fd_sc_hd__decap_4
XFILLER_69_30 VGND VGND VPWR VPWR sky130_fd_sc_hd__decap_8
XFILLER_4_477 VGND VGND VPWR VPWR sky130_fd_sc_hd__decap_4
XFILLER_79_212 VPWR VGND VPWR VGND sky130_ef_sc_hd__decap_12
XFILLER_69_63 VGND VGND VPWR VPWR sky130_fd_sc_hd__decap_4
XFILLER_69_52 VGND VGND VPWR VPWR sky130_fd_sc_hd__decap_4
XFILLER_47_131 VGND VGND VPWR VPWR sky130_fd_sc_hd__fill_1
XTAP_TAPCELL_ROW_46_800 VGND VPWR sky130_fd_sc_hd__tapvpwrvgnd_1
XFILLER_90_432 VGND VGND VPWR VPWR sky130_fd_sc_hd__fill_2
XFILLER_90_421 VGND VGND VPWR VPWR sky130_fd_sc_hd__decap_8
XFILLER_90_410 VGND VGND VPWR VPWR sky130_fd_sc_hd__decap_8
XFILLER_75_495 VGND VGND VPWR VPWR sky130_fd_sc_hd__decap_8
XFILLER_62_123 VGND VGND VPWR VPWR sky130_fd_sc_hd__fill_1
XFILLER_35_337 VGND VGND VPWR VPWR sky130_fd_sc_hd__decap_8
XTAP_TAPCELL_ROW_46_811 VGND VPWR sky130_fd_sc_hd__tapvpwrvgnd_1
XFILLER_90_454 VGND VGND VPWR VPWR sky130_fd_sc_hd__decap_3
XFILLER_63_679 VGND VGND VPWR VPWR sky130_fd_sc_hd__decap_4
XFILLER_31_543 VGND VGND VPWR VPWR sky130_fd_sc_hd__decap_3
X_5570_ net910 net393 VGND VGND VPWR VPWR _0111_ sky130_fd_sc_hd__and2_1
X_4521_ _4282_ _4283_ _4286_ VGND VGND VPWR VPWR _4287_ sky130_fd_sc_hd__and3_1
X_4452_ net329 VGND VGND VPWR VPWR _4233_ sky130_fd_sc_hd__inv_2
X_7240_ net446 net338 pe_array\[1\].u_pe.accum_reg\[15\] VGND VGND VPWR VPWR _2702_
+ sky130_fd_sc_hd__a21oi_1
XFILLER_104_309 VGND VGND VPWR VPWR sky130_fd_sc_hd__decap_8
X_7171_ _2631_ _2632_ net268 VGND VGND VPWR VPWR _2635_ sky130_fd_sc_hd__o21ai_1
X_6122_ _1610_ _1612_ _1652_ _1653_ VGND VGND VPWR VPWR _1654_ sky130_fd_sc_hd__o211a_1
XFILLER_58_407 VPWR VGND VPWR VGND sky130_ef_sc_hd__decap_12
XFILLER_105_39 VGND VGND VPWR VPWR sky130_fd_sc_hd__fill_1
XFILLER_98_587 VGND VGND VPWR VPWR sky130_fd_sc_hd__fill_1
X_6053_ _1584_ _1585_ _1517_ _1519_ VGND VGND VPWR VPWR _1587_ sky130_fd_sc_hd__o211a_1
XFILLER_85_237 VGND VGND VPWR VPWR sky130_fd_sc_hd__fill_2
X_5004_ _0747_ _0746_ VGND VGND VPWR VPWR _0748_ sky130_fd_sc_hd__xnor2_2
XFILLER_54_613 VGND VGND VPWR VPWR sky130_fd_sc_hd__decap_4
XFILLER_93_281 VGND VGND VPWR VPWR sky130_fd_sc_hd__decap_3
XFILLER_53_145 VPWR VGND VPWR VGND sky130_ef_sc_hd__decap_12
X_6955_ _2366_ _2374_ _2373_ VGND VGND VPWR VPWR _2424_ sky130_fd_sc_hd__a21bo_1
X_5906_ _1439_ _1440_ net274 VGND VGND VPWR VPWR _1443_ sky130_fd_sc_hd__o21ai_1
XTAP_TAPCELL_ROW_62_1002 VGND VPWR sky130_fd_sc_hd__tapvpwrvgnd_1
XFILLER_53_189 VGND VGND VPWR VPWR sky130_fd_sc_hd__fill_2
XFILLER_22_510 VGND VGND VPWR VPWR sky130_fd_sc_hd__decap_6
XFILLER_34_370 VGND VGND VPWR VPWR sky130_fd_sc_hd__decap_6
X_8625_ _3963_ _3965_ VGND VGND VPWR VPWR _4002_ sky130_fd_sc_hd__and2_1
XTAP_TAPCELL_ROW_24_538 VGND VPWR sky130_fd_sc_hd__tapvpwrvgnd_1
X_6886_ net487 net331 net329 net495 VGND VGND VPWR VPWR _2356_ sky130_fd_sc_hd__a22oi_1
X_5837_ _1374_ _1338_ VGND VGND VPWR VPWR _1376_ sky130_fd_sc_hd__xnor2_1
X_8556_ net572 _3932_ _3933_ VGND VGND VPWR VPWR _3935_ sky130_fd_sc_hd__a21oi_2
X_5768_ _1284_ _1308_ VGND VGND VPWR VPWR _1309_ sky130_fd_sc_hd__nor2_1
Xrebuffer313 _3266_ VGND VGND VPWR VPWR net828 sky130_fd_sc_hd__dlygate4sd1_1
X_8487_ _3866_ _3867_ VGND VGND VPWR VPWR _3868_ sky130_fd_sc_hd__and2b_1
Xrebuffer357 net871 VGND VGND VPWR VPWR net872 sky130_fd_sc_hd__dlymetal6s2s_1
X_4719_ _4439_ _4440_ _4437_ VGND VGND VPWR VPWR _0469_ sky130_fd_sc_hd__a21oi_1
X_7507_ _2818_ _2875_ _2959_ VGND VGND VPWR VPWR _2960_ sky130_fd_sc_hd__or3_1
X_5699_ net409 net1032 _1233_ _1243_ VGND VGND VPWR VPWR _1244_ sky130_fd_sc_hd__a22oi_1
X_7438_ _2893_ _2892_ VGND VGND VPWR VPWR _2894_ sky130_fd_sc_hd__and2b_1
XFILLER_116_681 VPWR VGND VPWR VGND sky130_ef_sc_hd__decap_12
XTAP_TAPCELL_ROW_73_1131 VGND VPWR sky130_fd_sc_hd__tapvpwrvgnd_1
X_7369_ _2823_ _2824_ net267 VGND VGND VPWR VPWR _2827_ sky130_fd_sc_hd__o21ai_1
XFILLER_89_565 VGND VGND VPWR VPWR sky130_fd_sc_hd__fill_1
X_9108_ clknet_leaf_0_clk _0220_ VGND VGND VPWR VPWR pe_array\[2\].u_pe.weight_in\[6\]
+ sky130_fd_sc_hd__dfxtp_1
XFILLER_39_11 VGND VGND VPWR VPWR sky130_fd_sc_hd__fill_1
X_9039_ clknet_leaf_12_clk _0151_ VGND VGND VPWR VPWR net111 sky130_fd_sc_hd__dfxtp_1
XFILLER_39_99 VGND VGND VPWR VPWR sky130_fd_sc_hd__decap_4
XFILLER_72_421 VPWR VGND VPWR VGND sky130_ef_sc_hd__decap_12
XFILLER_55_43 VPWR VGND VPWR VGND sky130_ef_sc_hd__decap_12
XTAP_TAPCELL_ROW_4_296 VGND VPWR sky130_fd_sc_hd__tapvpwrvgnd_1
XFILLER_17_337 VPWR VGND VPWR VGND sky130_ef_sc_hd__decap_12
XPHY_EDGE_ROW_105_Right_105 VGND VGND VPWR VPWR sky130_fd_sc_hd__decap_3
XTAP_TAPCELL_ROW_84_1260 VGND VPWR sky130_fd_sc_hd__tapvpwrvgnd_1
XFILLER_72_498 VPWR VGND VPWR VGND sky130_ef_sc_hd__decap_12
XFILLER_72_487 VGND VGND VPWR VPWR sky130_fd_sc_hd__fill_1
XFILLER_32_307 VGND VGND VPWR VPWR sky130_fd_sc_hd__fill_1
XFILLER_13_532 VGND VGND VPWR VPWR sky130_fd_sc_hd__decap_3
XFILLER_111_93 VGND VGND VPWR VPWR sky130_fd_sc_hd__decap_8
XFILLER_9_503 VGND VGND VPWR VPWR sky130_fd_sc_hd__fill_1
XFILLER_40_362 VGND VGND VPWR VPWR sky130_fd_sc_hd__fill_2
XFILLER_71_97 VPWR VGND VPWR VGND sky130_ef_sc_hd__decap_12
XFILLER_40_395 VGND VGND VPWR VPWR sky130_fd_sc_hd__fill_2
XFILLER_99_318 VPWR VGND VPWR VGND sky130_ef_sc_hd__decap_12
XFILLER_90_240 VPWR VGND VPWR VGND sky130_ef_sc_hd__decap_12
XFILLER_51_605 VGND VGND VPWR VPWR sky130_fd_sc_hd__decap_8
XFILLER_63_498 VGND VGND VPWR VPWR sky130_fd_sc_hd__decap_3
X_6740_ pe_array\[1\].u_pe.accum_reg\[1\] net503 net342 VGND VGND VPWR VPWR _2216_
+ sky130_fd_sc_hd__and3_1
XFILLER_90_284 VGND VGND VPWR VPWR sky130_fd_sc_hd__decap_3
XFILLER_50_148 VPWR VGND VPWR VGND sky130_ef_sc_hd__decap_12
X_6671_ net410 pe_array\[0\].u_pe.accum_reg\[30\] _1233_ _2185_ VGND VGND VPWR VPWR
+ _2186_ sky130_fd_sc_hd__a22o_1
XTAP_TAPCELL_ROW_21_508 VGND VPWR sky130_fd_sc_hd__tapvpwrvgnd_1
X_8410_ _3792_ _3793_ VGND VGND VPWR VPWR _3794_ sky130_fd_sc_hd__or2_4
X_5622_ net935 net382 VGND VGND VPWR VPWR _0163_ sky130_fd_sc_hd__and2_1
XFILLER_31_373 VGND VGND VPWR VPWR sky130_fd_sc_hd__fill_1
XFILLER_31_384 VGND VGND VPWR VPWR sky130_fd_sc_hd__decap_8
X_5553_ net1006 net393 VGND VGND VPWR VPWR _0094_ sky130_fd_sc_hd__and2_1
XTAP_TAPCELL_ROW_98_1429 VGND VPWR sky130_fd_sc_hd__tapvpwrvgnd_1
X_8341_ net562 _3724_ _3725_ VGND VGND VPWR VPWR _3727_ sky130_fd_sc_hd__nand3_1
XFILLER_117_434 VGND VGND VPWR VPWR sky130_fd_sc_hd__decap_3
X_4504_ _4267_ _4268_ _4269_ VGND VGND VPWR VPWR _4271_ sky130_fd_sc_hd__a21oi_1
X_8272_ _3658_ _3659_ VGND VGND VPWR VPWR _3660_ sky130_fd_sc_hd__xor2_1
X_5484_ net917 net253 _1202_ net367 VGND VGND VPWR VPWR _0052_ sky130_fd_sc_hd__o211a_1
XFILLER_105_629 VGND VGND VPWR VPWR sky130_fd_sc_hd__fill_2
XFILLER_104_106 VGND VGND VPWR VPWR sky130_fd_sc_hd__decap_4
X_7223_ _2683_ _2684_ _2660_ VGND VGND VPWR VPWR _2686_ sky130_fd_sc_hd__o21ai_1
XFILLER_116_27 VGND VGND VPWR VPWR sky130_fd_sc_hd__fill_1
XFILLER_104_139 VGND VGND VPWR VPWR sky130_fd_sc_hd__fill_1
Xfanout504 net506 VGND VGND VPWR VPWR net504 sky130_fd_sc_hd__buf_2
Xfanout515 net1 VGND VGND VPWR VPWR net515 sky130_fd_sc_hd__clkbuf_2
X_7154_ _2618_ _2617_ VGND VGND VPWR VPWR _2619_ sky130_fd_sc_hd__or2_4
XFILLER_113_673 VPWR VGND VPWR VGND sky130_ef_sc_hd__decap_12
XFILLER_98_351 VPWR VGND VPWR VGND sky130_ef_sc_hd__decap_12
XFILLER_86_513 VGND VGND VPWR VPWR sky130_fd_sc_hd__decap_8
X_6105_ net412 pe_array\[0\].u_pe.accum_reg\[12\] net240 _1637_ VGND VGND VPWR VPWR
+ _1638_ sky130_fd_sc_hd__o2bb2a_1
XFILLER_112_172 VGND VGND VPWR VPWR sky130_fd_sc_hd__decap_3
X_7085_ _2547_ _2548_ _2503_ _2505_ VGND VGND VPWR VPWR _2551_ sky130_fd_sc_hd__a211o_1
XFILLER_86_568 VGND VGND VPWR VPWR sky130_fd_sc_hd__fill_1
X_6036_ pe_array\[0\].u_pe.accum_reg\[11\] net455 net361 VGND VGND VPWR VPWR _1570_
+ sky130_fd_sc_hd__and3_1
XTAP_TAPCELL_ROW_57_939 VGND VPWR sky130_fd_sc_hd__tapvpwrvgnd_1
Xrebuffer20 _4414_ VGND VGND VPWR VPWR net535 sky130_fd_sc_hd__dlygate4sd1_1
XTAP_TAPCELL_ROW_107_1536 VGND VPWR sky130_fd_sc_hd__tapvpwrvgnd_1
XFILLER_92_19 VGND VGND VPWR VPWR sky130_fd_sc_hd__decap_8
XTAP_TAPCELL_ROW_1_266 VGND VPWR sky130_fd_sc_hd__tapvpwrvgnd_1
XFILLER_27_646 VGND VGND VPWR VPWR sky130_fd_sc_hd__fill_1
Xrebuffer31 _2506_ VGND VGND VPWR VPWR net546 sky130_fd_sc_hd__dlymetal6s2s_1
Xrebuffer64 _4306_ VGND VGND VPWR VPWR net579 sky130_fd_sc_hd__dlymetal6s2s_1
Xrebuffer42 net558 VGND VGND VPWR VPWR net557 sky130_fd_sc_hd__dlygate4sd1_1
Xrebuffer86 net600 VGND VGND VPWR VPWR net601 sky130_fd_sc_hd__dlymetal6s4s_1
X_7987_ _3365_ _3379_ VGND VGND VPWR VPWR _3381_ sky130_fd_sc_hd__xnor2_1
XFILLER_54_465 VGND VGND VPWR VPWR sky130_fd_sc_hd__fill_1
Xrebuffer75 net589 VGND VGND VPWR VPWR net590 sky130_fd_sc_hd__dlygate4sd1_1
XFILLER_25_57 VPWR VGND VPWR VGND sky130_ef_sc_hd__decap_12
XTAP_TAPCELL_ROW_37_696 VGND VPWR sky130_fd_sc_hd__tapvpwrvgnd_1
X_6938_ _2397_ _2405_ VGND VGND VPWR VPWR _2407_ sky130_fd_sc_hd__xnor2_1
X_6869_ _2337_ _2338_ _2339_ VGND VGND VPWR VPWR _2340_ sky130_fd_sc_hd__nand3_1
XFILLER_10_502 VGND VGND VPWR VPWR sky130_fd_sc_hd__decap_8
X_8608_ pe_array\[2\].u_pe.accum_reg\[24\] _3508_ VGND VGND VPWR VPWR _3985_ sky130_fd_sc_hd__nor2_1
X_8539_ net442 net316 pe_array\[2\].u_pe.accum_reg\[22\] VGND VGND VPWR VPWR _3918_
+ sky130_fd_sc_hd__a21oi_1
Xrebuffer165 net261 VGND VGND VPWR VPWR net680 sky130_fd_sc_hd__buf_6
Xrebuffer143 _1493_ VGND VGND VPWR VPWR net658 sky130_fd_sc_hd__dlygate4sd1_1
XFILLER_108_467 VGND VGND VPWR VPWR sky130_fd_sc_hd__decap_8
Xrebuffer176 _0841_ VGND VGND VPWR VPWR net691 sky130_fd_sc_hd__buf_6
XFILLER_108_489 VGND VGND VPWR VPWR sky130_fd_sc_hd__decap_8
XTAP_TAPCELL_ROW_9_366 VGND VPWR sky130_fd_sc_hd__tapvpwrvgnd_1
XFILLER_9_3 VPWR VGND VPWR VGND sky130_ef_sc_hd__decap_12
XFILLER_1_266 VPWR VGND VPWR VGND sky130_ef_sc_hd__decap_12
XFILLER_77_535 VGND VGND VPWR VPWR sky130_fd_sc_hd__decap_4
XFILLER_49_237 VGND VGND VPWR VPWR sky130_fd_sc_hd__decap_3
XFILLER_106_93 VGND VGND VPWR VPWR sky130_fd_sc_hd__fill_2
XFILLER_66_97 VGND VGND VPWR VPWR sky130_fd_sc_hd__fill_2
XFILLER_18_657 VGND VGND VPWR VPWR sky130_fd_sc_hd__fill_1
XFILLER_45_443 VGND VGND VPWR VPWR sky130_fd_sc_hd__decap_4
XFILLER_17_178 VGND VGND VPWR VPWR sky130_fd_sc_hd__decap_8
XFILLER_45_465 VGND VGND VPWR VPWR sky130_fd_sc_hd__decap_6
XFILLER_60_446 VGND VGND VPWR VPWR sky130_fd_sc_hd__fill_2
XFILLER_60_435 VGND VGND VPWR VPWR sky130_fd_sc_hd__fill_1
XFILLER_82_96 VPWR VGND VPWR VGND sky130_ef_sc_hd__decap_12
XFILLER_41_660 VGND VGND VPWR VPWR sky130_fd_sc_hd__fill_1
XFILLER_40_192 VGND VGND VPWR VPWR sky130_fd_sc_hd__decap_4
XFILLER_9_388 VGND VGND VPWR VPWR sky130_fd_sc_hd__decap_4
Xoutput107 net107 VGND VGND VPWR VPWR result_data[61] sky130_fd_sc_hd__buf_2
Xoutput118 net118 VGND VGND VPWR VPWR result_data[71] sky130_fd_sc_hd__buf_2
Xoutput129 net129 VGND VGND VPWR VPWR result_data[81] sky130_fd_sc_hd__buf_2
XFILLER_114_459 VGND VGND VPWR VPWR sky130_fd_sc_hd__decap_3
X_7910_ _3305_ VGND VGND VPWR VPWR _3306_ sky130_fd_sc_hd__inv_2
X_8890_ clknet_leaf_17_clk _0002_ VGND VGND VPWR VPWR pe_array\[0\].u_pe.weight_in\[2\]
+ sky130_fd_sc_hd__dfxtp_1
X_7841_ _3235_ _3237_ _3222_ _3224_ VGND VGND VPWR VPWR _3240_ sky130_fd_sc_hd__a211o_1
XFILLER_36_421 VGND VGND VPWR VPWR sky130_fd_sc_hd__decap_6
XFILLER_102_29 VGND VGND VPWR VPWR sky130_fd_sc_hd__decap_4
XFILLER_63_273 VGND VGND VPWR VPWR sky130_fd_sc_hd__decap_3
XFILLER_24_616 VGND VGND VPWR VPWR sky130_fd_sc_hd__fill_2
XFILLER_51_424 VPWR VGND VPWR VGND sky130_ef_sc_hd__decap_12
X_7772_ net922 net222 _3195_ net375 VGND VGND VPWR VPWR _0347_ sky130_fd_sc_hd__o211a_1
X_4984_ net688 _0725_ _0727_ VGND VGND VPWR VPWR _0728_ sky130_fd_sc_hd__or3b_1
X_6723_ net232 net507 pe_array\[1\].u_pe.tap_count\[0\] VGND VGND VPWR VPWR _2204_
+ sky130_fd_sc_hd__mux2_1
XTAP_TAPCELL_ROW_34_666 VGND VPWR sky130_fd_sc_hd__tapvpwrvgnd_1
XTAP_TAPCELL_ROW_102_1477 VGND VPWR sky130_fd_sc_hd__tapvpwrvgnd_1
X_6654_ _2167_ _2168_ VGND VGND VPWR VPWR _2169_ sky130_fd_sc_hd__nor2_1
XTAP_TAPCELL_ROW_62_997 VGND VPWR sky130_fd_sc_hd__tapvpwrvgnd_1
X_5605_ net966 net377 VGND VGND VPWR VPWR _0146_ sky130_fd_sc_hd__and2_1
X_6585_ _2100_ _2101_ VGND VGND VPWR VPWR _2102_ sky130_fd_sc_hd__nor2_1
XFILLER_11_15 VPWR VGND VPWR VGND sky130_ef_sc_hd__decap_12
XFILLER_117_231 VGND VGND VPWR VPWR sky130_fd_sc_hd__decap_3
X_8324_ _3706_ _3707_ _3672_ _3673_ VGND VGND VPWR VPWR _3710_ sky130_fd_sc_hd__a211o_1
X_5536_ net15 _1226_ _1227_ net335 VGND VGND VPWR VPWR _0079_ sky130_fd_sc_hd__a22o_1
X_8255_ _3640_ _3641_ net189 VGND VGND VPWR VPWR _3643_ sky130_fd_sc_hd__a21o_1
X_5467_ net253 _4253_ VGND VGND VPWR VPWR _1194_ sky130_fd_sc_hd__nand2_1
XFILLER_87_19 VGND VGND VPWR VPWR sky130_fd_sc_hd__fill_2
X_7206_ net266 _2667_ _2668_ VGND VGND VPWR VPWR _2669_ sky130_fd_sc_hd__nor3_1
XFILLER_99_671 VGND VGND VPWR VPWR sky130_fd_sc_hd__fill_1
Xfanout323 pe_array\[2\].u_pe.weight_in\[1\] VGND VGND VPWR VPWR net323 sky130_fd_sc_hd__clkbuf_2
X_8186_ _3574_ _3575_ VGND VGND VPWR VPWR _3576_ sky130_fd_sc_hd__nor2_4
Xfanout312 pe_array\[2\].u_pe.weight_in\[4\] VGND VGND VPWR VPWR net312 sky130_fd_sc_hd__buf_2
Xfanout301 pe_array\[3\].u_pe.weight_in\[3\] VGND VGND VPWR VPWR net301 sky130_fd_sc_hd__buf_6
XTAP_TAPCELL_ROW_6_325 VGND VPWR sky130_fd_sc_hd__tapvpwrvgnd_1
X_5398_ pe_array\[3\].u_pe.accum_reg\[29\] net301 net629 VGND VGND VPWR VPWR _1128_
+ sky130_fd_sc_hd__and3_1
XFILLER_98_170 VPWR VGND VPWR VGND sky130_ef_sc_hd__decap_12
XFILLER_86_321 VGND VGND VPWR VPWR sky130_fd_sc_hd__decap_8
Xfanout356 net357 VGND VGND VPWR VPWR net356 sky130_fd_sc_hd__buf_2
Xfanout345 pe_array\[0\].u_pe.weight_in\[6\] VGND VGND VPWR VPWR net345 sky130_fd_sc_hd__buf_1
Xfanout334 net335 VGND VGND VPWR VPWR net334 sky130_fd_sc_hd__buf_2
X_7137_ _2555_ _2557_ _2599_ _2601_ VGND VGND VPWR VPWR _2602_ sky130_fd_sc_hd__a211oi_2
Xfanout389 net396 VGND VGND VPWR VPWR net389 sky130_fd_sc_hd__clkbuf_4
XFILLER_59_579 VPWR VGND VPWR VGND sky130_ef_sc_hd__decap_12
Xfanout378 net379 VGND VGND VPWR VPWR net378 sky130_fd_sc_hd__buf_2
Xfanout367 net368 VGND VGND VPWR VPWR net367 sky130_fd_sc_hd__buf_2
X_7068_ net472 net464 net328 net326 VGND VGND VPWR VPWR _2534_ sky130_fd_sc_hd__and4_1
X_6019_ net411 pe_array\[0\].u_pe.accum_reg\[10\] net238 _1553_ VGND VGND VPWR VPWR
+ _1554_ sky130_fd_sc_hd__o2bb2a_1
XFILLER_74_516 VGND VGND VPWR VPWR sky130_fd_sc_hd__fill_2
XFILLER_100_197 VPWR VGND VPWR VGND sky130_ef_sc_hd__decap_12
XFILLER_39_281 VPWR VGND VPWR VGND sky130_ef_sc_hd__decap_12
XTAP_TAPCELL_ROW_68_1074 VGND VPWR sky130_fd_sc_hd__tapvpwrvgnd_1
XFILLER_36_89 VGND VGND VPWR VPWR sky130_fd_sc_hd__fill_1
XTAP_TAPCELL_ROW_81_1230 VGND VPWR sky130_fd_sc_hd__tapvpwrvgnd_1
XFILLER_14_159 VGND VGND VPWR VPWR sky130_fd_sc_hd__decap_8
XFILLER_52_77 VGND VGND VPWR VPWR sky130_fd_sc_hd__decap_6
XFILLER_10_365 VPWR VGND VPWR VGND sky130_ef_sc_hd__decap_12
XFILLER_6_358 VGND VGND VPWR VPWR sky130_fd_sc_hd__decap_6
XFILLER_117_81 VGND VGND VPWR VPWR sky130_fd_sc_hd__decap_3
XFILLER_2_553 VPWR VGND VPWR VGND sky130_ef_sc_hd__decap_12
XFILLER_77_41 VPWR VGND VPWR VGND sky130_ef_sc_hd__decap_12
XFILLER_77_85 VGND VGND VPWR VPWR sky130_fd_sc_hd__decap_8
XFILLER_65_505 VGND VGND VPWR VPWR sky130_fd_sc_hd__decap_8
XFILLER_77_387 VGND VGND VPWR VPWR sky130_fd_sc_hd__decap_4
XFILLER_18_421 VPWR VGND VPWR VGND sky130_ef_sc_hd__decap_12
XFILLER_18_454 VPWR VGND VPWR VGND sky130_ef_sc_hd__decap_12
XFILLER_60_287 VGND VGND VPWR VPWR sky130_fd_sc_hd__decap_3
XTAP_TAPCELL_ROW_31_625 VGND VPWR sky130_fd_sc_hd__tapvpwrvgnd_1
Xclkbuf_leaf_40_clk clknet_3_3__leaf_clk VGND VGND VPWR VPWR clknet_leaf_40_clk sky130_fd_sc_hd__clkbuf_8
XFILLER_13_181 VGND VGND VPWR VPWR sky130_fd_sc_hd__decap_4
X_6370_ _1893_ _1840_ _1892_ VGND VGND VPWR VPWR _1895_ sky130_fd_sc_hd__o21a_1
XTAP_TAPCELL_ROW_11_382 VGND VPWR sky130_fd_sc_hd__tapvpwrvgnd_1
X_5321_ _1052_ _1053_ VGND VGND VPWR VPWR _1054_ sky130_fd_sc_hd__nor2_1
XFILLER_88_608 VGND VGND VPWR VPWR sky130_fd_sc_hd__decap_4
X_8040_ _3369_ _3377_ _3376_ VGND VGND VPWR VPWR _3433_ sky130_fd_sc_hd__a21o_1
X_5252_ pe_array\[3\].u_pe.accum_reg\[24\] net296 net437 VGND VGND VPWR VPWR _0987_
+ sky130_fd_sc_hd__and3_1
X_5183_ _0920_ _0890_ VGND VGND VPWR VPWR _0921_ sky130_fd_sc_hd__xnor2_4
XFILLER_68_365 VGND VGND VPWR VPWR sky130_fd_sc_hd__decap_8
XFILLER_68_376 VGND VGND VPWR VPWR sky130_fd_sc_hd__decap_8
XTAP_TAPCELL_ROW_39_725 VGND VPWR sky130_fd_sc_hd__tapvpwrvgnd_1
XFILLER_113_39 VPWR VGND VPWR VGND sky130_ef_sc_hd__decap_12
XFILLER_83_346 VGND VGND VPWR VPWR sky130_fd_sc_hd__decap_6
XFILLER_83_335 VGND VGND VPWR VPWR sky130_fd_sc_hd__fill_1
X_8942_ clknet_leaf_61_clk _0054_ VGND VGND VPWR VPWR pe_accum\[3\]\[10\] sky130_fd_sc_hd__dfxtp_1
X_8873_ net916 net212 _4217_ net384 VGND VGND VPWR VPWR _0426_ sky130_fd_sc_hd__o211a_1
XTAP_TAPCELL_ROW_104_1506 VGND VPWR sky130_fd_sc_hd__tapvpwrvgnd_1
X_7824_ pe_array\[2\].u_pe.accum_reg\[1\] _3221_ _3223_ VGND VGND VPWR VPWR _3224_
+ sky130_fd_sc_hd__and3_1
XTAP_TAPCELL_ROW_19_482 VGND VPWR sky130_fd_sc_hd__tapvpwrvgnd_1
XFILLER_51_265 VGND VGND VPWR VPWR sky130_fd_sc_hd__fill_1
X_7755_ _2657_ net223 VGND VGND VPWR VPWR _3187_ sky130_fd_sc_hd__nand2_2
X_4967_ _0709_ _0710_ net686 VGND VGND VPWR VPWR _0712_ sky130_fd_sc_hd__nand3b_1
X_6706_ net904 net237 _1841_ net245 VGND VGND VPWR VPWR _0276_ sky130_fd_sc_hd__o2bb2ai_1
Xclkbuf_leaf_31_clk clknet_3_6__leaf_clk VGND VGND VPWR VPWR clknet_leaf_31_clk sky130_fd_sc_hd__clkbuf_8
X_7686_ _3102_ _3099_ VGND VGND VPWR VPWR _3134_ sky130_fd_sc_hd__nor2_4
X_4898_ net460 _0601_ _0603_ _0604_ VGND VGND VPWR VPWR _0644_ sky130_fd_sc_hd__a22o_1
X_6637_ _2150_ _2151_ VGND VGND VPWR VPWR _2153_ sky130_fd_sc_hd__and2b_1
X_6568_ _2057_ _2085_ VGND VGND VPWR VPWR _2086_ sky130_fd_sc_hd__nand2_1
XTAP_TAPCELL_ROW_115_1635 VGND VPWR sky130_fd_sc_hd__tapvpwrvgnd_1
XFILLER_98_29 VGND VGND VPWR VPWR sky130_fd_sc_hd__decap_8
X_8307_ net562 _3692_ _3653_ VGND VGND VPWR VPWR _3694_ sky130_fd_sc_hd__o21ai_1
X_5519_ net250 _1063_ VGND VGND VPWR VPWR _1220_ sky130_fd_sc_hd__nand2_2
X_9287_ clknet_leaf_9_clk _0399_ VGND VGND VPWR VPWR pe_array\[2\].u_pe.accum_reg\[29\]
+ sky130_fd_sc_hd__dfxtp_1
X_6499_ net198 _2018_ VGND VGND VPWR VPWR _2019_ sky130_fd_sc_hd__xnor2_1
XFILLER_105_278 VGND VGND VPWR VPWR sky130_fd_sc_hd__fill_2
X_8238_ _3624_ _3625_ VGND VGND VPWR VPWR _3626_ sky130_fd_sc_hd__or2_1
X_8169_ _3510_ _3512_ _3556_ _3557_ VGND VGND VPWR VPWR _3559_ sky130_fd_sc_hd__o211ai_1
XFILLER_59_321 VGND VGND VPWR VPWR sky130_fd_sc_hd__decap_4
Xfanout164 _3669_ VGND VGND VPWR VPWR net164 sky130_fd_sc_hd__clkbuf_2
XFILLER_47_505 VGND VGND VPWR VPWR sky130_fd_sc_hd__decap_3
XFILLER_101_462 VPWR VGND VPWR VGND sky130_ef_sc_hd__decap_12
Xfanout175 _1684_ VGND VGND VPWR VPWR net175 sky130_fd_sc_hd__buf_8
XFILLER_74_302 VGND VGND VPWR VPWR sky130_fd_sc_hd__fill_2
Xfanout197 _2542_ VGND VGND VPWR VPWR net197 sky130_fd_sc_hd__buf_6
Xfanout186 _0686_ VGND VGND VPWR VPWR net186 sky130_fd_sc_hd__buf_8
XFILLER_47_55 VGND VGND VPWR VPWR sky130_fd_sc_hd__fill_1
XFILLER_27_240 VGND VGND VPWR VPWR sky130_fd_sc_hd__decap_3
XFILLER_27_262 VGND VGND VPWR VPWR sky130_fd_sc_hd__decap_6
XFILLER_103_61 VGND VGND VPWR VPWR sky130_fd_sc_hd__decap_3
XFILLER_42_221 VGND VGND VPWR VPWR sky130_fd_sc_hd__fill_2
XFILLER_70_585 VGND VGND VPWR VPWR sky130_fd_sc_hd__decap_3
XFILLER_42_265 VGND VGND VPWR VPWR sky130_fd_sc_hd__fill_2
XFILLER_42_287 VGND VGND VPWR VPWR sky130_fd_sc_hd__fill_1
Xclkbuf_leaf_22_clk clknet_3_7__leaf_clk VGND VGND VPWR VPWR clknet_leaf_22_clk sky130_fd_sc_hd__clkbuf_8
XFILLER_11_641 VPWR VGND VPWR VGND sky130_ef_sc_hd__decap_12
XFILLER_8_27 VGND VGND VPWR VPWR sky130_fd_sc_hd__fill_1
XFILLER_10_173 VGND VGND VPWR VPWR sky130_fd_sc_hd__decap_4
XFILLER_109_595 VPWR VGND VPWR VGND sky130_ef_sc_hd__decap_12
XTAP_TAPCELL_ROW_90_1329 VGND VPWR sky130_fd_sc_hd__tapvpwrvgnd_1
XFILLER_2_350 VPWR VGND VPWR VGND sky130_ef_sc_hd__decap_12
XFILLER_97_449 VGND VGND VPWR VPWR sky130_fd_sc_hd__fill_2
XFILLER_97_427 VGND VGND VPWR VPWR sky130_fd_sc_hd__fill_1
XFILLER_93_622 VGND VGND VPWR VPWR sky130_fd_sc_hd__fill_2
XFILLER_65_302 VPWR VGND VPWR VGND sky130_ef_sc_hd__decap_12
XFILLER_93_644 VGND VGND VPWR VPWR sky130_fd_sc_hd__decap_8
XFILLER_77_195 VGND VGND VPWR VPWR sky130_fd_sc_hd__fill_1
XFILLER_92_165 VPWR VGND VPWR VGND sky130_ef_sc_hd__decap_12
XFILLER_80_305 VGND VGND VPWR VPWR sky130_fd_sc_hd__decap_3
X_5870_ _1407_ _1406_ VGND VGND VPWR VPWR _1408_ sky130_fd_sc_hd__nand2b_1
XFILLER_61_530 VGND VGND VPWR VPWR sky130_fd_sc_hd__decap_6
XFILLER_46_593 VGND VGND VPWR VPWR sky130_fd_sc_hd__fill_1
XTAP_TAPCELL_ROW_16_441 VGND VPWR sky130_fd_sc_hd__tapvpwrvgnd_1
X_4821_ net296 net434 pe_array\[3\].u_pe.accum_reg\[11\] VGND VGND VPWR VPWR _0569_
+ sky130_fd_sc_hd__a21oi_1
XFILLER_21_405 VGND VGND VPWR VPWR sky130_fd_sc_hd__decap_3
XTAP_TAPCELL_ROW_44_783 VGND VPWR sky130_fd_sc_hd__tapvpwrvgnd_1
Xclkbuf_leaf_13_clk clknet_3_5__leaf_clk VGND VGND VPWR VPWR clknet_leaf_13_clk sky130_fd_sc_hd__clkbuf_8
XFILLER_21_449 VPWR VGND VPWR VGND sky130_ef_sc_hd__decap_12
X_7540_ pe_array\[1\].u_pe.accum_reg\[25\] net550 net341 VGND VGND VPWR VPWR _2992_
+ sky130_fd_sc_hd__and3_1
X_4752_ _0498_ _0499_ _0501_ VGND VGND VPWR VPWR _0502_ sky130_fd_sc_hd__nor3_1
X_7471_ _2898_ _2924_ VGND VGND VPWR VPWR _2926_ sky130_fd_sc_hd__xnor2_2
X_4683_ _4435_ _4443_ VGND VGND VPWR VPWR _0434_ sky130_fd_sc_hd__nand2b_1
X_6422_ _1944_ VGND VGND VPWR VPWR _1945_ sky130_fd_sc_hd__inv_2
X_9210_ clknet_leaf_41_clk _0322_ VGND VGND VPWR VPWR pe_array\[1\].u_pe.accum_reg\[28\]
+ sky130_fd_sc_hd__dfxtp_1
X_9141_ clknet_leaf_21_clk _0253_ VGND VGND VPWR VPWR pe_array\[0\].u_pe.accum_reg\[27\]
+ sky130_fd_sc_hd__dfxtp_1
X_6353_ _1876_ _1877_ VGND VGND VPWR VPWR _1878_ sky130_fd_sc_hd__and2b_1
X_6284_ pe_array\[0\].u_pe.accum_reg\[18\] net455 net359 VGND VGND VPWR VPWR _1811_
+ sky130_fd_sc_hd__and3_4
XFILLER_0_309 VGND VGND VPWR VPWR sky130_fd_sc_hd__decap_8
X_9072_ clknet_leaf_52_clk _0184_ VGND VGND VPWR VPWR net147 sky130_fd_sc_hd__dfxtp_1
X_5304_ net399 pe_array\[3\].u_pe.accum_reg\[25\] _1037_ net257 VGND VGND VPWR VPWR
+ _1038_ sky130_fd_sc_hd__o2bb2a_4
XFILLER_102_215 VGND VGND VPWR VPWR sky130_fd_sc_hd__fill_1
X_8023_ _3413_ _3414_ VGND VGND VPWR VPWR _3416_ sky130_fd_sc_hd__xnor2_1
X_5235_ net179 _0970_ VGND VGND VPWR VPWR _0971_ sky130_fd_sc_hd__xor2_1
XFILLER_69_641 VPWR VGND VPWR VGND sky130_ef_sc_hd__decap_12
XTAP_TAPCELL_ROW_110_1576 VGND VPWR sky130_fd_sc_hd__tapvpwrvgnd_1
XFILLER_84_600 VPWR VGND VPWR VGND sky130_ef_sc_hd__decap_12
XFILLER_69_685 VGND VGND VPWR VPWR sky130_fd_sc_hd__decap_8
XFILLER_68_173 VGND VGND VPWR VPWR sky130_fd_sc_hd__decap_8
XPHY_EDGE_ROW_3_Left_121 VGND VGND VPWR VPWR sky130_fd_sc_hd__decap_3
X_5166_ net282 _0901_ _0902_ VGND VGND VPWR VPWR _0904_ sky130_fd_sc_hd__or3_1
XFILLER_83_132 VGND VGND VPWR VPWR sky130_fd_sc_hd__decap_8
XFILLER_83_110 VGND VGND VPWR VPWR sky130_fd_sc_hd__fill_2
XFILLER_56_346 VPWR VGND VPWR VGND sky130_ef_sc_hd__decap_12
X_5097_ _0834_ _0835_ VGND VGND VPWR VPWR _0838_ sky130_fd_sc_hd__xnor2_4
XFILLER_17_47 VGND VGND VPWR VPWR sky130_fd_sc_hd__decap_8
X_8925_ clknet_3_1__leaf_clk _0037_ VGND VGND VPWR VPWR pe_array\[3\].u_pe.accum_reg\[25\]
+ sky130_fd_sc_hd__dfxtp_1
XFILLER_44_519 VGND VGND VPWR VPWR sky130_fd_sc_hd__decap_4
XFILLER_17_69 VGND VGND VPWR VPWR sky130_fd_sc_hd__decap_4
X_8856_ net210 _3768_ VGND VGND VPWR VPWR _4209_ sky130_fd_sc_hd__nand2_2
XTAP_TAPCELL_ROW_65_1033 VGND VPWR sky130_fd_sc_hd__tapvpwrvgnd_1
X_8787_ pe_array\[2\].u_pe.accum_reg\[30\] _3509_ VGND VGND VPWR VPWR _4158_ sky130_fd_sc_hd__xnor2_1
X_7807_ net508 pe_array\[2\].u_pe.tap_count\[0\] net1027 VGND VGND VPWR VPWR _3211_
+ sky130_fd_sc_hd__a21oi_1
X_5999_ _1531_ _1532_ _1525_ VGND VGND VPWR VPWR _1534_ sky130_fd_sc_hd__a21o_1
X_7738_ net1023 net224 _3178_ net378 VGND VGND VPWR VPWR _0330_ sky130_fd_sc_hd__o211a_1
XFILLER_33_57 VPWR VGND VPWR VGND sky130_ef_sc_hd__decap_12
XPHY_EDGE_ROW_49_Left_167 VGND VGND VPWR VPWR sky130_fd_sc_hd__decap_3
X_7669_ _3082_ _3084_ _3115_ VGND VGND VPWR VPWR _3117_ sky130_fd_sc_hd__nor3_1
XFILLER_109_3 VPWR VGND VPWR VGND sky130_ef_sc_hd__decap_12
XFILLER_4_637 VGND VGND VPWR VPWR sky130_fd_sc_hd__decap_6
XFILLER_3_103 VGND VGND VPWR VPWR sky130_fd_sc_hd__fill_1
XTAP_TAPCELL_ROW_76_1162 VGND VPWR sky130_fd_sc_hd__tapvpwrvgnd_1
XFILLER_106_587 VGND VGND VPWR VPWR sky130_fd_sc_hd__fill_1
XFILLER_79_449 VPWR VGND VPWR VGND sky130_ef_sc_hd__decap_12
XFILLER_58_65 VPWR VGND VPWR VGND sky130_ef_sc_hd__decap_12
XPHY_EDGE_ROW_58_Left_176 VGND VGND VPWR VPWR sky130_fd_sc_hd__decap_3
XFILLER_101_281 VPWR VGND VPWR VGND sky130_ef_sc_hd__decap_12
XFILLER_75_633 VPWR VGND VPWR VGND sky130_ef_sc_hd__decap_12
XFILLER_75_677 VGND VGND VPWR VPWR sky130_fd_sc_hd__fill_1
XFILLER_74_165 VGND VGND VPWR VPWR sky130_fd_sc_hd__decap_8
XFILLER_74_42 VGND VGND VPWR VPWR sky130_fd_sc_hd__decap_4
XFILLER_28_582 VGND VGND VPWR VPWR sky130_fd_sc_hd__decap_6
XFILLER_43_530 VGND VGND VPWR VPWR sky130_fd_sc_hd__decap_8
XFILLER_15_287 VPWR VGND VPWR VGND sky130_ef_sc_hd__decap_12
XPHY_EDGE_ROW_67_Left_185 VGND VGND VPWR VPWR sky130_fd_sc_hd__decap_3
XTAP_TAPCELL_ROW_13_411 VGND VPWR sky130_fd_sc_hd__tapvpwrvgnd_1
XFILLER_30_246 VGND VGND VPWR VPWR sky130_fd_sc_hd__decap_6
XTAP_TAPCELL_ROW_41_742 VGND VPWR sky130_fd_sc_hd__tapvpwrvgnd_1
Xhold409 pe_accum\[0\]\[17\] VGND VGND VPWR VPWR net924 sky130_fd_sc_hd__dlygate4sd3_1
XFILLER_109_370 VGND VGND VPWR VPWR sky130_fd_sc_hd__decap_3
XFILLER_97_213 VGND VGND VPWR VPWR sky130_fd_sc_hd__decap_8
XPHY_EDGE_ROW_76_Left_194 VGND VGND VPWR VPWR sky130_fd_sc_hd__decap_3
X_5020_ net184 _0761_ _0762_ VGND VGND VPWR VPWR _0763_ sky130_fd_sc_hd__or3_1
XFILLER_97_279 VGND VGND VPWR VPWR sky130_fd_sc_hd__fill_1
Xclkbuf_leaf_2_clk clknet_3_4__leaf_clk VGND VGND VPWR VPWR clknet_leaf_2_clk sky130_fd_sc_hd__clkbuf_8
XFILLER_24_3 VPWR VGND VPWR VGND sky130_ef_sc_hd__decap_12
Xclone230 net208 VGND VGND VPWR VPWR net745 sky130_fd_sc_hd__clkbuf_1
XTAP_TAPCELL_ROW_49_842 VGND VPWR sky130_fd_sc_hd__tapvpwrvgnd_1
XFILLER_81_614 VGND VGND VPWR VPWR sky130_fd_sc_hd__fill_2
X_8710_ _4063_ _4082_ VGND VGND VPWR VPWR _4084_ sky130_fd_sc_hd__xnor2_1
XFILLER_65_198 VGND VGND VPWR VPWR sky130_fd_sc_hd__decap_4
XFILLER_19_593 VGND VGND VPWR VPWR sky130_fd_sc_hd__decap_6
X_6971_ _2438_ _2439_ VGND VGND VPWR VPWR _2440_ sky130_fd_sc_hd__nand2_1
XFILLER_80_135 VGND VGND VPWR VPWR sky130_fd_sc_hd__decap_4
X_5922_ _1420_ _1458_ VGND VGND VPWR VPWR _1459_ sky130_fd_sc_hd__xnor2_1
XFILLER_110_29 VPWR VGND VPWR VGND sky130_ef_sc_hd__decap_12
X_8641_ _4014_ _4015_ _3984_ _3986_ VGND VGND VPWR VPWR _4017_ sky130_fd_sc_hd__a211oi_1
X_5853_ _1389_ _1390_ VGND VGND VPWR VPWR _1391_ sky130_fd_sc_hd__nor2_1
X_8572_ net573 _3948_ _3949_ VGND VGND VPWR VPWR _3950_ sky130_fd_sc_hd__nor3_1
X_5784_ _1321_ _1322_ net480 net355 VGND VGND VPWR VPWR _1324_ sky130_fd_sc_hd__or4bb_4
X_4804_ _0547_ _0552_ VGND VGND VPWR VPWR _0553_ sky130_fd_sc_hd__xnor2_1
X_7523_ _2973_ _2974_ VGND VGND VPWR VPWR _2976_ sky130_fd_sc_hd__xnor2_1
X_4735_ net287 _0483_ _0484_ VGND VGND VPWR VPWR _0485_ sky130_fd_sc_hd__nor3_2
X_7454_ _2881_ _2882_ _2907_ _2908_ VGND VGND VPWR VPWR _2909_ sky130_fd_sc_hd__o211ai_1
X_4666_ _4350_ _4386_ _4351_ _4385_ _4349_ VGND VGND VPWR VPWR _4428_ sky130_fd_sc_hd__o32a_4
XFILLER_107_329 VGND VGND VPWR VPWR sky130_fd_sc_hd__decap_6
X_6405_ _1925_ _1926_ _1899_ _1900_ VGND VGND VPWR VPWR _1928_ sky130_fd_sc_hd__a211o_1
X_7385_ _2840_ _2841_ _2842_ VGND VGND VPWR VPWR _2843_ sky130_fd_sc_hd__nand3_2
X_4597_ _4354_ _4355_ _4358_ VGND VGND VPWR VPWR _4360_ sky130_fd_sc_hd__and3_1
X_6336_ net171 _1828_ _1827_ VGND VGND VPWR VPWR _1862_ sky130_fd_sc_hd__a21bo_1
X_9124_ clknet_3_7__leaf_clk _0236_ VGND VGND VPWR VPWR pe_array\[0\].u_pe.accum_reg\[10\]
+ sky130_fd_sc_hd__dfxtp_1
XFILLER_115_362 VGND VGND VPWR VPWR sky130_fd_sc_hd__decap_3
X_9055_ clknet_leaf_5_clk _0167_ VGND VGND VPWR VPWR net129 sky130_fd_sc_hd__dfxtp_1
XFILLER_1_629 VPWR VGND VPWR VGND sky130_ef_sc_hd__decap_12
XFILLER_103_557 VGND VGND VPWR VPWR sky130_fd_sc_hd__decap_3
X_6267_ _1792_ _1793_ net173 VGND VGND VPWR VPWR _1795_ sky130_fd_sc_hd__o21ai_1
XFILLER_76_408 VGND VGND VPWR VPWR sky130_fd_sc_hd__fill_1
X_8006_ _3315_ _3356_ _3398_ VGND VGND VPWR VPWR _3400_ sky130_fd_sc_hd__o21bai_1
X_6198_ _1725_ _1726_ net200 VGND VGND VPWR VPWR _1728_ sky130_fd_sc_hd__a21o_1
X_5218_ net296 net434 pe_array\[3\].u_pe.accum_reg\[23\] VGND VGND VPWR VPWR _0954_
+ sky130_fd_sc_hd__a21oi_1
XFILLER_57_633 VPWR VGND VPWR VGND sky130_ef_sc_hd__decap_12
X_5149_ _0887_ net178 VGND VGND VPWR VPWR _0888_ sky130_fd_sc_hd__xor2_2
XFILLER_28_57 VGND VGND VPWR VPWR sky130_fd_sc_hd__fill_2
XFILLER_29_357 VGND VGND VPWR VPWR sky130_fd_sc_hd__fill_1
XFILLER_29_368 VGND VGND VPWR VPWR sky130_fd_sc_hd__decap_3
XFILLER_44_305 VGND VGND VPWR VPWR sky130_fd_sc_hd__decap_3
XFILLER_72_625 VPWR VGND VPWR VGND sky130_ef_sc_hd__decap_12
XFILLER_44_316 VGND VGND VPWR VPWR sky130_fd_sc_hd__fill_1
X_8908_ clknet_leaf_55_clk _0020_ VGND VGND VPWR VPWR pe_array\[3\].u_pe.accum_reg\[8\]
+ sky130_fd_sc_hd__dfxtp_1
X_8839_ net950 net213 _4200_ net385 VGND VGND VPWR VPWR _0409_ sky130_fd_sc_hd__o211a_1
XFILLER_52_360 VGND VGND VPWR VPWR sky130_fd_sc_hd__decap_4
XFILLER_25_574 VGND VGND VPWR VPWR sky130_fd_sc_hd__decap_3
XFILLER_100_40 VGND VGND VPWR VPWR sky130_fd_sc_hd__decap_6
XFILLER_40_533 VGND VGND VPWR VPWR sky130_fd_sc_hd__fill_1
XFILLER_12_246 VGND VGND VPWR VPWR sky130_fd_sc_hd__decap_6
XFILLER_60_77 VGND VGND VPWR VPWR sky130_fd_sc_hd__decap_6
XFILLER_5_39 VPWR VGND VPWR VGND sky130_ef_sc_hd__decap_12
XFILLER_4_445 VPWR VGND VPWR VGND sky130_ef_sc_hd__decap_12
XFILLER_109_93 VGND VGND VPWR VPWR sky130_fd_sc_hd__fill_1
XFILLER_106_373 VGND VGND VPWR VPWR sky130_fd_sc_hd__fill_1
XFILLER_69_86 VGND VGND VPWR VPWR sky130_fd_sc_hd__fill_1
XFILLER_0_673 VPWR VGND VPWR VGND sky130_ef_sc_hd__decap_12
XTAP_TAPCELL_ROW_89_1320 VGND VPWR sky130_fd_sc_hd__tapvpwrvgnd_1
XFILLER_85_52 VGND VGND VPWR VPWR sky130_fd_sc_hd__decap_4
XTAP_TAPCELL_ROW_46_801 VGND VPWR sky130_fd_sc_hd__tapvpwrvgnd_1
XFILLER_90_400 VGND VGND VPWR VPWR sky130_fd_sc_hd__decap_3
XFILLER_16_530 VGND VGND VPWR VPWR sky130_fd_sc_hd__fill_2
XFILLER_70_190 VGND VGND VPWR VPWR sky130_fd_sc_hd__decap_6
XFILLER_43_393 VGND VGND VPWR VPWR sky130_fd_sc_hd__decap_4
XFILLER_31_588 VPWR VGND VPWR VGND sky130_ef_sc_hd__decap_12
X_4520_ _4284_ _4285_ VGND VGND VPWR VPWR _4286_ sky130_fd_sc_hd__nor2_1
X_4451_ pe_array\[0\].u_pe.weight_in\[7\] VGND VGND VPWR VPWR _4232_ sky130_fd_sc_hd__inv_2
X_7170_ net268 _2631_ _2632_ VGND VGND VPWR VPWR _2634_ sky130_fd_sc_hd__or3_1
XFILLER_98_533 VGND VGND VPWR VPWR sky130_fd_sc_hd__fill_2
XPHY_EDGE_ROW_84_Left_202 VGND VGND VPWR VPWR sky130_fd_sc_hd__decap_3
X_6121_ _1649_ _1650_ net277 VGND VGND VPWR VPWR _1653_ sky130_fd_sc_hd__o21ai_1
XFILLER_112_321 VPWR VGND VPWR VGND sky130_ef_sc_hd__decap_12
XFILLER_112_365 VGND VGND VPWR VPWR sky130_fd_sc_hd__decap_4
X_6052_ _1517_ _1519_ _1584_ _1585_ VGND VGND VPWR VPWR _1586_ sky130_fd_sc_hd__a211oi_2
XFILLER_58_419 VGND VGND VPWR VPWR sky130_fd_sc_hd__fill_1
XPHY_EDGE_ROW_7_Right_7 VGND VGND VPWR VPWR sky130_fd_sc_hd__decap_3
XFILLER_100_538 VPWR VGND VPWR VGND sky130_ef_sc_hd__decap_12
X_5003_ _0715_ _0713_ _0712_ VGND VGND VPWR VPWR _0747_ sky130_fd_sc_hd__a21bo_1
XFILLER_66_474 VGND VGND VPWR VPWR sky130_fd_sc_hd__fill_2
XFILLER_26_305 VGND VGND VPWR VPWR sky130_fd_sc_hd__decap_3
XFILLER_39_699 VGND VGND VPWR VPWR sky130_fd_sc_hd__fill_1
XPHY_EDGE_ROW_93_Left_211 VGND VGND VPWR VPWR sky130_fd_sc_hd__decap_3
XFILLER_53_157 VGND VGND VPWR VPWR sky130_fd_sc_hd__decap_4
X_6954_ _2420_ _2421_ _2412_ VGND VGND VPWR VPWR _2423_ sky130_fd_sc_hd__a21o_1
X_5905_ net274 _1439_ _1440_ VGND VGND VPWR VPWR _1442_ sky130_fd_sc_hd__or3_1
XTAP_TAPCELL_ROW_62_1003 VGND VPWR sky130_fd_sc_hd__tapvpwrvgnd_1
X_8624_ net155 _4000_ VGND VGND VPWR VPWR _4001_ sky130_fd_sc_hd__xnor2_1
X_6885_ net494 net331 _2327_ _2326_ VGND VGND VPWR VPWR _2355_ sky130_fd_sc_hd__a31o_1
XFILLER_14_15 VGND VGND VPWR VPWR sky130_fd_sc_hd__decap_8
XFILLER_22_533 VGND VGND VPWR VPWR sky130_fd_sc_hd__fill_1
XTAP_TAPCELL_ROW_24_539 VGND VPWR sky130_fd_sc_hd__tapvpwrvgnd_1
X_5836_ _1338_ _1374_ VGND VGND VPWR VPWR _1375_ sky130_fd_sc_hd__or2_1
XFILLER_22_566 VGND VGND VPWR VPWR sky130_fd_sc_hd__decap_4
X_8555_ _3931_ _3932_ _3933_ VGND VGND VPWR VPWR _3934_ sky130_fd_sc_hd__and3_1
X_5767_ _1306_ _1307_ VGND VGND VPWR VPWR _1308_ sky130_fd_sc_hd__nand2_1
XFILLER_108_627 VGND VGND VPWR VPWR sky130_fd_sc_hd__fill_1
X_5698_ _1241_ _1242_ VGND VGND VPWR VPWR _1243_ sky130_fd_sc_hd__nor2_1
X_8486_ _3863_ _3864_ _3865_ VGND VGND VPWR VPWR _3867_ sky130_fd_sc_hd__a21o_1
X_7506_ _2872_ _2900_ _2926_ _2955_ VGND VGND VPWR VPWR _2959_ sky130_fd_sc_hd__or4_4
X_4718_ _0462_ _0463_ _0465_ VGND VGND VPWR VPWR _0468_ sky130_fd_sc_hd__a21oi_1
Xrebuffer358 net475 VGND VGND VPWR VPWR net873 sky130_fd_sc_hd__dlygate4sd1_1
X_7437_ _2700_ _2862_ _2861_ VGND VGND VPWR VPWR _2893_ sky130_fd_sc_hd__a21oi_1
X_4649_ _4403_ _4409_ _4410_ VGND VGND VPWR VPWR _4411_ sky130_fd_sc_hd__nand3_1
XFILLER_30_58 VGND VGND VPWR VPWR sky130_fd_sc_hd__fill_1
XFILLER_116_693 VGND VGND VPWR VPWR sky130_fd_sc_hd__decap_6
XTAP_TAPCELL_ROW_73_1132 VGND VPWR sky130_fd_sc_hd__tapvpwrvgnd_1
X_7368_ net267 _2823_ _2824_ VGND VGND VPWR VPWR _2826_ sky130_fd_sc_hd__or3_4
X_6319_ net279 _1843_ _1844_ VGND VGND VPWR VPWR _1845_ sky130_fd_sc_hd__nor3_1
XFILLER_89_533 VGND VGND VPWR VPWR sky130_fd_sc_hd__decap_6
X_9107_ clknet_leaf_0_clk _0219_ VGND VGND VPWR VPWR pe_array\[2\].u_pe.weight_in\[5\]
+ sky130_fd_sc_hd__dfxtp_1
X_7299_ _2612_ _2654_ _2691_ _2727_ VGND VGND VPWR VPWR _2760_ sky130_fd_sc_hd__and4bb_1
X_9038_ clknet_leaf_11_clk _0150_ VGND VGND VPWR VPWR net110 sky130_fd_sc_hd__dfxtp_1
XFILLER_76_205 VGND VGND VPWR VPWR sky130_fd_sc_hd__decap_3
XFILLER_57_496 VGND VGND VPWR VPWR sky130_fd_sc_hd__decap_8
XTAP_TAPCELL_ROW_4_297 VGND VPWR sky130_fd_sc_hd__tapvpwrvgnd_1
XFILLER_17_327 VGND VGND VPWR VPWR sky130_fd_sc_hd__decap_8
XFILLER_72_433 VGND VGND VPWR VPWR sky130_fd_sc_hd__decap_4
XFILLER_55_55 VGND VGND VPWR VPWR sky130_fd_sc_hd__fill_1
XFILLER_17_349 VPWR VGND VPWR VGND sky130_ef_sc_hd__decap_12
XTAP_TAPCELL_ROW_84_1261 VGND VPWR sky130_fd_sc_hd__tapvpwrvgnd_1
XFILLER_44_157 VGND VGND VPWR VPWR sky130_fd_sc_hd__fill_1
XFILLER_25_393 VPWR VGND VPWR VGND sky130_ef_sc_hd__decap_12
XFILLER_71_65 VGND VGND VPWR VPWR sky130_fd_sc_hd__fill_2
XTAP_TAPCELL_ROW_51_870 VGND VPWR sky130_fd_sc_hd__tapvpwrvgnd_1
XFILLER_9_537 VGND VGND VPWR VPWR sky130_fd_sc_hd__fill_2
XTAP_TAPCELL_ROW_95_1390 VGND VPWR sky130_fd_sc_hd__tapvpwrvgnd_1
XFILLER_4_253 VGND VGND VPWR VPWR sky130_fd_sc_hd__decap_4
XFILLER_107_693 VGND VGND VPWR VPWR sky130_fd_sc_hd__decap_3
XFILLER_67_238 VGND VGND VPWR VPWR sky130_fd_sc_hd__fill_1
XFILLER_48_430 VGND VGND VPWR VPWR sky130_fd_sc_hd__fill_1
XFILLER_36_625 VGND VGND VPWR VPWR sky130_fd_sc_hd__fill_1
XFILLER_63_444 VGND VGND VPWR VPWR sky130_fd_sc_hd__decap_4
XFILLER_23_319 VGND VGND VPWR VPWR sky130_fd_sc_hd__decap_6
X_6670_ _2183_ _2161_ VGND VGND VPWR VPWR _2185_ sky130_fd_sc_hd__xor2_2
XTAP_TAPCELL_ROW_21_509 VGND VPWR sky130_fd_sc_hd__tapvpwrvgnd_1
XFILLER_31_330 VGND VGND VPWR VPWR sky130_fd_sc_hd__fill_1
X_5621_ net1019 net382 VGND VGND VPWR VPWR _0162_ sky130_fd_sc_hd__and2_1
XFILLER_31_363 VGND VGND VPWR VPWR sky130_fd_sc_hd__fill_1
X_5552_ net959 net393 VGND VGND VPWR VPWR _0093_ sky130_fd_sc_hd__and2_1
X_8340_ _3724_ _3725_ net562 VGND VGND VPWR VPWR _3726_ sky130_fd_sc_hd__a21o_1
X_8271_ _3621_ _3617_ _3615_ VGND VGND VPWR VPWR _3659_ sky130_fd_sc_hd__a21bo_1
XFILLER_8_581 VGND VGND VPWR VPWR sky130_fd_sc_hd__decap_6
X_4503_ _4267_ _4268_ _4269_ VGND VGND VPWR VPWR _4270_ sky130_fd_sc_hd__and3_1
X_5483_ net253 _0466_ VGND VGND VPWR VPWR _1202_ sky130_fd_sc_hd__nand2_1
XFILLER_6_82 VGND VGND VPWR VPWR sky130_fd_sc_hd__fill_2
X_7222_ _2660_ _2683_ _2684_ VGND VGND VPWR VPWR _2685_ sky130_fd_sc_hd__or3_1
XFILLER_113_641 VPWR VGND VPWR VGND sky130_ef_sc_hd__decap_12
Xfanout505 net506 VGND VGND VPWR VPWR net505 sky130_fd_sc_hd__dlymetal6s2s_1
X_7153_ _2612_ net768 _2616_ VGND VGND VPWR VPWR _2618_ sky130_fd_sc_hd__and3_1
XFILLER_113_685 VPWR VGND VPWR VGND sky130_ef_sc_hd__decap_12
XFILLER_112_151 VGND VGND VPWR VPWR sky130_fd_sc_hd__decap_8
XFILLER_98_363 VGND VGND VPWR VPWR sky130_fd_sc_hd__fill_1
XFILLER_86_503 VGND VGND VPWR VPWR sky130_fd_sc_hd__decap_6
X_6104_ _1597_ _1635_ VGND VGND VPWR VPWR _1637_ sky130_fd_sc_hd__xnor2_1
X_7084_ _2503_ _2505_ _2547_ _2548_ VGND VGND VPWR VPWR _2550_ sky130_fd_sc_hd__o211ai_1
XFILLER_98_396 VGND VGND VPWR VPWR sky130_fd_sc_hd__fill_1
X_6035_ net455 net361 pe_array\[0\].u_pe.accum_reg\[11\] VGND VGND VPWR VPWR _1569_
+ sky130_fd_sc_hd__a21oi_1
XFILLER_39_430 VGND VGND VPWR VPWR sky130_fd_sc_hd__decap_4
XFILLER_66_260 VGND VGND VPWR VPWR sky130_fd_sc_hd__decap_6
Xrebuffer10 net449 VGND VGND VPWR VPWR net525 sky130_fd_sc_hd__clkbuf_2
Xrebuffer21 _4370_ VGND VGND VPWR VPWR net536 sky130_fd_sc_hd__dlymetal6s2s_1
XFILLER_39_496 VGND VGND VPWR VPWR sky130_fd_sc_hd__fill_1
XTAP_TAPCELL_ROW_107_1537 VGND VPWR sky130_fd_sc_hd__tapvpwrvgnd_1
XTAP_TAPCELL_ROW_1_267 VGND VPWR sky130_fd_sc_hd__tapvpwrvgnd_1
XFILLER_26_135 VGND VGND VPWR VPWR sky130_fd_sc_hd__decap_4
Xrebuffer32 _2509_ VGND VGND VPWR VPWR net547 sky130_fd_sc_hd__buf_1
Xrebuffer43 net451 VGND VGND VPWR VPWR net558 sky130_fd_sc_hd__dlygate4sd1_1
X_7986_ _3365_ _3379_ VGND VGND VPWR VPWR _3380_ sky130_fd_sc_hd__and2_1
Xrebuffer65 net503 VGND VGND VPWR VPWR net580 sky130_fd_sc_hd__dlygate4sd1_1
Xrebuffer87 net639 VGND VGND VPWR VPWR net602 sky130_fd_sc_hd__buf_6
XFILLER_26_157 VGND VGND VPWR VPWR sky130_fd_sc_hd__fill_2
Xrebuffer98 _1502_ VGND VGND VPWR VPWR net613 sky130_fd_sc_hd__buf_1
XFILLER_25_69 VPWR VGND VPWR VGND sky130_ef_sc_hd__decap_12
XTAP_TAPCELL_ROW_37_697 VGND VPWR sky130_fd_sc_hd__tapvpwrvgnd_1
X_6937_ _2397_ _2405_ VGND VGND VPWR VPWR _2406_ sky130_fd_sc_hd__nand2b_1
X_6868_ _2298_ _2291_ _2297_ VGND VGND VPWR VPWR _2339_ sky130_fd_sc_hd__a21bo_1
X_8607_ pe_array\[2\].u_pe.accum_reg\[24\] net442 net316 VGND VGND VPWR VPWR _3984_
+ sky130_fd_sc_hd__and3_1
X_5819_ net467 net358 pe_array\[0\].u_pe.accum_reg\[6\] VGND VGND VPWR VPWR _1358_
+ sky130_fd_sc_hd__a21oi_1
X_8538_ net420 _3917_ VGND VGND VPWR VPWR _0391_ sky130_fd_sc_hd__nor2_1
Xrebuffer100 net640 VGND VGND VPWR VPWR net615 sky130_fd_sc_hd__buf_6
X_6799_ _2244_ _2248_ _2243_ VGND VGND VPWR VPWR _2272_ sky130_fd_sc_hd__a21o_1
XFILLER_6_507 VGND VGND VPWR VPWR sky130_fd_sc_hd__fill_1
Xrebuffer111 _3039_ VGND VGND VPWR VPWR net626 sky130_fd_sc_hd__buf_1
XFILLER_41_57 VPWR VGND VPWR VGND sky130_ef_sc_hd__decap_12
Xrebuffer144 _1852_ VGND VGND VPWR VPWR net659 sky130_fd_sc_hd__dlymetal6s4s_1
X_8469_ _3819_ _3849_ VGND VGND VPWR VPWR _3851_ sky130_fd_sc_hd__xor2_1
Xrebuffer166 _3572_ VGND VGND VPWR VPWR net681 sky130_fd_sc_hd__buf_6
Xrebuffer177 _0745_ VGND VGND VPWR VPWR net692 sky130_fd_sc_hd__buf_6
XTAP_TAPCELL_ROW_9_367 VGND VPWR sky130_fd_sc_hd__tapvpwrvgnd_1
XTAP_TAPCELL_ROW_9_356 VGND VPWR sky130_fd_sc_hd__tapvpwrvgnd_1
XFILLER_77_503 VGND VGND VPWR VPWR sky130_fd_sc_hd__fill_1
XFILLER_77_525 VGND VGND VPWR VPWR sky130_fd_sc_hd__fill_2
XFILLER_1_278 VGND VGND VPWR VPWR sky130_fd_sc_hd__fill_2
XFILLER_2_29 VPWR VGND VPWR VGND sky130_ef_sc_hd__decap_12
XFILLER_106_83 VGND VGND VPWR VPWR sky130_fd_sc_hd__fill_1
XFILLER_92_528 VGND VGND VPWR VPWR sky130_fd_sc_hd__decap_4
XFILLER_64_219 VGND VGND VPWR VPWR sky130_fd_sc_hd__decap_8
XFILLER_17_113 VPWR VGND VPWR VGND sky130_ef_sc_hd__decap_12
XFILLER_33_606 VGND VGND VPWR VPWR sky130_fd_sc_hd__fill_1
XFILLER_32_127 VPWR VGND VPWR VGND sky130_ef_sc_hd__decap_12
XFILLER_9_334 VGND VGND VPWR VPWR sky130_fd_sc_hd__fill_2
Xoutput119 net119 VGND VGND VPWR VPWR result_data[72] sky130_fd_sc_hd__buf_2
Xoutput108 net108 VGND VGND VPWR VPWR result_data[62] sky130_fd_sc_hd__buf_2
XFILLER_99_127 VPWR VGND VPWR VGND sky130_ef_sc_hd__decap_12
XFILLER_110_600 VPWR VGND VPWR VGND sky130_ef_sc_hd__decap_12
XFILLER_95_333 VGND VGND VPWR VPWR sky130_fd_sc_hd__decap_3
XFILLER_95_300 VGND VGND VPWR VPWR sky130_fd_sc_hd__decap_4
Xoutput90 net90 VGND VGND VPWR VPWR result_data[46] sky130_fd_sc_hd__buf_2
X_7840_ _3238_ VGND VGND VPWR VPWR _3239_ sky130_fd_sc_hd__inv_2
XFILLER_51_447 VGND VGND VPWR VPWR sky130_fd_sc_hd__fill_1
XFILLER_51_436 VGND VGND VPWR VPWR sky130_fd_sc_hd__decap_3
X_7771_ net222 _2902_ VGND VGND VPWR VPWR _3195_ sky130_fd_sc_hd__nand2_1
X_4983_ _0723_ _0724_ _0690_ _0691_ VGND VGND VPWR VPWR _0727_ sky130_fd_sc_hd__a211o_1
X_6722_ net507 _2202_ VGND VGND VPWR VPWR _2203_ sky130_fd_sc_hd__nand2_2
XTAP_TAPCELL_ROW_34_656 VGND VPWR sky130_fd_sc_hd__tapvpwrvgnd_1
XTAP_TAPCELL_ROW_34_667 VGND VPWR sky130_fd_sc_hd__tapvpwrvgnd_1
XTAP_TAPCELL_ROW_102_1478 VGND VPWR sky130_fd_sc_hd__tapvpwrvgnd_1
X_6653_ net642 _2165_ _2166_ VGND VGND VPWR VPWR _2168_ sky130_fd_sc_hd__and3_1
XTAP_TAPCELL_ROW_62_998 VGND VPWR sky130_fd_sc_hd__tapvpwrvgnd_1
XFILLER_31_182 VGND VGND VPWR VPWR sky130_fd_sc_hd__decap_4
X_5604_ net1008 net376 VGND VGND VPWR VPWR _0145_ sky130_fd_sc_hd__and2_1
XFILLER_117_210 VGND VGND VPWR VPWR sky130_fd_sc_hd__decap_3
X_6584_ _2098_ _2099_ net276 VGND VGND VPWR VPWR _2101_ sky130_fd_sc_hd__o21a_1
X_8323_ _3672_ _3673_ _3706_ _3707_ VGND VGND VPWR VPWR _3709_ sky130_fd_sc_hd__o211ai_1
X_5535_ net14 _1226_ _1227_ net336 VGND VGND VPWR VPWR _0078_ sky130_fd_sc_hd__a22o_1
XFILLER_11_27 VPWR VGND VPWR VGND sky130_ef_sc_hd__decap_12
XFILLER_117_287 VGND VGND VPWR VPWR sky130_fd_sc_hd__decap_3
X_8254_ net187 _3639_ _3641_ VGND VGND VPWR VPWR _3642_ sky130_fd_sc_hd__or3b_1
X_5466_ net417 _1193_ VGND VGND VPWR VPWR _0043_ sky130_fd_sc_hd__nor2_1
X_7205_ pe_array\[1\].u_pe.accum_reg\[14\] net446 net338 VGND VGND VPWR VPWR _2668_
+ sky130_fd_sc_hd__and3_1
X_8185_ _3528_ net681 _3573_ VGND VGND VPWR VPWR _3575_ sky130_fd_sc_hd__and3_4
Xfanout313 net314 VGND VGND VPWR VPWR net313 sky130_fd_sc_hd__clkbuf_2
XTAP_TAPCELL_ROW_6_326 VGND VPWR sky130_fd_sc_hd__tapvpwrvgnd_1
X_5397_ pe_array\[3\].u_pe.accum_reg\[29\] _0520_ VGND VGND VPWR VPWR _1127_ sky130_fd_sc_hd__nor2_1
Xfanout302 net303 VGND VGND VPWR VPWR net302 sky130_fd_sc_hd__buf_2
Xfanout357 net362 VGND VGND VPWR VPWR net357 sky130_fd_sc_hd__clkbuf_2
Xfanout346 pe_array\[0\].u_pe.weight_in\[5\] VGND VGND VPWR VPWR net346 sky130_fd_sc_hd__clkbuf_4
Xfanout324 net325 VGND VGND VPWR VPWR net324 sky130_fd_sc_hd__buf_2
Xfanout335 pe_array\[1\].u_pe.weight_in\[2\] VGND VGND VPWR VPWR net335 sky130_fd_sc_hd__buf_2
X_7136_ _2597_ _2598_ _2585_ VGND VGND VPWR VPWR _2601_ sky130_fd_sc_hd__a21oi_1
XFILLER_59_558 VGND VGND VPWR VPWR sky130_fd_sc_hd__fill_2
Xfanout379 net396 VGND VGND VPWR VPWR net379 sky130_fd_sc_hd__clkbuf_2
Xfanout368 net369 VGND VGND VPWR VPWR net368 sky130_fd_sc_hd__buf_1
XPHY_EDGE_ROW_21_Left_139 VGND VGND VPWR VPWR sky130_fd_sc_hd__decap_3
X_7067_ net464 net328 net326 net472 VGND VGND VPWR VPWR _2533_ sky130_fd_sc_hd__a22oi_1
XFILLER_86_388 VGND VGND VPWR VPWR sky130_fd_sc_hd__fill_1
X_6018_ _1550_ net151 VGND VGND VPWR VPWR _1553_ sky130_fd_sc_hd__xnor2_2
XFILLER_27_444 VGND VGND VPWR VPWR sky130_fd_sc_hd__decap_4
XFILLER_39_293 VGND VGND VPWR VPWR sky130_fd_sc_hd__decap_6
XTAP_TAPCELL_ROW_68_1064 VGND VPWR sky130_fd_sc_hd__tapvpwrvgnd_1
XFILLER_15_617 VPWR VGND VPWR VGND sky130_ef_sc_hd__decap_12
X_7969_ _3308_ _3354_ _3353_ VGND VGND VPWR VPWR _3363_ sky130_fd_sc_hd__a21oi_1
XTAP_TAPCELL_ROW_68_1075 VGND VPWR sky130_fd_sc_hd__tapvpwrvgnd_1
XFILLER_42_425 VGND VGND VPWR VPWR sky130_fd_sc_hd__fill_1
XTAP_TAPCELL_ROW_81_1231 VGND VPWR sky130_fd_sc_hd__tapvpwrvgnd_1
XTAP_TAPCELL_ROW_81_1220 VGND VPWR sky130_fd_sc_hd__tapvpwrvgnd_1
XPHY_EDGE_ROW_30_Left_148 VGND VGND VPWR VPWR sky130_fd_sc_hd__decap_3
XFILLER_10_377 VPWR VGND VPWR VGND sky130_ef_sc_hd__decap_12
XFILLER_97_609 VGND VGND VPWR VPWR sky130_fd_sc_hd__decap_6
XTAP_TAPCELL_ROW_92_1360 VGND VPWR sky130_fd_sc_hd__tapvpwrvgnd_1
XFILLER_2_565 VPWR VGND VPWR VGND sky130_ef_sc_hd__decap_12
XFILLER_77_300 VGND VGND VPWR VPWR sky130_fd_sc_hd__decap_8
XFILLER_37_219 VGND VGND VPWR VPWR sky130_fd_sc_hd__decap_4
XFILLER_93_30 VPWR VGND VPWR VGND sky130_ef_sc_hd__decap_12
XFILLER_18_433 VGND VGND VPWR VPWR sky130_fd_sc_hd__decap_3
XFILLER_18_444 VGND VGND VPWR VPWR sky130_fd_sc_hd__decap_6
XFILLER_73_550 VGND VGND VPWR VPWR sky130_fd_sc_hd__fill_1
XFILLER_18_466 VGND VGND VPWR VPWR sky130_fd_sc_hd__decap_4
XFILLER_93_96 VGND VGND VPWR VPWR sky130_fd_sc_hd__decap_3
XFILLER_33_425 VGND VGND VPWR VPWR sky130_fd_sc_hd__fill_1
XFILLER_14_672 VGND VGND VPWR VPWR sky130_fd_sc_hd__decap_4
XTAP_TAPCELL_ROW_31_626 VGND VPWR sky130_fd_sc_hd__tapvpwrvgnd_1
XFILLER_41_480 VGND VGND VPWR VPWR sky130_fd_sc_hd__fill_2
XTAP_TAPCELL_ROW_11_383 VGND VPWR sky130_fd_sc_hd__tapvpwrvgnd_1
Xrebuffer1 net459 VGND VGND VPWR VPWR net516 sky130_fd_sc_hd__clkbuf_2
XFILLER_114_202 VGND VGND VPWR VPWR sky130_fd_sc_hd__fill_1
X_5320_ _1022_ _1024_ _1051_ VGND VGND VPWR VPWR _1053_ sky130_fd_sc_hd__nor3_1
X_5251_ _0981_ net628 VGND VGND VPWR VPWR _0986_ sky130_fd_sc_hd__nand2_2
X_5182_ _0917_ _0918_ VGND VGND VPWR VPWR _0920_ sky130_fd_sc_hd__xnor2_2
XFILLER_95_163 VGND VGND VPWR VPWR sky130_fd_sc_hd__decap_4
X_8941_ clknet_leaf_60_clk _0053_ VGND VGND VPWR VPWR pe_accum\[3\]\[9\] sky130_fd_sc_hd__dfxtp_1
XTAP_TAPCELL_ROW_39_726 VGND VPWR sky130_fd_sc_hd__tapvpwrvgnd_1
XFILLER_95_196 VGND VGND VPWR VPWR sky130_fd_sc_hd__decap_4
X_8872_ net212 _4010_ VGND VGND VPWR VPWR _4217_ sky130_fd_sc_hd__nand2_2
XTAP_TAPCELL_ROW_104_1507 VGND VPWR sky130_fd_sc_hd__tapvpwrvgnd_1
X_7823_ _3222_ VGND VGND VPWR VPWR _3223_ sky130_fd_sc_hd__inv_2
XTAP_TAPCELL_ROW_19_483 VGND VPWR sky130_fd_sc_hd__tapvpwrvgnd_1
X_7754_ net938 net221 _3186_ net374 VGND VGND VPWR VPWR _0338_ sky130_fd_sc_hd__o211a_1
X_6705_ net924 net236 _1809_ net244 VGND VGND VPWR VPWR _0275_ sky130_fd_sc_hd__o2bb2ai_1
X_4966_ _0709_ _0710_ VGND VGND VPWR VPWR _0711_ sky130_fd_sc_hd__nand2b_4
XFILLER_22_15 VPWR VGND VPWR VGND sky130_ef_sc_hd__decap_12
X_4897_ net414 _0643_ VGND VGND VPWR VPWR _0024_ sky130_fd_sc_hd__nor2_1
X_7685_ _3130_ _3131_ VGND VGND VPWR VPWR _3133_ sky130_fd_sc_hd__nand2_1
X_6636_ _2151_ _2150_ VGND VGND VPWR VPWR _2152_ sky130_fd_sc_hd__and2b_1
X_6567_ _2082_ _2083_ VGND VGND VPWR VPWR _2085_ sky130_fd_sc_hd__xnor2_1
XTAP_TAPCELL_ROW_115_1636 VGND VPWR sky130_fd_sc_hd__tapvpwrvgnd_1
X_8306_ _3691_ _3653_ _3692_ VGND VGND VPWR VPWR _3693_ sky130_fd_sc_hd__or3_4
X_5518_ net991 net250 _1219_ net365 VGND VGND VPWR VPWR _0069_ sky130_fd_sc_hd__o211a_1
X_9286_ clknet_leaf_9_clk _0398_ VGND VGND VPWR VPWR pe_array\[2\].u_pe.accum_reg\[28\]
+ sky130_fd_sc_hd__dfxtp_1
X_6498_ _2016_ _2017_ VGND VGND VPWR VPWR _2018_ sky130_fd_sc_hd__and2b_1
X_8237_ net440 net311 net308 VGND VGND VPWR VPWR _3625_ sky130_fd_sc_hd__and3_4
X_5449_ _1176_ _1177_ VGND VGND VPWR VPWR _1178_ sky130_fd_sc_hd__or2_4
X_8168_ _3510_ _3512_ _3556_ _3557_ VGND VGND VPWR VPWR _3558_ sky130_fd_sc_hd__o211a_1
XFILLER_86_141 VGND VGND VPWR VPWR sky130_fd_sc_hd__decap_3
Xfanout165 net167 VGND VGND VPWR VPWR net165 sky130_fd_sc_hd__clkbuf_2
X_7119_ _2574_ _2583_ VGND VGND VPWR VPWR _2584_ sky130_fd_sc_hd__nand2b_1
XFILLER_101_474 VPWR VGND VPWR VGND sky130_ef_sc_hd__decap_12
Xfanout198 _1568_ VGND VGND VPWR VPWR net198 sky130_fd_sc_hd__clkbuf_4
XFILLER_86_163 VGND VGND VPWR VPWR sky130_fd_sc_hd__fill_1
X_8099_ _3404_ _3447_ _3488_ VGND VGND VPWR VPWR _3491_ sky130_fd_sc_hd__a21oi_1
Xfanout176 _3668_ VGND VGND VPWR VPWR net176 sky130_fd_sc_hd__buf_4
Xfanout187 _3552_ VGND VGND VPWR VPWR net187 sky130_fd_sc_hd__clkbuf_4
XFILLER_59_366 VGND VGND VPWR VPWR sky130_fd_sc_hd__decap_3
XFILLER_19_208 VGND VGND VPWR VPWR sky130_fd_sc_hd__decap_3
XFILLER_74_347 VGND VGND VPWR VPWR sky130_fd_sc_hd__decap_3
XFILLER_103_51 VGND VGND VPWR VPWR sky130_fd_sc_hd__decap_4
XFILLER_82_380 VPWR VGND VPWR VGND sky130_ef_sc_hd__decap_12
XFILLER_70_542 VPWR VGND VPWR VGND sky130_ef_sc_hd__decap_12
XFILLER_70_531 VGND VGND VPWR VPWR sky130_fd_sc_hd__fill_1
XFILLER_63_55 VGND VGND VPWR VPWR sky130_fd_sc_hd__fill_1
XFILLER_15_447 VGND VGND VPWR VPWR sky130_fd_sc_hd__fill_1
XFILLER_11_653 VGND VGND VPWR VPWR sky130_fd_sc_hd__fill_2
XFILLER_109_552 VGND VGND VPWR VPWR sky130_fd_sc_hd__decap_3
XFILLER_12_81 VGND VGND VPWR VPWR sky130_fd_sc_hd__decap_3
XFILLER_88_85 VPWR VGND VPWR VGND sky130_ef_sc_hd__decap_12
XFILLER_78_620 VPWR VGND VPWR VGND sky130_ef_sc_hd__decap_12
XFILLER_2_362 VGND VGND VPWR VPWR sky130_fd_sc_hd__fill_2
XFILLER_65_314 VPWR VGND VPWR VGND sky130_ef_sc_hd__decap_12
XFILLER_92_177 VPWR VGND VPWR VGND sky130_ef_sc_hd__decap_12
XFILLER_33_200 VGND VGND VPWR VPWR sky130_fd_sc_hd__fill_1
XFILLER_73_391 VGND VGND VPWR VPWR sky130_fd_sc_hd__fill_1
XFILLER_61_553 VGND VGND VPWR VPWR sky130_fd_sc_hd__decap_6
XTAP_TAPCELL_ROW_16_442 VGND VPWR sky130_fd_sc_hd__tapvpwrvgnd_1
X_4820_ _0566_ net532 _0440_ VGND VGND VPWR VPWR _0568_ sky130_fd_sc_hd__o21bai_4
XTAP_TAPCELL_ROW_44_784 VGND VPWR sky130_fd_sc_hd__tapvpwrvgnd_1
X_4751_ _4434_ _0457_ _0456_ VGND VGND VPWR VPWR _0501_ sky130_fd_sc_hd__o21ba_1
X_4682_ _4436_ _4441_ VGND VGND VPWR VPWR _4443_ sky130_fd_sc_hd__xnor2_1
X_7470_ _2898_ _2924_ VGND VGND VPWR VPWR _2925_ sky130_fd_sc_hd__nor2_1
X_6421_ _1916_ _1942_ VGND VGND VPWR VPWR _1944_ sky130_fd_sc_hd__xnor2_2
X_9140_ clknet_leaf_20_clk _0252_ VGND VGND VPWR VPWR pe_array\[0\].u_pe.accum_reg\[26\]
+ sky130_fd_sc_hd__dfxtp_1
XFILLER_108_29 VPWR VGND VPWR VGND sky130_ef_sc_hd__decap_12
X_6352_ _1874_ _1875_ _1844_ _1845_ VGND VGND VPWR VPWR _1877_ sky130_fd_sc_hd__a211o_1
X_6283_ net431 _1810_ VGND VGND VPWR VPWR _0243_ sky130_fd_sc_hd__nor2_1
X_5303_ _1036_ _1035_ VGND VGND VPWR VPWR _1037_ sky130_fd_sc_hd__nand2_4
X_9071_ clknet_leaf_52_clk _0183_ VGND VGND VPWR VPWR net146 sky130_fd_sc_hd__dfxtp_1
X_8022_ _3414_ _3413_ VGND VGND VPWR VPWR _3415_ sky130_fd_sc_hd__nand2b_1
X_5234_ _0967_ _0968_ VGND VGND VPWR VPWR _0970_ sky130_fd_sc_hd__xor2_1
XFILLER_69_653 VPWR VGND VPWR VGND sky130_ef_sc_hd__decap_12
X_5165_ net285 _0901_ _0902_ VGND VGND VPWR VPWR _0903_ sky130_fd_sc_hd__nor3_1
XTAP_TAPCELL_ROW_110_1577 VGND VPWR sky130_fd_sc_hd__tapvpwrvgnd_1
XFILLER_84_612 VGND VGND VPWR VPWR sky130_fd_sc_hd__fill_2
XFILLER_68_141 VGND VGND VPWR VPWR sky130_fd_sc_hd__decap_4
XFILLER_29_517 VGND VGND VPWR VPWR sky130_fd_sc_hd__fill_2
XFILLER_84_645 VPWR VGND VPWR VGND sky130_ef_sc_hd__decap_12
XFILLER_83_100 VGND VGND VPWR VPWR sky130_fd_sc_hd__fill_1
X_5096_ _0834_ _0835_ VGND VGND VPWR VPWR _0837_ sky130_fd_sc_hd__nand2_1
XFILLER_29_539 VPWR VGND VPWR VGND sky130_ef_sc_hd__decap_12
XFILLER_84_678 VPWR VGND VPWR VGND sky130_ef_sc_hd__decap_12
XFILLER_56_358 VGND VGND VPWR VPWR sky130_fd_sc_hd__fill_2
XFILLER_17_15 VPWR VGND VPWR VGND sky130_ef_sc_hd__decap_12
X_8924_ clknet_leaf_62_clk _0036_ VGND VGND VPWR VPWR pe_array\[3\].u_pe.accum_reg\[24\]
+ sky130_fd_sc_hd__dfxtp_1
XFILLER_37_561 VGND VGND VPWR VPWR sky130_fd_sc_hd__decap_8
X_8855_ net990 net209 _4208_ net380 VGND VGND VPWR VPWR _0417_ sky130_fd_sc_hd__o211a_1
X_7806_ net421 _3210_ VGND VGND VPWR VPWR _0366_ sky130_fd_sc_hd__nor2_1
XTAP_TAPCELL_ROW_65_1034 VGND VPWR sky130_fd_sc_hd__tapvpwrvgnd_1
XFILLER_52_553 VGND VGND VPWR VPWR sky130_fd_sc_hd__decap_3
XFILLER_52_531 VGND VGND VPWR VPWR sky130_fd_sc_hd__fill_1
X_8786_ _4119_ _4152_ _4122_ _4150_ VGND VGND VPWR VPWR _4157_ sky130_fd_sc_hd__o31a_1
X_5998_ _1525_ _1531_ _1532_ VGND VGND VPWR VPWR _1533_ sky130_fd_sc_hd__nand3_1
X_7737_ net224 _2282_ VGND VGND VPWR VPWR _3178_ sky130_fd_sc_hd__nand2_1
XFILLER_52_597 VPWR VGND VPWR VGND sky130_ef_sc_hd__decap_12
X_4949_ _0654_ _0655_ _0692_ _0693_ VGND VGND VPWR VPWR _0694_ sky130_fd_sc_hd__o211a_1
XFILLER_33_69 VPWR VGND VPWR VGND sky130_ef_sc_hd__decap_12
X_7668_ _3082_ _3084_ _3115_ VGND VGND VPWR VPWR _3116_ sky130_fd_sc_hd__o21a_1
XPHY_EDGE_ROW_104_Left_222 VGND VGND VPWR VPWR sky130_fd_sc_hd__decap_3
X_6619_ _2134_ _2133_ VGND VGND VPWR VPWR _2135_ sky130_fd_sc_hd__and2b_1
X_7599_ _3047_ _3048_ VGND VGND VPWR VPWR _3049_ sky130_fd_sc_hd__and2_1
XFILLER_106_533 VPWR VGND VPWR VGND sky130_ef_sc_hd__decap_12
XTAP_TAPCELL_ROW_76_1163 VGND VPWR sky130_fd_sc_hd__tapvpwrvgnd_1
X_9269_ clknet_leaf_3_clk _0381_ VGND VGND VPWR VPWR pe_array\[2\].u_pe.accum_reg\[11\]
+ sky130_fd_sc_hd__dfxtp_1
XFILLER_58_77 VGND VGND VPWR VPWR sky130_fd_sc_hd__decap_6
XPHY_EDGE_ROW_113_Left_231 VGND VGND VPWR VPWR sky130_fd_sc_hd__decap_3
XFILLER_101_293 VGND VGND VPWR VPWR sky130_fd_sc_hd__fill_2
XFILLER_75_645 VGND VGND VPWR VPWR sky130_fd_sc_hd__decap_8
XFILLER_114_83 VGND VGND VPWR VPWR sky130_fd_sc_hd__fill_1
XFILLER_74_133 VGND VGND VPWR VPWR sky130_fd_sc_hd__decap_6
XFILLER_62_306 VGND VGND VPWR VPWR sky130_fd_sc_hd__fill_2
XTAP_TAPCELL_ROW_87_1292 VGND VPWR sky130_fd_sc_hd__tapvpwrvgnd_1
XFILLER_55_391 VGND VGND VPWR VPWR sky130_fd_sc_hd__fill_1
XFILLER_55_380 VGND VGND VPWR VPWR sky130_fd_sc_hd__fill_1
XFILLER_15_244 VGND VGND VPWR VPWR sky130_fd_sc_hd__decap_8
XFILLER_70_350 VPWR VGND VPWR VGND sky130_ef_sc_hd__decap_12
XTAP_TAPCELL_ROW_13_412 VGND VPWR sky130_fd_sc_hd__tapvpwrvgnd_1
XFILLER_15_299 VPWR VGND VPWR VGND sky130_ef_sc_hd__decap_12
XTAP_TAPCELL_ROW_41_743 VGND VPWR sky130_fd_sc_hd__tapvpwrvgnd_1
XFILLER_109_393 VGND VGND VPWR VPWR sky130_fd_sc_hd__fill_1
XFILLER_97_225 VGND VGND VPWR VPWR sky130_fd_sc_hd__fill_2
XFILLER_3_671 VGND VGND VPWR VPWR sky130_fd_sc_hd__fill_1
XFILLER_66_601 VPWR VGND VPWR VGND sky130_ef_sc_hd__decap_12
XFILLER_66_645 VPWR VGND VPWR VGND sky130_ef_sc_hd__decap_12
XFILLER_65_111 VGND VGND VPWR VPWR sky130_fd_sc_hd__fill_1
XFILLER_17_3 VPWR VGND VPWR VGND sky130_ef_sc_hd__decap_12
XTAP_TAPCELL_ROW_49_843 VGND VPWR sky130_fd_sc_hd__tapvpwrvgnd_1
XFILLER_66_689 VGND VGND VPWR VPWR sky130_fd_sc_hd__decap_3
XFILLER_38_347 VPWR VGND VPWR VGND sky130_ef_sc_hd__decap_12
X_6970_ _2389_ _2391_ _2437_ VGND VGND VPWR VPWR _2439_ sky130_fd_sc_hd__nand3_1
X_5921_ _1456_ _1457_ VGND VGND VPWR VPWR _1458_ sky130_fd_sc_hd__nor2_2
XFILLER_46_380 VPWR VGND VPWR VGND sky130_ef_sc_hd__decap_12
X_8640_ _3984_ _3986_ _4014_ _4015_ VGND VGND VPWR VPWR _4016_ sky130_fd_sc_hd__o211a_1
X_5852_ net474 net467 net355 net352 VGND VGND VPWR VPWR _1390_ sky130_fd_sc_hd__and4_1
XFILLER_34_575 VGND VGND VPWR VPWR sky130_fd_sc_hd__decap_4
XFILLER_34_586 VGND VGND VPWR VPWR sky130_fd_sc_hd__fill_2
X_8571_ pe_array\[2\].u_pe.accum_reg\[23\] net442 net316 VGND VGND VPWR VPWR _3949_
+ sky130_fd_sc_hd__and3_1
X_5783_ pe_array\[0\].u_pe.accum_reg\[5\] net474 net358 VGND VGND VPWR VPWR _1323_
+ sky130_fd_sc_hd__nand3_1
XFILLER_21_225 VPWR VGND VPWR VGND sky130_ef_sc_hd__decap_12
X_4803_ _0503_ _0551_ _0549_ VGND VGND VPWR VPWR _0552_ sky130_fd_sc_hd__a21o_1
X_7522_ _2973_ _2974_ VGND VGND VPWR VPWR _2975_ sky130_fd_sc_hd__and2_1
X_4734_ pe_array\[3\].u_pe.accum_reg\[9\] net301 net461 VGND VGND VPWR VPWR _0484_
+ sky130_fd_sc_hd__and3_1
X_7453_ _2904_ _2905_ net268 VGND VGND VPWR VPWR _2908_ sky130_fd_sc_hd__o21ai_1
X_4665_ _4390_ _4426_ VGND VGND VPWR VPWR _4427_ sky130_fd_sc_hd__xnor2_2
X_6404_ _1899_ _1900_ _1925_ _1926_ VGND VGND VPWR VPWR _1927_ sky130_fd_sc_hd__o211ai_1
X_7384_ net168 _2810_ _2809_ VGND VGND VPWR VPWR _2842_ sky130_fd_sc_hd__a21bo_1
X_4596_ _4355_ _4358_ VGND VGND VPWR VPWR _4359_ sky130_fd_sc_hd__nand2_1
X_6335_ _1858_ _1859_ net171 VGND VGND VPWR VPWR _1861_ sky130_fd_sc_hd__a21o_1
X_9123_ clknet_leaf_18_clk _0235_ VGND VGND VPWR VPWR pe_array\[0\].u_pe.accum_reg\[9\]
+ sky130_fd_sc_hd__dfxtp_1
X_9054_ clknet_leaf_4_clk _0166_ VGND VGND VPWR VPWR net128 sky130_fd_sc_hd__dfxtp_1
X_6266_ net173 _1792_ _1793_ VGND VGND VPWR VPWR _1794_ sky130_fd_sc_hd__or3_1
X_8005_ _3315_ _3356_ _3398_ VGND VGND VPWR VPWR _3399_ sky130_fd_sc_hd__nor3b_1
X_6197_ net199 _1724_ _1726_ VGND VGND VPWR VPWR _1727_ sky130_fd_sc_hd__or3b_1
X_5217_ net414 _0953_ VGND VGND VPWR VPWR _0034_ sky130_fd_sc_hd__nor2_1
XFILLER_57_645 VPWR VGND VPWR VGND sky130_ef_sc_hd__decap_12
X_5148_ _0885_ _0884_ VGND VGND VPWR VPWR _0887_ sky130_fd_sc_hd__xnor2_2
X_5079_ _0786_ _0788_ _0818_ _0819_ VGND VGND VPWR VPWR _0820_ sky130_fd_sc_hd__o211a_1
XFILLER_72_637 VGND VGND VPWR VPWR sky130_fd_sc_hd__decap_6
X_8907_ clknet_leaf_55_clk _0019_ VGND VGND VPWR VPWR pe_array\[3\].u_pe.accum_reg\[7\]
+ sky130_fd_sc_hd__dfxtp_1
X_8838_ net216 _3402_ VGND VGND VPWR VPWR _4200_ sky130_fd_sc_hd__nand2_1
XFILLER_71_169 VGND VGND VPWR VPWR sky130_fd_sc_hd__decap_8
XFILLER_25_553 VGND VGND VPWR VPWR sky130_fd_sc_hd__decap_6
X_8769_ _3668_ _4139_ VGND VGND VPWR VPWR _4141_ sky130_fd_sc_hd__xnor2_1
XFILLER_100_63 VPWR VGND VPWR VGND sky130_ef_sc_hd__decap_12
XFILLER_4_457 VPWR VGND VPWR VGND sky130_ef_sc_hd__decap_12
XFILLER_106_363 VGND VGND VPWR VPWR sky130_fd_sc_hd__fill_1
XFILLER_79_225 VPWR VGND VPWR VGND sky130_ef_sc_hd__decap_12
XFILLER_0_641 VGND VGND VPWR VPWR sky130_fd_sc_hd__decap_3
XFILLER_48_601 VPWR VGND VPWR VGND sky130_ef_sc_hd__decap_12
XTAP_TAPCELL_ROW_89_1321 VGND VPWR sky130_fd_sc_hd__tapvpwrvgnd_1
XFILLER_85_42 VGND VGND VPWR VPWR sky130_fd_sc_hd__decap_6
XFILLER_0_685 VPWR VGND VPWR VGND sky130_ef_sc_hd__decap_12
XFILLER_48_667 VPWR VGND VPWR VGND sky130_ef_sc_hd__decap_12
XTAP_TAPCELL_ROW_46_802 VGND VPWR sky130_fd_sc_hd__tapvpwrvgnd_1
XFILLER_47_177 VGND VGND VPWR VPWR sky130_fd_sc_hd__decap_3
XFILLER_63_648 VGND VGND VPWR VPWR sky130_fd_sc_hd__fill_1
XFILLER_47_199 VGND VGND VPWR VPWR sky130_fd_sc_hd__fill_2
XFILLER_50_309 VGND VGND VPWR VPWR sky130_fd_sc_hd__fill_2
XFILLER_93_7 VGND VGND VPWR VPWR sky130_fd_sc_hd__fill_1
XTAP_TAPCELL_ROW_26_570 VGND VPWR sky130_fd_sc_hd__tapvpwrvgnd_1
XFILLER_117_617 VPWR VGND VPWR VGND sky130_ef_sc_hd__decap_12
X_4450_ net346 VGND VGND VPWR VPWR _4231_ sky130_fd_sc_hd__inv_2
XFILLER_112_300 VGND VGND VPWR VPWR sky130_fd_sc_hd__decap_8
X_6120_ net277 _1649_ _1650_ VGND VGND VPWR VPWR _1652_ sky130_fd_sc_hd__or3_4
XFILLER_112_333 VPWR VGND VPWR VGND sky130_ef_sc_hd__decap_12
XFILLER_112_377 VGND VGND VPWR VPWR sky130_fd_sc_hd__fill_1
XFILLER_98_589 VGND VGND VPWR VPWR sky130_fd_sc_hd__fill_2
X_6051_ _1582_ _1583_ _1537_ _1539_ VGND VGND VPWR VPWR _1585_ sky130_fd_sc_hd__a211oi_2
XFILLER_39_601 VGND VGND VPWR VPWR sky130_fd_sc_hd__fill_1
X_5002_ _0744_ _0745_ VGND VGND VPWR VPWR _0746_ sky130_fd_sc_hd__nor2_4
XFILLER_81_401 VPWR VGND VPWR VGND sky130_ef_sc_hd__decap_12
XFILLER_26_317 VGND VGND VPWR VPWR sky130_fd_sc_hd__decap_3
XFILLER_39_689 VGND VGND VPWR VPWR sky130_fd_sc_hd__fill_2
XFILLER_81_445 VGND VGND VPWR VPWR sky130_fd_sc_hd__decap_3
XFILLER_19_391 VGND VGND VPWR VPWR sky130_fd_sc_hd__fill_1
X_6953_ _2412_ _2420_ _2421_ VGND VGND VPWR VPWR _2422_ sky130_fd_sc_hd__nand3_1
Xclkbuf_3_5__f_clk clknet_0_clk VGND VGND VPWR VPWR clknet_3_5__leaf_clk sky130_fd_sc_hd__clkbuf_16
X_5904_ net274 _1439_ _1440_ VGND VGND VPWR VPWR _1441_ sky130_fd_sc_hd__nor3_1
XFILLER_53_169 VPWR VGND VPWR VGND sky130_ef_sc_hd__decap_12
X_6884_ net510 _4234_ VGND VGND VPWR VPWR _2354_ sky130_fd_sc_hd__nor2_1
X_8623_ _3997_ _3998_ VGND VGND VPWR VPWR _4000_ sky130_fd_sc_hd__xnor2_1
X_5835_ _1313_ _1373_ VGND VGND VPWR VPWR _1374_ sky130_fd_sc_hd__xnor2_2
X_8554_ net162 _3901_ _3900_ VGND VGND VPWR VPWR _3933_ sky130_fd_sc_hd__o21bai_1
X_5766_ _1280_ _1305_ VGND VGND VPWR VPWR _1307_ sky130_fd_sc_hd__nand2_1
X_5697_ net513 net356 pe_array\[0\].u_pe.accum_reg\[0\] VGND VGND VPWR VPWR _1242_
+ sky130_fd_sc_hd__a21oi_1
X_8485_ _3863_ _3864_ _3865_ VGND VGND VPWR VPWR _3866_ sky130_fd_sc_hd__and3_1
X_7505_ net425 _2958_ VGND VGND VPWR VPWR _0317_ sky130_fd_sc_hd__nor2_1
X_4717_ net416 _0467_ VGND VGND VPWR VPWR _0020_ sky130_fd_sc_hd__nor2_1
Xrebuffer359 net873 VGND VGND VPWR VPWR net874 sky130_fd_sc_hd__dlymetal6s2s_1
X_7436_ net166 _2891_ VGND VGND VPWR VPWR _2892_ sky130_fd_sc_hd__xnor2_1
X_4648_ _4407_ _4408_ _4369_ net577 VGND VGND VPWR VPWR _4410_ sky130_fd_sc_hd__o211ai_2
XFILLER_89_512 VPWR VGND VPWR VGND sky130_ef_sc_hd__decap_12
X_9106_ clknet_leaf_1_clk _0218_ VGND VGND VPWR VPWR pe_array\[2\].u_pe.weight_in\[4\]
+ sky130_fd_sc_hd__dfxtp_1
X_7367_ net267 _2823_ _2824_ VGND VGND VPWR VPWR _2825_ sky130_fd_sc_hd__nor3_1
X_4579_ _4339_ _4340_ _4341_ VGND VGND VPWR VPWR _4343_ sky130_fd_sc_hd__a21o_1
X_6318_ net456 pe_array\[0\].u_pe.accum_reg\[19\] net359 VGND VGND VPWR VPWR _1844_
+ sky130_fd_sc_hd__and3_1
XFILLER_89_545 VPWR VGND VPWR VGND sky130_ef_sc_hd__decap_12
XTAP_TAPCELL_ROW_73_1133 VGND VPWR sky130_fd_sc_hd__tapvpwrvgnd_1
XFILLER_1_449 VPWR VGND VPWR VGND sky130_ef_sc_hd__decap_12
X_7298_ _2691_ _2693_ _2727_ _2758_ _2726_ VGND VGND VPWR VPWR _2759_ sky130_fd_sc_hd__a311o_1
X_6249_ _1777_ _1751_ VGND VGND VPWR VPWR _1778_ sky130_fd_sc_hd__nand2b_1
X_9037_ clknet_leaf_40_clk _0149_ VGND VGND VPWR VPWR net109 sky130_fd_sc_hd__dfxtp_1
XFILLER_39_57 VPWR VGND VPWR VGND sky130_ef_sc_hd__decap_12
XFILLER_29_111 VGND VGND VPWR VPWR sky130_fd_sc_hd__fill_1
XTAP_TAPCELL_ROW_4_298 VGND VPWR sky130_fd_sc_hd__tapvpwrvgnd_1
XFILLER_32_309 VPWR VGND VPWR VGND sky130_ef_sc_hd__decap_12
XFILLER_111_51 VGND VGND VPWR VPWR sky130_fd_sc_hd__decap_4
XTAP_TAPCELL_ROW_84_1262 VGND VPWR sky130_fd_sc_hd__tapvpwrvgnd_1
XFILLER_71_44 VGND VGND VPWR VPWR sky130_fd_sc_hd__decap_3
XFILLER_9_505 VPWR VGND VPWR VGND sky130_ef_sc_hd__decap_12
XFILLER_13_545 VPWR VGND VPWR VGND sky130_ef_sc_hd__decap_12
XFILLER_40_342 VGND VGND VPWR VPWR sky130_fd_sc_hd__fill_1
XTAP_TAPCELL_ROW_51_871 VGND VPWR sky130_fd_sc_hd__tapvpwrvgnd_1
XTAP_TAPCELL_ROW_51_860 VGND VPWR sky130_fd_sc_hd__tapvpwrvgnd_1
XFILLER_40_375 VPWR VGND VPWR VGND sky130_ef_sc_hd__decap_12
XTAP_TAPCELL_ROW_95_1391 VGND VPWR sky130_fd_sc_hd__tapvpwrvgnd_1
XFILLER_20_92 VGND VGND VPWR VPWR sky130_fd_sc_hd__decap_4
XFILLER_96_63 VGND VGND VPWR VPWR sky130_fd_sc_hd__decap_8
XFILLER_48_442 VPWR VGND VPWR VGND sky130_ef_sc_hd__decap_12
XTAP_TAPCELL_ROW_59_960 VGND VPWR sky130_fd_sc_hd__tapvpwrvgnd_1
XFILLER_90_253 VGND VGND VPWR VPWR sky130_fd_sc_hd__decap_8
XFILLER_23_309 VGND VGND VPWR VPWR sky130_fd_sc_hd__fill_1
XFILLER_35_169 VGND VGND VPWR VPWR sky130_fd_sc_hd__fill_1
XFILLER_90_275 VGND VGND VPWR VPWR sky130_fd_sc_hd__decap_3
X_5620_ net1005 net380 VGND VGND VPWR VPWR _0161_ sky130_fd_sc_hd__and2_1
X_5551_ net1025 net394 VGND VGND VPWR VPWR _0092_ sky130_fd_sc_hd__and2_1
XFILLER_31_397 VGND VGND VPWR VPWR sky130_fd_sc_hd__fill_1
X_8270_ _3655_ _3657_ VGND VGND VPWR VPWR _3658_ sky130_fd_sc_hd__nand2_1
X_4502_ _4227_ _4257_ _4256_ VGND VGND VPWR VPWR _4269_ sky130_fd_sc_hd__o21ai_1
XFILLER_117_469 VGND VGND VPWR VPWR sky130_fd_sc_hd__decap_3
X_5482_ net934 net250 _1201_ net367 VGND VGND VPWR VPWR _0051_ sky130_fd_sc_hd__o211a_1
X_7221_ _2680_ _2681_ _2682_ VGND VGND VPWR VPWR _2684_ sky130_fd_sc_hd__a21oi_1
XFILLER_116_29 VPWR VGND VPWR VGND sky130_ef_sc_hd__decap_12
Xfanout506 net593 VGND VGND VPWR VPWR net506 sky130_fd_sc_hd__buf_4
X_7152_ _2616_ net768 _2612_ VGND VGND VPWR VPWR _2617_ sky130_fd_sc_hd__a21oi_4
XFILLER_113_653 VPWR VGND VPWR VGND sky130_ef_sc_hd__decap_12
XFILLER_112_141 VGND VGND VPWR VPWR sky130_fd_sc_hd__decap_3
X_6103_ _1635_ VGND VGND VPWR VPWR _1636_ sky130_fd_sc_hd__inv_2
X_7083_ _2503_ _2505_ _2547_ _2548_ VGND VGND VPWR VPWR _2549_ sky130_fd_sc_hd__o211a_1
XFILLER_113_697 VGND VGND VPWR VPWR sky130_fd_sc_hd__decap_3
X_6034_ _1522_ _1524_ VGND VGND VPWR VPWR _1568_ sky130_fd_sc_hd__xor2_4
XFILLER_58_239 VPWR VGND VPWR VGND sky130_ef_sc_hd__decap_12
XFILLER_39_453 VGND VGND VPWR VPWR sky130_fd_sc_hd__fill_1
Xrebuffer11 net525 VGND VGND VPWR VPWR net526 sky130_fd_sc_hd__dlymetal6s2s_1
XTAP_TAPCELL_ROW_107_1538 VGND VPWR sky130_fd_sc_hd__tapvpwrvgnd_1
X_7985_ _3369_ _3378_ VGND VGND VPWR VPWR _3379_ sky130_fd_sc_hd__xnor2_1
XFILLER_66_283 VGND VGND VPWR VPWR sky130_fd_sc_hd__fill_1
Xrebuffer44 _3422_ VGND VGND VPWR VPWR net559 sky130_fd_sc_hd__dlygate4sd1_1
Xrebuffer33 net549 VGND VGND VPWR VPWR net548 sky130_fd_sc_hd__buf_6
Xrebuffer22 _2565_ VGND VGND VPWR VPWR net537 sky130_fd_sc_hd__dlymetal6s4s_1
XFILLER_14_309 VGND VGND VPWR VPWR sky130_fd_sc_hd__fill_2
XTAP_TAPCELL_ROW_1_268 VGND VPWR sky130_fd_sc_hd__tapvpwrvgnd_1
XFILLER_25_15 VGND VGND VPWR VPWR sky130_fd_sc_hd__fill_2
Xrebuffer66 _0781_ VGND VGND VPWR VPWR net581 sky130_fd_sc_hd__clkbuf_2
X_6936_ _2398_ _2403_ VGND VGND VPWR VPWR _2405_ sky130_fd_sc_hd__xnor2_1
XTAP_TAPCELL_ROW_37_698 VGND VPWR sky130_fd_sc_hd__tapvpwrvgnd_1
X_6867_ _2335_ _2336_ _2329_ VGND VGND VPWR VPWR _2338_ sky130_fd_sc_hd__a21o_1
X_8606_ _3970_ _3981_ _3980_ _3982_ VGND VGND VPWR VPWR _3983_ sky130_fd_sc_hd__o211a_1
X_5818_ net473 net355 VGND VGND VPWR VPWR _1357_ sky130_fd_sc_hd__nand2_1
X_6798_ _2268_ _2269_ _2262_ VGND VGND VPWR VPWR _2271_ sky130_fd_sc_hd__a21o_1
X_8537_ net402 pe_array\[2\].u_pe.accum_reg\[21\] net218 _3916_ VGND VGND VPWR VPWR
+ _3917_ sky130_fd_sc_hd__o2bb2a_4
X_5749_ _1288_ _1289_ net512 net348 VGND VGND VPWR VPWR _1290_ sky130_fd_sc_hd__and4bb_1
Xrebuffer112 _0686_ VGND VGND VPWR VPWR net627 sky130_fd_sc_hd__buf_2
XFILLER_41_69 VPWR VGND VPWR VGND sky130_ef_sc_hd__decap_12
Xrebuffer189 _1814_ VGND VGND VPWR VPWR net704 sky130_fd_sc_hd__dlygate4sd3_1
Xrebuffer167 _3465_ VGND VGND VPWR VPWR net682 sky130_fd_sc_hd__buf_6
X_8468_ _3819_ _3849_ VGND VGND VPWR VPWR _3850_ sky130_fd_sc_hd__and2_1
X_8399_ net161 _3781_ _3782_ VGND VGND VPWR VPWR _3783_ sky130_fd_sc_hd__or3_1
X_7419_ _2817_ _2819_ _2847_ VGND VGND VPWR VPWR _2876_ sky130_fd_sc_hd__and3b_1
XFILLER_104_631 VGND VGND VPWR VPWR sky130_fd_sc_hd__decap_3
XTAP_TAPCELL_ROW_9_357 VGND VPWR sky130_fd_sc_hd__tapvpwrvgnd_1
XFILLER_77_559 VGND VGND VPWR VPWR sky130_fd_sc_hd__fill_1
XFILLER_85_570 VGND VGND VPWR VPWR sky130_fd_sc_hd__decap_3
XTAP_TAPCELL_ROW_56_930 VGND VPWR sky130_fd_sc_hd__tapvpwrvgnd_1
XFILLER_17_125 VGND VGND VPWR VPWR sky130_fd_sc_hd__decap_6
XFILLER_17_136 VGND VGND VPWR VPWR sky130_fd_sc_hd__decap_8
XFILLER_72_253 VPWR VGND VPWR VGND sky130_ef_sc_hd__decap_12
XFILLER_26_681 VGND VGND VPWR VPWR sky130_fd_sc_hd__decap_3
XFILLER_32_139 VGND VGND VPWR VPWR sky130_fd_sc_hd__fill_1
XFILLER_41_673 VGND VGND VPWR VPWR sky130_fd_sc_hd__decap_3
XFILLER_40_172 VGND VGND VPWR VPWR sky130_fd_sc_hd__fill_2
XTAP_TAPCELL_ROW_97_1420 VGND VPWR sky130_fd_sc_hd__tapvpwrvgnd_1
XFILLER_5_530 VGND VGND VPWR VPWR sky130_fd_sc_hd__fill_1
XFILLER_56_7 VPWR VGND VPWR VGND sky130_ef_sc_hd__decap_12
Xoutput109 net109 VGND VGND VPWR VPWR result_data[63] sky130_fd_sc_hd__buf_2
XFILLER_5_552 VGND VGND VPWR VPWR sky130_fd_sc_hd__decap_8
XFILLER_99_139 VGND VGND VPWR VPWR sky130_fd_sc_hd__decap_4
XFILLER_68_504 VGND VGND VPWR VPWR sky130_fd_sc_hd__decap_8
XFILLER_110_612 VPWR VGND VPWR VGND sky130_ef_sc_hd__decap_12
Xoutput80 net80 VGND VGND VPWR VPWR result_data[37] sky130_fd_sc_hd__buf_2
Xoutput91 net91 VGND VGND VPWR VPWR result_data[47] sky130_fd_sc_hd__buf_2
XFILLER_110_645 VPWR VGND VPWR VGND sky130_ef_sc_hd__decap_12
XFILLER_83_529 VGND VGND VPWR VPWR sky130_fd_sc_hd__decap_6
XFILLER_36_434 VGND VGND VPWR VPWR sky130_fd_sc_hd__fill_2
XFILLER_36_467 VGND VGND VPWR VPWR sky130_fd_sc_hd__decap_8
X_7770_ net951 net222 _3194_ net375 VGND VGND VPWR VPWR _0346_ sky130_fd_sc_hd__o211a_1
X_4982_ _0690_ _0691_ _0723_ _0724_ VGND VGND VPWR VPWR _0726_ sky130_fd_sc_hd__o211ai_1
X_6721_ pe_array\[1\].u_pe.tap_count\[2\] pe_array\[1\].u_pe.tap_count\[1\] pe_array\[1\].u_pe.tap_count\[0\]
+ pe_array\[1\].u_pe.tap_count\[3\] VGND VGND VPWR VPWR _2202_ sky130_fd_sc_hd__or4b_1
XTAP_TAPCELL_ROW_34_657 VGND VPWR sky130_fd_sc_hd__tapvpwrvgnd_1
XTAP_TAPCELL_ROW_102_1479 VGND VPWR sky130_fd_sc_hd__tapvpwrvgnd_1
X_6652_ _2165_ _2166_ net642 VGND VGND VPWR VPWR _2167_ sky130_fd_sc_hd__a21oi_1
XTAP_TAPCELL_ROW_62_999 VGND VPWR sky130_fd_sc_hd__tapvpwrvgnd_1
X_5603_ net956 net377 VGND VGND VPWR VPWR _0144_ sky130_fd_sc_hd__and2_1
X_6583_ net276 _2098_ _2099_ VGND VGND VPWR VPWR _2100_ sky130_fd_sc_hd__nor3_1
X_8322_ _3672_ _3673_ _3706_ _3707_ VGND VGND VPWR VPWR _3708_ sky130_fd_sc_hd__o211a_1
X_5534_ net13 _1226_ _1227_ net343 VGND VGND VPWR VPWR _0077_ sky130_fd_sc_hd__a22o_1
XFILLER_11_39 VPWR VGND VPWR VGND sky130_ef_sc_hd__decap_12
X_8253_ _3637_ _3638_ _3592_ _3594_ VGND VGND VPWR VPWR _3641_ sky130_fd_sc_hd__a211o_1
X_5465_ net400 pe_array\[3\].u_pe.accum_reg\[31\] net258 _1192_ VGND VGND VPWR VPWR
+ _1193_ sky130_fd_sc_hd__o2bb2a_1
X_8184_ net681 _3573_ _3528_ VGND VGND VPWR VPWR _3574_ sky130_fd_sc_hd__a21oi_4
X_7204_ net452 net338 pe_array\[1\].u_pe.accum_reg\[14\] VGND VGND VPWR VPWR _2667_
+ sky130_fd_sc_hd__a21oi_1
Xfanout314 net319 VGND VGND VPWR VPWR net314 sky130_fd_sc_hd__dlymetal6s2s_1
Xfanout303 pe_array\[3\].u_pe.weight_in\[2\] VGND VGND VPWR VPWR net303 sky130_fd_sc_hd__buf_2
X_5396_ net417 _1126_ VGND VGND VPWR VPWR _0040_ sky130_fd_sc_hd__nor2_1
X_7135_ _2585_ _2597_ _2598_ VGND VGND VPWR VPWR _2600_ sky130_fd_sc_hd__nand3_1
Xfanout347 pe_array\[0\].u_pe.weight_in\[5\] VGND VGND VPWR VPWR net347 sky130_fd_sc_hd__clkbuf_2
XFILLER_59_526 VGND VGND VPWR VPWR sky130_fd_sc_hd__decap_8
Xfanout325 pe_array\[2\].u_pe.weight_in\[0\] VGND VGND VPWR VPWR net325 sky130_fd_sc_hd__buf_2
Xfanout336 pe_array\[1\].u_pe.weight_in\[1\] VGND VGND VPWR VPWR net336 sky130_fd_sc_hd__buf_2
XTAP_TAPCELL_ROW_6_327 VGND VPWR sky130_fd_sc_hd__tapvpwrvgnd_1
Xfanout358 net362 VGND VGND VPWR VPWR net358 sky130_fd_sc_hd__buf_2
Xfanout369 net370 VGND VGND VPWR VPWR net369 sky130_fd_sc_hd__clkbuf_4
X_7066_ net465 net330 _2498_ net530 VGND VGND VPWR VPWR _2532_ sky130_fd_sc_hd__a31o_1
X_6017_ _1414_ _1506_ _1462_ _1415_ _1551_ VGND VGND VPWR VPWR _1552_ sky130_fd_sc_hd__o41ai_2
XFILLER_39_250 VPWR VGND VPWR VGND sky130_ef_sc_hd__decap_12
XTAP_TAPCELL_ROW_68_1065 VGND VPWR sky130_fd_sc_hd__tapvpwrvgnd_1
XFILLER_54_253 VGND VGND VPWR VPWR sky130_fd_sc_hd__decap_8
XFILLER_27_467 VGND VGND VPWR VPWR sky130_fd_sc_hd__decap_3
X_7968_ net512 _4238_ VGND VGND VPWR VPWR _3362_ sky130_fd_sc_hd__nor2_1
XFILLER_54_286 VGND VGND VPWR VPWR sky130_fd_sc_hd__fill_1
XFILLER_14_128 VGND VGND VPWR VPWR sky130_fd_sc_hd__decap_4
XFILLER_15_629 VPWR VGND VPWR VGND sky130_ef_sc_hd__decap_12
X_7899_ _3291_ _3292_ net485 net320 VGND VGND VPWR VPWR _3295_ sky130_fd_sc_hd__a2bb2o_1
XTAP_TAPCELL_ROW_81_1221 VGND VPWR sky130_fd_sc_hd__tapvpwrvgnd_1
XFILLER_14_139 VGND VGND VPWR VPWR sky130_fd_sc_hd__fill_1
X_6919_ _2348_ _2388_ VGND VGND VPWR VPWR _2389_ sky130_fd_sc_hd__or2_1
XFILLER_23_673 VGND VGND VPWR VPWR sky130_fd_sc_hd__fill_1
XFILLER_6_305 VGND VGND VPWR VPWR sky130_fd_sc_hd__decap_3
XFILLER_108_233 VPWR VGND VPWR VGND sky130_ef_sc_hd__decap_12
XFILLER_10_389 VPWR VGND VPWR VGND sky130_ef_sc_hd__decap_12
XFILLER_2_533 VGND VGND VPWR VPWR sky130_fd_sc_hd__decap_8
XTAP_TAPCELL_ROW_92_1361 VGND VPWR sky130_fd_sc_hd__tapvpwrvgnd_1
Xhold390 pe_accum\[3\]\[16\] VGND VGND VPWR VPWR net905 sky130_fd_sc_hd__dlygate4sd3_1
XFILLER_89_172 VGND VGND VPWR VPWR sky130_fd_sc_hd__fill_2
XFILLER_77_32 VGND VGND VPWR VPWR sky130_fd_sc_hd__fill_1
XFILLER_2_577 VGND VGND VPWR VPWR sky130_fd_sc_hd__decap_8
XFILLER_18_401 VPWR VGND VPWR VGND sky130_ef_sc_hd__decap_12
XFILLER_93_42 VGND VGND VPWR VPWR sky130_fd_sc_hd__decap_4
XFILLER_13_150 VGND VGND VPWR VPWR sky130_fd_sc_hd__fill_1
XFILLER_20_109 VGND VGND VPWR VPWR sky130_fd_sc_hd__decap_8
XTAP_TAPCELL_ROW_31_627 VGND VPWR sky130_fd_sc_hd__tapvpwrvgnd_1
Xrebuffer2 _0464_ VGND VGND VPWR VPWR net517 sky130_fd_sc_hd__dlygate4sd1_1
XTAP_TAPCELL_ROW_11_384 VGND VPWR sky130_fd_sc_hd__tapvpwrvgnd_1
X_5250_ _0984_ _0781_ _0780_ _0983_ VGND VGND VPWR VPWR _0985_ sky130_fd_sc_hd__o31a_1
XFILLER_5_393 VPWR VGND VPWR VGND sky130_ef_sc_hd__decap_12
X_5181_ _0918_ _0917_ VGND VGND VPWR VPWR _0919_ sky130_fd_sc_hd__and2b_1
XFILLER_95_131 VGND VGND VPWR VPWR sky130_fd_sc_hd__fill_1
XFILLER_3_51 VGND VGND VPWR VPWR sky130_fd_sc_hd__decap_4
XFILLER_110_475 VGND VGND VPWR VPWR sky130_fd_sc_hd__fill_1
XFILLER_83_304 VPWR VGND VPWR VGND sky130_ef_sc_hd__decap_12
X_8940_ clknet_leaf_60_clk _0052_ VGND VGND VPWR VPWR pe_accum\[3\]\[8\] sky130_fd_sc_hd__dfxtp_1
XTAP_TAPCELL_ROW_39_716 VGND VPWR sky130_fd_sc_hd__tapvpwrvgnd_1
XFILLER_110_497 VPWR VGND VPWR VGND sky130_ef_sc_hd__decap_12
XFILLER_83_337 VGND VGND VPWR VPWR sky130_fd_sc_hd__fill_1
XTAP_TAPCELL_ROW_39_727 VGND VPWR sky130_fd_sc_hd__tapvpwrvgnd_1
X_8871_ net984 net212 _4216_ net383 VGND VGND VPWR VPWR _0425_ sky130_fd_sc_hd__o211a_1
X_7822_ net513 net504 net323 net325 VGND VGND VPWR VPWR _3222_ sky130_fd_sc_hd__and4_1
XTAP_TAPCELL_ROW_19_484 VGND VPWR sky130_fd_sc_hd__tapvpwrvgnd_1
X_7753_ net223 _2619_ VGND VGND VPWR VPWR _3186_ sky130_fd_sc_hd__nand2_2
X_4965_ _0707_ _0708_ _0668_ _0670_ VGND VGND VPWR VPWR _0710_ sky130_fd_sc_hd__a211o_4
X_6704_ net902 net236 _1779_ net244 VGND VGND VPWR VPWR _0274_ sky130_fd_sc_hd__o2bb2ai_1
X_4896_ net397 pe_array\[3\].u_pe.accum_reg\[12\] net255 _0642_ VGND VGND VPWR VPWR
+ _0643_ sky130_fd_sc_hd__o2bb2a_4
X_7684_ _3131_ VGND VGND VPWR VPWR _3132_ sky130_fd_sc_hd__inv_2
X_6635_ net172 _2116_ _2115_ VGND VGND VPWR VPWR _2151_ sky130_fd_sc_hd__a21oi_1
XFILLER_22_27 VGND VGND VPWR VPWR sky130_fd_sc_hd__fill_1
X_6566_ _2083_ _2082_ VGND VGND VPWR VPWR _2084_ sky130_fd_sc_hd__and2b_1
X_9285_ clknet_leaf_7_clk _0397_ VGND VGND VPWR VPWR pe_array\[2\].u_pe.accum_reg\[27\]
+ sky130_fd_sc_hd__dfxtp_1
X_8305_ _3689_ _3690_ _3649_ _3651_ VGND VGND VPWR VPWR _3692_ sky130_fd_sc_hd__a211oi_1
X_5517_ net250 _1037_ VGND VGND VPWR VPWR _1219_ sky130_fd_sc_hd__nand2_2
XFILLER_3_308 VGND VGND VPWR VPWR sky130_fd_sc_hd__decap_6
XTAP_TAPCELL_ROW_115_1637 VGND VPWR sky130_fd_sc_hd__tapvpwrvgnd_1
XFILLER_105_225 VPWR VGND VPWR VGND sky130_ef_sc_hd__decap_12
X_6497_ _2014_ _2015_ _1986_ _1988_ VGND VGND VPWR VPWR _2017_ sky130_fd_sc_hd__a211o_1
X_8236_ net311 net308 net440 VGND VGND VPWR VPWR _3624_ sky130_fd_sc_hd__o21ai_1
X_5448_ _1154_ _1153_ _1174_ _1151_ VGND VGND VPWR VPWR _1177_ sky130_fd_sc_hd__o211a_1
X_8167_ _3553_ _3554_ net683 VGND VGND VPWR VPWR _3557_ sky130_fd_sc_hd__o21ai_1
X_5379_ _1107_ _1108_ VGND VGND VPWR VPWR _1110_ sky130_fd_sc_hd__xor2_1
Xfanout155 _3700_ VGND VGND VPWR VPWR net155 sky130_fd_sc_hd__buf_4
X_8098_ _3404_ _3489_ VGND VGND VPWR VPWR _3490_ sky130_fd_sc_hd__and2_4
X_7118_ _2575_ _2581_ VGND VGND VPWR VPWR _2583_ sky130_fd_sc_hd__xnor2_1
Xfanout188 _3552_ VGND VGND VPWR VPWR net188 sky130_fd_sc_hd__buf_6
Xfanout199 _1568_ VGND VGND VPWR VPWR net199 sky130_fd_sc_hd__buf_6
Xfanout177 _1683_ VGND VGND VPWR VPWR net177 sky130_fd_sc_hd__clkbuf_4
Xfanout166 net167 VGND VGND VPWR VPWR net166 sky130_fd_sc_hd__clkbuf_4
X_7049_ _2497_ _2515_ _2513_ VGND VGND VPWR VPWR _2516_ sky130_fd_sc_hd__and3_4
XFILLER_101_486 VGND VGND VPWR VPWR sky130_fd_sc_hd__decap_3
XFILLER_86_197 VGND VGND VPWR VPWR sky130_fd_sc_hd__decap_8
XPHY_EDGE_ROW_29_Right_29 VGND VGND VPWR VPWR sky130_fd_sc_hd__decap_3
XFILLER_47_57 VPWR VGND VPWR VGND sky130_ef_sc_hd__decap_12
XFILLER_82_392 VGND VGND VPWR VPWR sky130_fd_sc_hd__fill_1
XFILLER_70_554 VGND VGND VPWR VPWR sky130_fd_sc_hd__decap_8
XFILLER_8_29 VPWR VGND VPWR VGND sky130_ef_sc_hd__decap_12
XPHY_EDGE_ROW_38_Right_38 VGND VGND VPWR VPWR sky130_fd_sc_hd__decap_3
XFILLER_10_153 VGND VGND VPWR VPWR sky130_fd_sc_hd__decap_3
XFILLER_10_197 VGND VGND VPWR VPWR sky130_fd_sc_hd__decap_6
XFILLER_88_97 VGND VGND VPWR VPWR sky130_fd_sc_hd__decap_6
XFILLER_78_610 VGND VGND VPWR VPWR sky130_fd_sc_hd__fill_1
XFILLER_104_291 VGND VGND VPWR VPWR sky130_fd_sc_hd__fill_1
XFILLER_78_632 VPWR VGND VPWR VGND sky130_ef_sc_hd__decap_12
XFILLER_77_142 VGND VGND VPWR VPWR sky130_fd_sc_hd__fill_2
XPHY_EDGE_ROW_47_Right_47 VGND VGND VPWR VPWR sky130_fd_sc_hd__decap_3
XFILLER_92_112 VGND VGND VPWR VPWR sky130_fd_sc_hd__fill_1
XFILLER_65_326 VGND VGND VPWR VPWR sky130_fd_sc_hd__decap_8
XFILLER_18_220 VPWR VGND VPWR VGND sky130_ef_sc_hd__decap_12
XFILLER_92_189 VGND VGND VPWR VPWR sky130_fd_sc_hd__fill_2
XFILLER_18_253 VPWR VGND VPWR VGND sky130_ef_sc_hd__decap_12
XTAP_TAPCELL_ROW_16_443 VGND VPWR sky130_fd_sc_hd__tapvpwrvgnd_1
XFILLER_33_278 VGND VGND VPWR VPWR sky130_fd_sc_hd__fill_2
XPHY_EDGE_ROW_56_Right_56 VGND VGND VPWR VPWR sky130_fd_sc_hd__decap_3
XFILLER_14_492 VGND VGND VPWR VPWR sky130_fd_sc_hd__decap_8
X_4750_ _0498_ _0499_ VGND VGND VPWR VPWR _0500_ sky130_fd_sc_hd__nor2_1
XTAP_TAPCELL_ROW_44_785 VGND VPWR sky130_fd_sc_hd__tapvpwrvgnd_1
X_4681_ _4436_ _4441_ VGND VGND VPWR VPWR _4442_ sky130_fd_sc_hd__nand2b_1
X_6420_ _1915_ _1942_ _1914_ VGND VGND VPWR VPWR _1943_ sky130_fd_sc_hd__nor3b_1
X_6351_ _1844_ _1845_ _1874_ _1875_ VGND VGND VPWR VPWR _1876_ sky130_fd_sc_hd__o211a_1
X_5302_ _1010_ _1008_ _1034_ VGND VGND VPWR VPWR _1036_ sky130_fd_sc_hd__nand3_4
X_6282_ net411 pe_array\[0\].u_pe.accum_reg\[17\] net240 _1809_ VGND VGND VPWR VPWR
+ _1810_ sky130_fd_sc_hd__o2bb2a_1
X_9070_ clknet_leaf_52_clk _0182_ VGND VGND VPWR VPWR net145 sky130_fd_sc_hd__dfxtp_1
X_8021_ _3345_ _3383_ _3384_ VGND VGND VPWR VPWR _3414_ sky130_fd_sc_hd__o21ba_1
XPHY_EDGE_ROW_65_Right_65 VGND VGND VPWR VPWR sky130_fd_sc_hd__decap_3
X_5233_ _0967_ _0968_ VGND VGND VPWR VPWR _0969_ sky130_fd_sc_hd__and2_1
X_5164_ pe_array\[3\].u_pe.accum_reg\[21\] net296 net434 VGND VGND VPWR VPWR _0902_
+ sky130_fd_sc_hd__and3_1
XTAP_TAPCELL_ROW_110_1578 VGND VPWR sky130_fd_sc_hd__tapvpwrvgnd_1
XFILLER_96_473 VGND VGND VPWR VPWR sky130_fd_sc_hd__decap_3
XFILLER_69_665 VGND VGND VPWR VPWR sky130_fd_sc_hd__decap_6
XFILLER_96_495 VGND VGND VPWR VPWR sky130_fd_sc_hd__decap_6
XFILLER_83_123 VGND VGND VPWR VPWR sky130_fd_sc_hd__decap_4
X_5095_ _0834_ _0835_ VGND VGND VPWR VPWR _0836_ sky130_fd_sc_hd__nor2_1
XFILLER_84_657 VGND VGND VPWR VPWR sky130_fd_sc_hd__decap_4
X_8923_ clknet_leaf_63_clk _0035_ VGND VGND VPWR VPWR pe_array\[3\].u_pe.accum_reg\[23\]
+ sky130_fd_sc_hd__dfxtp_1
XFILLER_83_167 VGND VGND VPWR VPWR sky130_fd_sc_hd__fill_1
X_8854_ net209 _3730_ VGND VGND VPWR VPWR _4208_ sky130_fd_sc_hd__nand2_1
X_7805_ net219 net508 pe_array\[2\].u_pe.tap_count\[0\] VGND VGND VPWR VPWR _3210_
+ sky130_fd_sc_hd__mux2_1
XTAP_TAPCELL_ROW_65_1035 VGND VPWR sky130_fd_sc_hd__tapvpwrvgnd_1
XFILLER_37_595 VGND VGND VPWR VPWR sky130_fd_sc_hd__fill_1
X_8785_ net421 _4156_ VGND VGND VPWR VPWR _0399_ sky130_fd_sc_hd__nor2_1
X_5997_ _1529_ _1530_ _1483_ _1484_ VGND VGND VPWR VPWR _1532_ sky130_fd_sc_hd__a211o_1
XPHY_EDGE_ROW_74_Right_74 VGND VGND VPWR VPWR sky130_fd_sc_hd__decap_3
X_7736_ net1012 net228 _3177_ net390 VGND VGND VPWR VPWR _0329_ sky130_fd_sc_hd__o211a_1
XFILLER_33_48 VGND VGND VPWR VPWR sky130_fd_sc_hd__decap_8
X_4948_ _0689_ _0690_ net284 VGND VGND VPWR VPWR _0693_ sky130_fd_sc_hd__o21ai_1
X_4879_ _0580_ _0583_ _0623_ _0625_ VGND VGND VPWR VPWR _0626_ sky130_fd_sc_hd__a211oi_1
X_7667_ net649 _3113_ VGND VGND VPWR VPWR _3115_ sky130_fd_sc_hd__xnor2_1
X_6618_ _2098_ _2100_ VGND VGND VPWR VPWR _2134_ sky130_fd_sc_hd__nor2_1
XFILLER_20_473 VGND VGND VPWR VPWR sky130_fd_sc_hd__decap_3
X_7598_ net550 net337 _3020_ _3018_ VGND VGND VPWR VPWR _3048_ sky130_fd_sc_hd__a31o_1
X_6549_ _2064_ _2065_ net276 VGND VGND VPWR VPWR _2067_ sky130_fd_sc_hd__o21a_1
XFILLER_106_545 VPWR VGND VPWR VGND sky130_ef_sc_hd__decap_12
XPHY_EDGE_ROW_83_Right_83 VGND VGND VPWR VPWR sky130_fd_sc_hd__decap_3
XTAP_TAPCELL_ROW_76_1164 VGND VPWR sky130_fd_sc_hd__tapvpwrvgnd_1
X_9268_ clknet_leaf_2_clk _0380_ VGND VGND VPWR VPWR pe_array\[2\].u_pe.accum_reg\[10\]
+ sky130_fd_sc_hd__dfxtp_1
XFILLER_106_589 VGND VGND VPWR VPWR sky130_fd_sc_hd__fill_1
X_8219_ _3563_ _3566_ _3605_ _3607_ VGND VGND VPWR VPWR _3608_ sky130_fd_sc_hd__a211oi_2
X_9199_ clknet_leaf_47_clk _0311_ VGND VGND VPWR VPWR pe_array\[1\].u_pe.accum_reg\[17\]
+ sky130_fd_sc_hd__dfxtp_1
XFILLER_59_164 VGND VGND VPWR VPWR sky130_fd_sc_hd__decap_4
XFILLER_47_304 VPWR VGND VPWR VGND sky130_ef_sc_hd__decap_12
XFILLER_74_123 VGND VGND VPWR VPWR sky130_fd_sc_hd__decap_4
XFILLER_74_101 VGND VGND VPWR VPWR sky130_fd_sc_hd__decap_3
XFILLER_47_337 VGND VGND VPWR VPWR sky130_fd_sc_hd__fill_1
XFILLER_47_359 VGND VGND VPWR VPWR sky130_fd_sc_hd__decap_3
XFILLER_15_201 VGND VGND VPWR VPWR sky130_fd_sc_hd__decap_8
XPHY_EDGE_ROW_92_Right_92 VGND VGND VPWR VPWR sky130_fd_sc_hd__decap_3
XTAP_TAPCELL_ROW_87_1293 VGND VPWR sky130_fd_sc_hd__tapvpwrvgnd_1
XFILLER_28_595 VGND VGND VPWR VPWR sky130_fd_sc_hd__decap_3
XFILLER_70_362 VGND VGND VPWR VPWR sky130_fd_sc_hd__fill_2
XFILLER_43_576 VGND VGND VPWR VPWR sky130_fd_sc_hd__decap_3
XFILLER_90_54 VGND VGND VPWR VPWR sky130_fd_sc_hd__decap_3
XTAP_TAPCELL_ROW_13_413 VGND VPWR sky130_fd_sc_hd__tapvpwrvgnd_1
XTAP_TAPCELL_ROW_41_744 VGND VPWR sky130_fd_sc_hd__tapvpwrvgnd_1
XFILLER_116_309 VGND VGND VPWR VPWR sky130_fd_sc_hd__decap_4
XFILLER_7_499 VGND VGND VPWR VPWR sky130_fd_sc_hd__decap_4
XFILLER_97_204 VGND VGND VPWR VPWR sky130_fd_sc_hd__fill_2
XFILLER_66_613 VPWR VGND VPWR VGND sky130_ef_sc_hd__decap_12
XFILLER_93_432 VPWR VGND VPWR VGND sky130_ef_sc_hd__decap_12
XFILLER_93_465 VPWR VGND VPWR VGND sky130_ef_sc_hd__decap_12
XFILLER_66_657 VPWR VGND VPWR VGND sky130_ef_sc_hd__decap_12
XFILLER_38_359 VGND VGND VPWR VPWR sky130_fd_sc_hd__decap_4
XTAP_TAPCELL_ROW_49_844 VGND VPWR sky130_fd_sc_hd__tapvpwrvgnd_1
XFILLER_93_487 VPWR VGND VPWR VGND sky130_ef_sc_hd__decap_12
X_5920_ _1454_ _1455_ _1421_ VGND VGND VPWR VPWR _1457_ sky130_fd_sc_hd__o21a_1
XFILLER_0_41 VPWR VGND VPWR VGND sky130_ef_sc_hd__decap_12
XFILLER_0_85 VPWR VGND VPWR VGND sky130_ef_sc_hd__decap_12
XFILLER_46_392 VGND VGND VPWR VPWR sky130_fd_sc_hd__decap_6
X_5851_ net467 net355 net352 net474 VGND VGND VPWR VPWR _1389_ sky130_fd_sc_hd__a22oi_1
X_8570_ net442 net315 pe_array\[2\].u_pe.accum_reg\[23\] VGND VGND VPWR VPWR _3948_
+ sky130_fd_sc_hd__a21oi_1
XPHY_EDGE_ROW_100_Right_100 VGND VGND VPWR VPWR sky130_fd_sc_hd__decap_3
X_5782_ pe_array\[0\].u_pe.accum_reg\[5\] net474 net358 VGND VGND VPWR VPWR _1322_
+ sky130_fd_sc_hd__and3_1
XFILLER_21_237 VGND VGND VPWR VPWR sky130_fd_sc_hd__decap_4
X_4802_ _0462_ _0463_ _0461_ VGND VGND VPWR VPWR _0551_ sky130_fd_sc_hd__a21o_1
XFILLER_34_598 VPWR VGND VPWR VGND sky130_ef_sc_hd__decap_12
XFILLER_9_72 VPWR VGND VPWR VGND sky130_ef_sc_hd__decap_12
X_7521_ net193 _2938_ _2937_ VGND VGND VPWR VPWR _2974_ sky130_fd_sc_hd__o21bai_1
X_4733_ net301 net461 pe_array\[3\].u_pe.accum_reg\[9\] VGND VGND VPWR VPWR _0483_
+ sky130_fd_sc_hd__a21oi_1
X_7452_ net268 _2904_ _2905_ VGND VGND VPWR VPWR _2907_ sky130_fd_sc_hd__or3_1
X_6403_ _1922_ _1923_ net279 VGND VGND VPWR VPWR _1926_ sky130_fd_sc_hd__o21ai_1
X_4664_ _4424_ _4425_ VGND VGND VPWR VPWR _4426_ sky130_fd_sc_hd__and2b_1
X_7383_ _2838_ _2839_ net168 VGND VGND VPWR VPWR _2841_ sky130_fd_sc_hd__a21o_1
X_4595_ _4324_ _4356_ VGND VGND VPWR VPWR _4358_ sky130_fd_sc_hd__or2_1
X_6334_ net171 _1858_ _1859_ VGND VGND VPWR VPWR _1860_ sky130_fd_sc_hd__nand3_1
X_9122_ clknet_leaf_18_clk _0234_ VGND VGND VPWR VPWR pe_array\[0\].u_pe.accum_reg\[8\]
+ sky130_fd_sc_hd__dfxtp_1
X_6265_ _1789_ _1790_ _1791_ VGND VGND VPWR VPWR _1793_ sky130_fd_sc_hd__a21oi_1
X_9053_ clknet_leaf_4_clk _0165_ VGND VGND VPWR VPWR net126 sky130_fd_sc_hd__dfxtp_1
XFILLER_1_609 VGND VGND VPWR VPWR sky130_fd_sc_hd__decap_6
XFILLER_103_548 VGND VGND VPWR VPWR sky130_fd_sc_hd__fill_2
X_8004_ _3362_ _3397_ VGND VGND VPWR VPWR _3398_ sky130_fd_sc_hd__xor2_1
X_5216_ net397 pe_array\[3\].u_pe.accum_reg\[22\] net255 _0952_ VGND VGND VPWR VPWR
+ _0953_ sky130_fd_sc_hd__o2bb2a_4
X_6196_ _1723_ _1722_ _1687_ _1688_ VGND VGND VPWR VPWR _1726_ sky130_fd_sc_hd__a211o_1
XFILLER_69_495 VGND VGND VPWR VPWR sky130_fd_sc_hd__decap_3
XFILLER_69_473 VGND VGND VPWR VPWR sky130_fd_sc_hd__decap_3
X_5147_ _0885_ _0884_ VGND VGND VPWR VPWR _0886_ sky130_fd_sc_hd__and2b_1
XFILLER_29_326 VGND VGND VPWR VPWR sky130_fd_sc_hd__decap_6
XFILLER_84_432 VGND VGND VPWR VPWR sky130_fd_sc_hd__fill_1
XFILLER_57_657 VPWR VGND VPWR VGND sky130_ef_sc_hd__decap_12
XFILLER_56_123 VPWR VGND VPWR VGND sky130_ef_sc_hd__decap_12
X_5078_ _0815_ _0816_ net282 VGND VGND VPWR VPWR _0819_ sky130_fd_sc_hd__o21ai_1
XFILLER_56_178 VGND VGND VPWR VPWR sky130_fd_sc_hd__fill_1
X_8906_ clknet_leaf_55_clk _0018_ VGND VGND VPWR VPWR pe_array\[3\].u_pe.accum_reg\[6\]
+ sky130_fd_sc_hd__dfxtp_1
XFILLER_72_649 VGND VGND VPWR VPWR sky130_fd_sc_hd__fill_1
XFILLER_37_370 VPWR VGND VPWR VGND sky130_ef_sc_hd__decap_12
X_8837_ net918 net213 _4199_ net385 VGND VGND VPWR VPWR _0408_ sky130_fd_sc_hd__o211a_1
X_8768_ net163 _4139_ VGND VGND VPWR VPWR _4140_ sky130_fd_sc_hd__nor2_1
XFILLER_25_587 VPWR VGND VPWR VGND sky130_ef_sc_hd__decap_12
X_7719_ _3139_ _3140_ net649 VGND VGND VPWR VPWR _3165_ sky130_fd_sc_hd__mux2_1
XFILLER_100_75 VGND VGND VPWR VPWR sky130_fd_sc_hd__fill_1
X_8699_ net188 _4072_ VGND VGND VPWR VPWR _4073_ sky130_fd_sc_hd__nor2_1
XFILLER_114_3 VPWR VGND VPWR VGND sky130_ef_sc_hd__decap_12
XFILLER_109_51 VGND VGND VPWR VPWR sky130_fd_sc_hd__decap_4
XFILLER_69_44 VGND VGND VPWR VPWR sky130_fd_sc_hd__decap_4
XFILLER_4_469 VGND VGND VPWR VPWR sky130_fd_sc_hd__decap_6
XFILLER_79_237 VPWR VGND VPWR VGND sky130_ef_sc_hd__decap_12
XTAP_TAPCELL_ROW_89_1322 VGND VPWR sky130_fd_sc_hd__tapvpwrvgnd_1
XFILLER_87_281 VGND VGND VPWR VPWR sky130_fd_sc_hd__decap_4
XFILLER_0_697 VGND VGND VPWR VPWR sky130_fd_sc_hd__decap_3
XFILLER_48_613 VPWR VGND VPWR VGND sky130_ef_sc_hd__decap_12
XFILLER_47_123 VGND VGND VPWR VPWR sky130_fd_sc_hd__decap_8
XFILLER_47_167 VGND VGND VPWR VPWR sky130_fd_sc_hd__fill_1
XTAP_TAPCELL_ROW_46_803 VGND VPWR sky130_fd_sc_hd__tapvpwrvgnd_1
XFILLER_90_446 VGND VGND VPWR VPWR sky130_fd_sc_hd__decap_8
XTAP_TAPCELL_ROW_26_560 VGND VPWR sky130_fd_sc_hd__tapvpwrvgnd_1
XTAP_TAPCELL_ROW_26_571 VGND VPWR sky130_fd_sc_hd__tapvpwrvgnd_1
XFILLER_11_281 VGND VGND VPWR VPWR sky130_fd_sc_hd__decap_3
XFILLER_117_629 VPWR VGND VPWR VGND sky130_ef_sc_hd__decap_12
XFILLER_7_252 VGND VGND VPWR VPWR sky130_fd_sc_hd__decap_4
XFILLER_109_180 VGND VGND VPWR VPWR sky130_fd_sc_hd__decap_3
XFILLER_112_345 VPWR VGND VPWR VGND sky130_ef_sc_hd__decap_12
X_6050_ _1537_ _1539_ _1582_ _1583_ VGND VGND VPWR VPWR _1584_ sky130_fd_sc_hd__o211a_1
XFILLER_38_101 VGND VGND VPWR VPWR sky130_fd_sc_hd__fill_1
X_5001_ _0742_ _0709_ _0743_ VGND VGND VPWR VPWR _0745_ sky130_fd_sc_hd__and3_4
XFILLER_39_613 VGND VGND VPWR VPWR sky130_fd_sc_hd__decap_3
XFILLER_39_624 VGND VGND VPWR VPWR sky130_fd_sc_hd__decap_8
XFILLER_39_635 VGND VGND VPWR VPWR sky130_fd_sc_hd__fill_2
XFILLER_93_240 VPWR VGND VPWR VGND sky130_ef_sc_hd__decap_12
XFILLER_26_329 VGND VGND VPWR VPWR sky130_fd_sc_hd__fill_1
X_6952_ _2418_ _2417_ _2419_ VGND VGND VPWR VPWR _2421_ sky130_fd_sc_hd__a21o_1
X_5903_ net454 net358 pe_array\[0\].u_pe.accum_reg\[8\] VGND VGND VPWR VPWR _1440_
+ sky130_fd_sc_hd__a21oi_1
X_6883_ net427 _2353_ VGND VGND VPWR VPWR _0300_ sky130_fd_sc_hd__nor2_1
X_8622_ _3998_ _3997_ VGND VGND VPWR VPWR _3999_ sky130_fd_sc_hd__and2b_1
X_5834_ _1371_ _1372_ VGND VGND VPWR VPWR _1373_ sky130_fd_sc_hd__and2b_1
XFILLER_62_682 VPWR VGND VPWR VGND sky130_ef_sc_hd__decap_12
XFILLER_61_192 VGND VGND VPWR VPWR sky130_fd_sc_hd__fill_1
X_8553_ _3929_ _3930_ net162 VGND VGND VPWR VPWR _3932_ sky130_fd_sc_hd__o21ai_1
X_5765_ _1280_ _1305_ VGND VGND VPWR VPWR _1306_ sky130_fd_sc_hd__or2_1
X_5696_ pe_array\[0\].u_pe.accum_reg\[0\] net513 net356 VGND VGND VPWR VPWR _1241_
+ sky130_fd_sc_hd__and3_1
X_8484_ net191 _3834_ _3832_ VGND VGND VPWR VPWR _3865_ sky130_fd_sc_hd__a21o_1
X_7504_ net407 pe_array\[1\].u_pe.accum_reg\[23\] net230 _2957_ VGND VGND VPWR VPWR
+ _2958_ sky130_fd_sc_hd__o2bb2a_4
X_4716_ net399 pe_array\[3\].u_pe.accum_reg\[8\] net257 _0466_ VGND VGND VPWR VPWR
+ _0467_ sky130_fd_sc_hd__o2bb2a_1
X_7435_ _2888_ _2889_ VGND VGND VPWR VPWR _2891_ sky130_fd_sc_hd__xnor2_1
X_4647_ _4370_ _4369_ _4407_ _4408_ VGND VGND VPWR VPWR _4409_ sky130_fd_sc_hd__a211o_1
X_7366_ pe_array\[1\].u_pe.accum_reg\[19\] net447 net340 VGND VGND VPWR VPWR _2824_
+ sky130_fd_sc_hd__and3_1
X_6317_ net456 net359 pe_array\[0\].u_pe.accum_reg\[19\] VGND VGND VPWR VPWR _1843_
+ sky130_fd_sc_hd__a21oi_1
X_9105_ clknet_leaf_1_clk _0217_ VGND VGND VPWR VPWR pe_array\[2\].u_pe.weight_in\[3\]
+ sky130_fd_sc_hd__dfxtp_1
X_4578_ _4341_ _4340_ _4339_ VGND VGND VPWR VPWR _4342_ sky130_fd_sc_hd__and3_4
XFILLER_89_557 VGND VGND VPWR VPWR sky130_fd_sc_hd__decap_3
XFILLER_89_524 VGND VGND VPWR VPWR sky130_fd_sc_hd__decap_6
XTAP_TAPCELL_ROW_73_1134 VGND VPWR sky130_fd_sc_hd__tapvpwrvgnd_1
X_7297_ _2689_ _2725_ VGND VGND VPWR VPWR _2758_ sky130_fd_sc_hd__nor2_1
X_6248_ _1740_ _1775_ VGND VGND VPWR VPWR _1777_ sky130_fd_sc_hd__xnor2_2
X_9036_ clknet_leaf_40_clk _0148_ VGND VGND VPWR VPWR net108 sky130_fd_sc_hd__dfxtp_1
X_6179_ _1708_ _1709_ VGND VGND VPWR VPWR _1710_ sky130_fd_sc_hd__nand2_1
XFILLER_39_69 VGND VGND VPWR VPWR sky130_fd_sc_hd__fill_2
XFILLER_69_281 VGND VGND VPWR VPWR sky130_fd_sc_hd__decap_4
XFILLER_29_123 VGND VGND VPWR VPWR sky130_fd_sc_hd__fill_2
XFILLER_84_251 VGND VGND VPWR VPWR sky130_fd_sc_hd__fill_1
XFILLER_72_413 VGND VGND VPWR VPWR sky130_fd_sc_hd__decap_6
XFILLER_57_476 VGND VGND VPWR VPWR sky130_fd_sc_hd__decap_6
XFILLER_57_465 VGND VGND VPWR VPWR sky130_fd_sc_hd__fill_2
XTAP_TAPCELL_ROW_4_299 VGND VPWR sky130_fd_sc_hd__tapvpwrvgnd_1
XFILLER_55_57 VPWR VGND VPWR VGND sky130_ef_sc_hd__decap_12
XFILLER_60_608 VPWR VGND VPWR VGND sky130_ef_sc_hd__decap_12
XTAP_TAPCELL_ROW_84_1263 VGND VPWR sky130_fd_sc_hd__tapvpwrvgnd_1
XFILLER_25_373 VPWR VGND VPWR VGND sky130_ef_sc_hd__decap_12
XFILLER_9_517 VPWR VGND VPWR VGND sky130_ef_sc_hd__decap_12
XFILLER_13_557 VGND VGND VPWR VPWR sky130_fd_sc_hd__decap_3
XTAP_TAPCELL_ROW_23_530 VGND VPWR sky130_fd_sc_hd__tapvpwrvgnd_1
XTAP_TAPCELL_ROW_51_861 VGND VPWR sky130_fd_sc_hd__tapvpwrvgnd_1
XFILLER_40_365 VGND VGND VPWR VPWR sky130_fd_sc_hd__decap_4
XFILLER_40_387 VGND VGND VPWR VPWR sky130_fd_sc_hd__decap_8
XFILLER_107_673 VPWR VGND VPWR VGND sky130_ef_sc_hd__decap_12
XFILLER_106_161 VGND VGND VPWR VPWR sky130_fd_sc_hd__fill_1
XTAP_TAPCELL_ROW_95_1392 VGND VPWR sky130_fd_sc_hd__tapvpwrvgnd_1
XFILLER_0_461 VPWR VGND VPWR VGND sky130_ef_sc_hd__decap_12
XFILLER_48_454 VGND VGND VPWR VPWR sky130_fd_sc_hd__decap_3
XTAP_TAPCELL_ROW_59_961 VGND VPWR sky130_fd_sc_hd__tapvpwrvgnd_1
X_5550_ net901 net392 VGND VGND VPWR VPWR _0091_ sky130_fd_sc_hd__and2_1
X_5481_ net253 _4431_ VGND VGND VPWR VPWR _1201_ sky130_fd_sc_hd__nand2_1
X_4501_ _4262_ _4263_ _4266_ VGND VGND VPWR VPWR _4268_ sky130_fd_sc_hd__o21ai_1
X_7220_ _2680_ _2681_ _2682_ VGND VGND VPWR VPWR _2683_ sky130_fd_sc_hd__and3_1
XFILLER_98_321 VPWR VGND VPWR VGND sky130_ef_sc_hd__decap_12
X_7151_ _2483_ _2527_ _2614_ _2613_ _2569_ VGND VGND VPWR VPWR _2616_ sky130_fd_sc_hd__o311a_1
XFILLER_113_665 VGND VGND VPWR VPWR sky130_fd_sc_hd__decap_6
XFILLER_98_365 VGND VGND VPWR VPWR sky130_fd_sc_hd__decap_4
X_6102_ _1590_ _1633_ VGND VGND VPWR VPWR _1635_ sky130_fd_sc_hd__xnor2_2
Xfanout507 net10 VGND VGND VPWR VPWR net507 sky130_fd_sc_hd__clkbuf_4
X_7082_ _2544_ net539 net551 VGND VGND VPWR VPWR _2548_ sky130_fd_sc_hd__o21ai_1
XFILLER_112_186 VGND VGND VPWR VPWR sky130_fd_sc_hd__fill_2
X_6033_ _1522_ _1524_ VGND VGND VPWR VPWR _1567_ sky130_fd_sc_hd__xnor2_2
XFILLER_94_571 VGND VGND VPWR VPWR sky130_fd_sc_hd__fill_1
XFILLER_54_402 VPWR VGND VPWR VGND sky130_ef_sc_hd__decap_12
Xrebuffer12 _2800_ VGND VGND VPWR VPWR net527 sky130_fd_sc_hd__buf_1
XTAP_TAPCELL_ROW_107_1539 VGND VPWR sky130_fd_sc_hd__tapvpwrvgnd_1
X_7984_ _3374_ _3375_ VGND VGND VPWR VPWR _3378_ sky130_fd_sc_hd__xnor2_1
Xrebuffer45 _3422_ VGND VGND VPWR VPWR net560 sky130_fd_sc_hd__dlygate4sd1_1
Xrebuffer23 _2562_ VGND VGND VPWR VPWR net538 sky130_fd_sc_hd__dlymetal6s4s_1
Xrebuffer34 _2463_ VGND VGND VPWR VPWR net549 sky130_fd_sc_hd__buf_6
Xrebuffer56 _3926_ VGND VGND VPWR VPWR net571 sky130_fd_sc_hd__dlymetal6s2s_1
Xrebuffer78 net2 VGND VGND VPWR VPWR net593 sky130_fd_sc_hd__dlygate4sd1_1
XTAP_TAPCELL_ROW_1_269 VGND VPWR sky130_fd_sc_hd__tapvpwrvgnd_1
Xrebuffer67 _4293_ VGND VGND VPWR VPWR net582 sky130_fd_sc_hd__dlymetal6s2s_1
X_6935_ _2398_ _2403_ VGND VGND VPWR VPWR _2404_ sky130_fd_sc_hd__nand2b_1
Xrebuffer89 _3931_ VGND VGND VPWR VPWR net604 sky130_fd_sc_hd__buf_1
XTAP_TAPCELL_ROW_37_699 VGND VPWR sky130_fd_sc_hd__tapvpwrvgnd_1
X_6866_ _2329_ _2335_ _2336_ VGND VGND VPWR VPWR _2337_ sky130_fd_sc_hd__nand3_1
Xclkbuf_leaf_61_clk clknet_3_0__leaf_clk VGND VGND VPWR VPWR clknet_leaf_61_clk sky130_fd_sc_hd__clkbuf_8
XFILLER_22_321 VGND VGND VPWR VPWR sky130_fd_sc_hd__fill_2
X_8605_ _3976_ _3882_ VGND VGND VPWR VPWR _3982_ sky130_fd_sc_hd__nand2b_1
X_5817_ _1351_ _1355_ VGND VGND VPWR VPWR _1356_ sky130_fd_sc_hd__xnor2_1
X_6797_ _2262_ _2268_ _2269_ VGND VGND VPWR VPWR _2270_ sky130_fd_sc_hd__nand3_1
XFILLER_22_365 VPWR VGND VPWR VGND sky130_ef_sc_hd__decap_12
X_8536_ _3913_ _3914_ VGND VGND VPWR VPWR _3916_ sky130_fd_sc_hd__xor2_4
X_5748_ net496 net353 net351 net505 VGND VGND VPWR VPWR _1289_ sky130_fd_sc_hd__a22oi_1
Xrebuffer113 _0985_ VGND VGND VPWR VPWR net628 sky130_fd_sc_hd__clkbuf_2
XFILLER_41_15 VPWR VGND VPWR VGND sky130_ef_sc_hd__decap_12
Xrebuffer124 net445 VGND VGND VPWR VPWR net639 sky130_fd_sc_hd__buf_6
X_8467_ _3846_ _3847_ VGND VGND VPWR VPWR _3849_ sky130_fd_sc_hd__xor2_1
X_5679_ net17 _1230_ _1231_ net312 VGND VGND VPWR VPWR _0218_ sky130_fd_sc_hd__a22o_1
X_8398_ _3778_ _3779_ _3780_ VGND VGND VPWR VPWR _3782_ sky130_fd_sc_hd__a21oi_1
X_7418_ _2817_ _2847_ VGND VGND VPWR VPWR _2875_ sky130_fd_sc_hd__nand2b_4
XFILLER_89_332 VGND VGND VPWR VPWR sky130_fd_sc_hd__decap_4
X_7349_ net165 _2779_ _2778_ VGND VGND VPWR VPWR _2808_ sky130_fd_sc_hd__o21bai_1
XTAP_TAPCELL_ROW_9_358 VGND VPWR sky130_fd_sc_hd__tapvpwrvgnd_1
XFILLER_104_643 VGND VGND VPWR VPWR sky130_fd_sc_hd__fill_1
XFILLER_1_247 VGND VGND VPWR VPWR sky130_fd_sc_hd__decap_3
XFILLER_106_41 VPWR VGND VPWR VGND sky130_ef_sc_hd__decap_12
XFILLER_103_175 VPWR VGND VPWR VGND sky130_ef_sc_hd__decap_12
X_9019_ clknet_leaf_47_clk _0131_ VGND VGND VPWR VPWR net89 sky130_fd_sc_hd__dfxtp_1
XFILLER_106_85 VGND VGND VPWR VPWR sky130_fd_sc_hd__decap_8
XFILLER_66_78 VGND VGND VPWR VPWR sky130_fd_sc_hd__decap_6
XFILLER_85_582 VGND VGND VPWR VPWR sky130_fd_sc_hd__fill_1
XFILLER_72_210 VGND VGND VPWR VPWR sky130_fd_sc_hd__decap_3
XTAP_TAPCELL_ROW_56_931 VGND VPWR sky130_fd_sc_hd__tapvpwrvgnd_1
XTAP_TAPCELL_ROW_56_920 VGND VPWR sky130_fd_sc_hd__tapvpwrvgnd_1
XFILLER_45_424 VGND VGND VPWR VPWR sky130_fd_sc_hd__fill_1
XFILLER_82_66 VGND VGND VPWR VPWR sky130_fd_sc_hd__decap_6
XFILLER_72_287 VGND VGND VPWR VPWR sky130_fd_sc_hd__decap_8
XFILLER_72_265 VGND VGND VPWR VPWR sky130_fd_sc_hd__decap_8
Xclkbuf_leaf_52_clk clknet_3_0__leaf_clk VGND VGND VPWR VPWR clknet_leaf_52_clk sky130_fd_sc_hd__clkbuf_8
XFILLER_41_641 VGND VGND VPWR VPWR sky130_fd_sc_hd__decap_4
XFILLER_9_358 VGND VGND VPWR VPWR sky130_fd_sc_hd__decap_6
XTAP_TAPCELL_ROW_97_1421 VGND VPWR sky130_fd_sc_hd__tapvpwrvgnd_1
XFILLER_99_118 VGND VGND VPWR VPWR sky130_fd_sc_hd__decap_6
XFILLER_5_586 VPWR VGND VPWR VGND sky130_ef_sc_hd__decap_12
Xoutput70 net70 VGND VGND VPWR VPWR result_data[28] sky130_fd_sc_hd__buf_2
XFILLER_110_624 VPWR VGND VPWR VGND sky130_ef_sc_hd__decap_12
XFILLER_68_538 VPWR VGND VPWR VGND sky130_ef_sc_hd__decap_12
Xoutput81 net81 VGND VGND VPWR VPWR result_data[38] sky130_fd_sc_hd__buf_2
Xoutput92 net92 VGND VGND VPWR VPWR result_data[48] sky130_fd_sc_hd__buf_2
XFILLER_110_657 VPWR VGND VPWR VGND sky130_ef_sc_hd__decap_12
XFILLER_48_240 VGND VGND VPWR VPWR sky130_fd_sc_hd__fill_2
XFILLER_63_221 VGND VGND VPWR VPWR sky130_fd_sc_hd__decap_3
XFILLER_63_287 VGND VGND VPWR VPWR sky130_fd_sc_hd__fill_1
X_4981_ _0690_ _0691_ _0723_ _0724_ VGND VGND VPWR VPWR _0725_ sky130_fd_sc_hd__o211a_1
X_6720_ net242 _2199_ _2198_ _2201_ VGND VGND VPWR VPWR _0289_ sky130_fd_sc_hd__o31ai_1
XTAP_TAPCELL_ROW_34_658 VGND VPWR sky130_fd_sc_hd__tapvpwrvgnd_1
X_6651_ _2130_ _2131_ _2164_ VGND VGND VPWR VPWR _2166_ sky130_fd_sc_hd__o21ai_1
XFILLER_32_663 VGND VGND VPWR VPWR sky130_fd_sc_hd__decap_6
X_6582_ pe_array\[0\].u_pe.accum_reg\[28\] _1393_ VGND VGND VPWR VPWR _2099_ sky130_fd_sc_hd__nor2_1
X_5602_ net974 net376 VGND VGND VPWR VPWR _0143_ sky130_fd_sc_hd__and2_1
XFILLER_31_162 VGND VGND VPWR VPWR sky130_fd_sc_hd__fill_2
X_8321_ _3703_ _3704_ net684 VGND VGND VPWR VPWR _3707_ sky130_fd_sc_hd__o21ai_1
X_5533_ net418 _1226_ VGND VGND VPWR VPWR _1227_ sky130_fd_sc_hd__nor2_2
XFILLER_8_391 VPWR VGND VPWR VGND sky130_ef_sc_hd__decap_12
XFILLER_117_245 VGND VGND VPWR VPWR sky130_fd_sc_hd__decap_3
X_8252_ _3592_ _3594_ _3637_ _3638_ VGND VGND VPWR VPWR _3640_ sky130_fd_sc_hd__o211ai_1
X_5464_ _1180_ _1191_ VGND VGND VPWR VPWR _1192_ sky130_fd_sc_hd__xnor2_1
XFILLER_99_630 VGND VGND VPWR VPWR sky130_fd_sc_hd__decap_3
X_8183_ _3570_ _3571_ _3524_ _3526_ VGND VGND VPWR VPWR _3573_ sky130_fd_sc_hd__o211ai_2
X_5395_ net399 pe_array\[3\].u_pe.accum_reg\[28\] net258 _1125_ VGND VGND VPWR VPWR
+ _1126_ sky130_fd_sc_hd__o2bb2a_4
X_7203_ _2626_ _2663_ _2664_ _2665_ VGND VGND VPWR VPWR _2666_ sky130_fd_sc_hd__a211oi_2
XFILLER_99_663 VGND VGND VPWR VPWR sky130_fd_sc_hd__fill_1
Xfanout304 pe_array\[3\].u_pe.weight_in\[1\] VGND VGND VPWR VPWR net304 sky130_fd_sc_hd__buf_2
X_7134_ _2585_ _2597_ _2598_ VGND VGND VPWR VPWR _2599_ sky130_fd_sc_hd__and3_1
XFILLER_113_473 VGND VGND VPWR VPWR sky130_fd_sc_hd__decap_4
XFILLER_101_613 VGND VGND VPWR VPWR sky130_fd_sc_hd__decap_3
Xfanout315 net316 VGND VGND VPWR VPWR net315 sky130_fd_sc_hd__clkbuf_2
Xfanout348 pe_array\[0\].u_pe.weight_in\[4\] VGND VGND VPWR VPWR net348 sky130_fd_sc_hd__buf_2
Xfanout337 pe_array\[1\].u_pe.weight_in\[1\] VGND VGND VPWR VPWR net337 sky130_fd_sc_hd__clkbuf_2
XTAP_TAPCELL_ROW_6_328 VGND VPWR sky130_fd_sc_hd__tapvpwrvgnd_1
Xfanout326 pe_array\[1\].u_pe.weight_in\[6\] VGND VGND VPWR VPWR net326 sky130_fd_sc_hd__clkbuf_2
XFILLER_98_195 VGND VGND VPWR VPWR sky130_fd_sc_hd__fill_1
Xfanout359 net362 VGND VGND VPWR VPWR net359 sky130_fd_sc_hd__clkbuf_2
X_7065_ _2490_ _2492_ _2489_ VGND VGND VPWR VPWR _2531_ sky130_fd_sc_hd__a21oi_1
X_6016_ _1459_ _1460_ _1503_ _1504_ VGND VGND VPWR VPWR _1551_ sky130_fd_sc_hd__o31a_1
XFILLER_39_262 VGND VGND VPWR VPWR sky130_fd_sc_hd__fill_2
XFILLER_54_221 VPWR VGND VPWR VGND sky130_ef_sc_hd__decap_12
X_7967_ _3320_ _3356_ _3358_ _3324_ VGND VGND VPWR VPWR _3361_ sky130_fd_sc_hd__a2bb2o_2
XFILLER_82_585 VGND VGND VPWR VPWR sky130_fd_sc_hd__decap_3
XTAP_TAPCELL_ROW_68_1066 VGND VPWR sky130_fd_sc_hd__tapvpwrvgnd_1
X_7898_ _3291_ _3292_ net485 net320 VGND VGND VPWR VPWR _3294_ sky130_fd_sc_hd__or4bb_4
XTAP_TAPCELL_ROW_81_1222 VGND VPWR sky130_fd_sc_hd__tapvpwrvgnd_1
X_6918_ _2387_ _2354_ VGND VGND VPWR VPWR _2388_ sky130_fd_sc_hd__xnor2_2
X_6849_ _4228_ _4233_ _2319_ VGND VGND VPWR VPWR _2320_ sky130_fd_sc_hd__or3_1
XFILLER_23_663 VGND VGND VPWR VPWR sky130_fd_sc_hd__fill_1
X_8519_ net191 _3862_ _3860_ VGND VGND VPWR VPWR _3899_ sky130_fd_sc_hd__a21o_1
XFILLER_108_267 VGND VGND VPWR VPWR sky130_fd_sc_hd__fill_1
XFILLER_108_245 VGND VGND VPWR VPWR sky130_fd_sc_hd__decap_6
XTAP_TAPCELL_ROW_92_1362 VGND VPWR sky130_fd_sc_hd__tapvpwrvgnd_1
XFILLER_77_11 VGND VGND VPWR VPWR sky130_fd_sc_hd__decap_8
Xhold380 pe_accum\[0\]\[13\] VGND VGND VPWR VPWR net895 sky130_fd_sc_hd__dlygate4sd3_1
XFILLER_7_3 VPWR VGND VPWR VGND sky130_ef_sc_hd__decap_12
Xhold391 pe_accum\[0\]\[22\] VGND VGND VPWR VPWR net906 sky130_fd_sc_hd__dlygate4sd3_1
XFILLER_89_162 VGND VGND VPWR VPWR sky130_fd_sc_hd__decap_6
XFILLER_2_589 VPWR VGND VPWR VGND sky130_ef_sc_hd__decap_12
XFILLER_77_335 VGND VGND VPWR VPWR sky130_fd_sc_hd__fill_1
XFILLER_92_349 VGND VGND VPWR VPWR sky130_fd_sc_hd__fill_1
XFILLER_18_413 VGND VGND VPWR VPWR sky130_fd_sc_hd__decap_6
Xclkbuf_leaf_25_clk clknet_3_7__leaf_clk VGND VGND VPWR VPWR clknet_leaf_25_clk sky130_fd_sc_hd__clkbuf_8
XFILLER_14_663 VGND VGND VPWR VPWR sky130_fd_sc_hd__fill_1
XFILLER_9_111 VGND VGND VPWR VPWR sky130_fd_sc_hd__fill_1
XTAP_TAPCELL_ROW_31_628 VGND VPWR sky130_fd_sc_hd__tapvpwrvgnd_1
XFILLER_13_195 VGND VGND VPWR VPWR sky130_fd_sc_hd__fill_1
Xrebuffer3 _2472_ VGND VGND VPWR VPWR net518 sky130_fd_sc_hd__dlymetal6s2s_1
XTAP_TAPCELL_ROW_11_385 VGND VPWR sky130_fd_sc_hd__tapvpwrvgnd_1
X_5180_ net178 _0887_ _0886_ VGND VGND VPWR VPWR _0918_ sky130_fd_sc_hd__a21oi_2
XFILLER_110_421 VGND VGND VPWR VPWR sky130_fd_sc_hd__decap_8
XFILLER_95_121 VGND VGND VPWR VPWR sky130_fd_sc_hd__fill_1
XFILLER_68_346 VGND VGND VPWR VPWR sky130_fd_sc_hd__fill_2
XFILLER_110_443 VPWR VGND VPWR VGND sky130_ef_sc_hd__decap_12
XFILLER_96_699 VGND VGND VPWR VPWR sky130_fd_sc_hd__fill_1
XTAP_TAPCELL_ROW_39_717 VGND VPWR sky130_fd_sc_hd__tapvpwrvgnd_1
XFILLER_95_187 VGND VGND VPWR VPWR sky130_fd_sc_hd__fill_2
XFILLER_83_316 VGND VGND VPWR VPWR sky130_fd_sc_hd__decap_8
X_8870_ _3974_ net212 VGND VGND VPWR VPWR _4216_ sky130_fd_sc_hd__nand2_1
XFILLER_76_390 VGND VGND VPWR VPWR sky130_fd_sc_hd__fill_2
XFILLER_36_232 VGND VGND VPWR VPWR sky130_fd_sc_hd__fill_1
X_7821_ net513 net323 net325 net504 VGND VGND VPWR VPWR _3221_ sky130_fd_sc_hd__a22o_1
XFILLER_64_574 VPWR VGND VPWR VGND sky130_ef_sc_hd__decap_12
XFILLER_91_393 VGND VGND VPWR VPWR sky130_fd_sc_hd__fill_1
XFILLER_91_382 VGND VGND VPWR VPWR sky130_fd_sc_hd__fill_2
XTAP_TAPCELL_ROW_19_485 VGND VPWR sky130_fd_sc_hd__tapvpwrvgnd_1
X_7752_ net976 net228 _3185_ net376 VGND VGND VPWR VPWR _0337_ sky130_fd_sc_hd__o211a_1
X_4964_ _0668_ _0670_ _0707_ _0708_ VGND VGND VPWR VPWR _0709_ sky130_fd_sc_hd__o211a_4
X_6703_ net244 _1744_ net236 net893 VGND VGND VPWR VPWR _0273_ sky130_fd_sc_hd__a2bb2o_1
XFILLER_51_279 VGND VGND VPWR VPWR sky130_fd_sc_hd__fill_1
XFILLER_20_611 VGND VGND VPWR VPWR sky130_fd_sc_hd__fill_1
X_4895_ _0640_ _0641_ VGND VGND VPWR VPWR _0642_ sky130_fd_sc_hd__nand2b_4
X_7683_ _3096_ _3129_ VGND VGND VPWR VPWR _3131_ sky130_fd_sc_hd__nand2_1
X_6634_ _2148_ _2149_ VGND VGND VPWR VPWR _2150_ sky130_fd_sc_hd__nor2_1
XFILLER_20_666 VPWR VGND VPWR VGND sky130_ef_sc_hd__decap_12
X_6565_ net172 _2054_ _2052_ VGND VGND VPWR VPWR _2083_ sky130_fd_sc_hd__a21oi_1
XFILLER_20_699 VGND VGND VPWR VPWR sky130_fd_sc_hd__fill_1
X_9284_ clknet_leaf_7_clk _0396_ VGND VGND VPWR VPWR pe_array\[2\].u_pe.accum_reg\[26\]
+ sky130_fd_sc_hd__dfxtp_1
X_6496_ _1986_ _1988_ _2014_ _2015_ VGND VGND VPWR VPWR _2016_ sky130_fd_sc_hd__o211a_1
X_8304_ _3649_ _3651_ _3689_ _3690_ VGND VGND VPWR VPWR _3691_ sky130_fd_sc_hd__o211a_1
X_5516_ net982 net247 _1218_ net365 VGND VGND VPWR VPWR _0068_ sky130_fd_sc_hd__o211a_1
XTAP_TAPCELL_ROW_115_1638 VGND VPWR sky130_fd_sc_hd__tapvpwrvgnd_1
X_8235_ net419 _3623_ VGND VGND VPWR VPWR _0382_ sky130_fd_sc_hd__nor2_1
X_5447_ _1120_ _1152_ _1123_ _1175_ _1150_ VGND VGND VPWR VPWR _1176_ sky130_fd_sc_hd__o311a_1
XFILLER_105_237 VGND VGND VPWR VPWR sky130_fd_sc_hd__fill_2
X_8166_ net260 _3553_ _3554_ VGND VGND VPWR VPWR _3556_ sky130_fd_sc_hd__or3_4
X_5378_ _1108_ _1107_ VGND VGND VPWR VPWR _1109_ sky130_fd_sc_hd__and2b_1
XFILLER_113_270 VGND VGND VPWR VPWR sky130_fd_sc_hd__decap_8
X_8097_ _3447_ _3488_ VGND VGND VPWR VPWR _3489_ sky130_fd_sc_hd__and2_1
X_7117_ _2576_ _2581_ VGND VGND VPWR VPWR _2582_ sky130_fd_sc_hd__nand2_1
Xfanout156 _2698_ VGND VGND VPWR VPWR net156 sky130_fd_sc_hd__buf_4
Xfanout189 net190 VGND VGND VPWR VPWR net189 sky130_fd_sc_hd__buf_2
Xfanout167 _2701_ VGND VGND VPWR VPWR net167 sky130_fd_sc_hd__clkbuf_4
Xfanout178 net179 VGND VGND VPWR VPWR net178 sky130_fd_sc_hd__clkbuf_4
X_7048_ _2511_ _2510_ _2512_ VGND VGND VPWR VPWR _2515_ sky130_fd_sc_hd__a21o_1
XPHY_EDGE_ROW_114_Right_114 VGND VGND VPWR VPWR sky130_fd_sc_hd__decap_3
XFILLER_47_69 VPWR VGND VPWR VGND sky130_ef_sc_hd__decap_12
XFILLER_27_232 VGND VGND VPWR VPWR sky130_fd_sc_hd__fill_1
X_8999_ clknet_leaf_22_clk _0111_ VGND VGND VPWR VPWR net67 sky130_fd_sc_hd__dfxtp_1
XFILLER_15_405 VPWR VGND VPWR VGND sky130_ef_sc_hd__decap_12
XFILLER_63_57 VPWR VGND VPWR VGND sky130_ef_sc_hd__decap_12
XFILLER_15_449 VPWR VGND VPWR VGND sky130_ef_sc_hd__decap_12
XFILLER_70_577 VGND VGND VPWR VPWR sky130_fd_sc_hd__decap_8
XFILLER_70_566 VGND VGND VPWR VPWR sky130_fd_sc_hd__fill_1
XFILLER_30_408 VPWR VGND VPWR VGND sky130_ef_sc_hd__decap_12
XFILLER_88_76 VGND VGND VPWR VPWR sky130_fd_sc_hd__decap_8
XFILLER_2_397 VPWR VGND VPWR VGND sky130_ef_sc_hd__decap_12
XFILLER_93_614 VGND VGND VPWR VPWR sky130_fd_sc_hd__fill_2
XFILLER_78_699 VGND VGND VPWR VPWR sky130_fd_sc_hd__fill_1
XFILLER_77_187 VGND VGND VPWR VPWR sky130_fd_sc_hd__fill_1
XFILLER_93_669 VGND VGND VPWR VPWR sky130_fd_sc_hd__decap_3
XFILLER_18_232 VPWR VGND VPWR VGND sky130_ef_sc_hd__decap_12
XFILLER_18_265 VGND VGND VPWR VPWR sky130_fd_sc_hd__decap_4
XFILLER_73_393 VGND VGND VPWR VPWR sky130_fd_sc_hd__decap_3
XTAP_TAPCELL_ROW_16_444 VGND VPWR sky130_fd_sc_hd__tapvpwrvgnd_1
XTAP_TAPCELL_ROW_44_786 VGND VPWR sky130_fd_sc_hd__tapvpwrvgnd_1
X_4680_ _4439_ _4440_ VGND VGND VPWR VPWR _4441_ sky130_fd_sc_hd__xor2_1
X_6350_ _1871_ _1872_ net279 VGND VGND VPWR VPWR _1875_ sky130_fd_sc_hd__o21ai_1
X_5301_ _1010_ _1008_ _1034_ VGND VGND VPWR VPWR _1035_ sky130_fd_sc_hd__a21o_1
XFILLER_6_681 VPWR VGND VPWR VGND sky130_ef_sc_hd__decap_12
X_6281_ _1807_ _1808_ VGND VGND VPWR VPWR _1809_ sky130_fd_sc_hd__xnor2_1
Xclkbuf_leaf_5_clk clknet_3_4__leaf_clk VGND VGND VPWR VPWR clknet_leaf_5_clk sky130_fd_sc_hd__clkbuf_8
X_8020_ _3406_ _3411_ VGND VGND VPWR VPWR _3413_ sky130_fd_sc_hd__xor2_1
X_5232_ net186 _0937_ _0936_ VGND VGND VPWR VPWR _0968_ sky130_fd_sc_hd__a21o_1
X_5163_ net296 net434 pe_array\[3\].u_pe.accum_reg\[21\] VGND VGND VPWR VPWR _0901_
+ sky130_fd_sc_hd__a21oi_1
XTAP_TAPCELL_ROW_110_1579 VGND VPWR sky130_fd_sc_hd__tapvpwrvgnd_1
XTAP_TAPCELL_ROW_110_1568 VGND VPWR sky130_fd_sc_hd__tapvpwrvgnd_1
XFILLER_96_485 VGND VGND VPWR VPWR sky130_fd_sc_hd__decap_3
X_5094_ _0802_ _0804_ VGND VGND VPWR VPWR _0835_ sky130_fd_sc_hd__and2_4
X_8922_ clknet_leaf_64_clk _0034_ VGND VGND VPWR VPWR pe_array\[3\].u_pe.accum_reg\[22\]
+ sky130_fd_sc_hd__dfxtp_1
X_8853_ net987 net209 _4207_ net382 VGND VGND VPWR VPWR _0416_ sky130_fd_sc_hd__o211a_1
X_7804_ net508 _3208_ VGND VGND VPWR VPWR _3209_ sky130_fd_sc_hd__nand2_2
XTAP_TAPCELL_ROW_65_1036 VGND VPWR sky130_fd_sc_hd__tapvpwrvgnd_1
XFILLER_52_533 VPWR VGND VPWR VGND sky130_ef_sc_hd__decap_12
XFILLER_24_213 VGND VGND VPWR VPWR sky130_fd_sc_hd__fill_2
XFILLER_24_235 VGND VGND VPWR VPWR sky130_fd_sc_hd__fill_1
X_8784_ net403 pe_array\[2\].u_pe.accum_reg\[29\] net220 _4155_ VGND VGND VPWR VPWR
+ _4156_ sky130_fd_sc_hd__o2bb2a_4
X_5996_ _1483_ _1484_ _1529_ _1530_ VGND VGND VPWR VPWR _1531_ sky130_fd_sc_hd__o211ai_2
X_7735_ net224 _2256_ VGND VGND VPWR VPWR _3177_ sky130_fd_sc_hd__nand2_1
X_4947_ net283 _0689_ _0690_ VGND VGND VPWR VPWR _0692_ sky130_fd_sc_hd__or3_4
X_4878_ _0621_ _0622_ _0609_ VGND VGND VPWR VPWR _0625_ sky130_fd_sc_hd__a21oi_1
X_7666_ net197 _3113_ VGND VGND VPWR VPWR _3114_ sky130_fd_sc_hd__nand2_1
X_6617_ _2131_ _2132_ VGND VGND VPWR VPWR _2133_ sky130_fd_sc_hd__nor2_1
X_7597_ _3045_ _3046_ VGND VGND VPWR VPWR _3047_ sky130_fd_sc_hd__nor2_1
X_6548_ net276 _2064_ _2065_ VGND VGND VPWR VPWR _2066_ sky130_fd_sc_hd__nor3_1
X_6479_ _1962_ _1964_ _1998_ VGND VGND VPWR VPWR _2000_ sky130_fd_sc_hd__nor3_1
XFILLER_106_557 VPWR VGND VPWR VGND sky130_ef_sc_hd__decap_12
XTAP_TAPCELL_ROW_76_1165 VGND VPWR sky130_fd_sc_hd__tapvpwrvgnd_1
X_9267_ clknet_leaf_2_clk _0379_ VGND VGND VPWR VPWR pe_array\[2\].u_pe.accum_reg\[9\]
+ sky130_fd_sc_hd__dfxtp_1
XPHY_EDGE_ROW_18_Left_136 VGND VGND VPWR VPWR sky130_fd_sc_hd__decap_3
X_8218_ _3603_ _3604_ _3591_ VGND VGND VPWR VPWR _3607_ sky130_fd_sc_hd__a21oi_1
X_9198_ clknet_leaf_48_clk _0310_ VGND VGND VPWR VPWR pe_array\[1\].u_pe.accum_reg\[16\]
+ sky130_fd_sc_hd__dfxtp_1
X_8149_ net476 _4238_ VGND VGND VPWR VPWR _3539_ sky130_fd_sc_hd__or2_1
XFILLER_114_41 VPWR VGND VPWR VGND sky130_ef_sc_hd__decap_12
XFILLER_47_316 VGND VGND VPWR VPWR sky130_fd_sc_hd__fill_2
XFILLER_114_85 VPWR VGND VPWR VGND sky130_ef_sc_hd__decap_12
XFILLER_90_628 VGND VGND VPWR VPWR sky130_fd_sc_hd__decap_3
XPHY_EDGE_ROW_27_Left_145 VGND VGND VPWR VPWR sky130_fd_sc_hd__decap_3
XTAP_TAPCELL_ROW_87_1294 VGND VPWR sky130_fd_sc_hd__tapvpwrvgnd_1
XFILLER_55_393 VGND VGND VPWR VPWR sky130_fd_sc_hd__decap_6
XTAP_TAPCELL_ROW_13_414 VGND VPWR sky130_fd_sc_hd__tapvpwrvgnd_1
XFILLER_15_279 VGND VGND VPWR VPWR sky130_fd_sc_hd__fill_1
XFILLER_11_441 VGND VGND VPWR VPWR sky130_fd_sc_hd__decap_6
XTAP_TAPCELL_ROW_41_745 VGND VPWR sky130_fd_sc_hd__tapvpwrvgnd_1
XPHY_EDGE_ROW_36_Left_154 VGND VGND VPWR VPWR sky130_fd_sc_hd__decap_3
XFILLER_3_673 VPWR VGND VPWR VGND sky130_ef_sc_hd__decap_12
XFILLER_66_625 VPWR VGND VPWR VGND sky130_ef_sc_hd__decap_12
XFILLER_65_113 VGND VGND VPWR VPWR sky130_fd_sc_hd__decap_3
Xclone233 _0686_ VGND VGND VPWR VPWR net748 sky130_fd_sc_hd__clkbuf_1
XFILLER_93_444 VGND VGND VPWR VPWR sky130_fd_sc_hd__fill_1
XFILLER_66_669 VPWR VGND VPWR VGND sky130_ef_sc_hd__decap_12
XFILLER_19_541 VPWR VGND VPWR VGND sky130_ef_sc_hd__decap_12
XFILLER_38_338 VGND VGND VPWR VPWR sky130_fd_sc_hd__decap_4
XPHY_EDGE_ROW_45_Left_163 VGND VGND VPWR VPWR sky130_fd_sc_hd__decap_3
XTAP_TAPCELL_ROW_49_845 VGND VPWR sky130_fd_sc_hd__tapvpwrvgnd_1
XFILLER_93_499 VGND VGND VPWR VPWR sky130_fd_sc_hd__decap_4
XFILLER_93_477 VGND VGND VPWR VPWR sky130_fd_sc_hd__fill_1
XFILLER_81_628 VPWR VGND VPWR VGND sky130_ef_sc_hd__decap_12
XFILLER_81_617 VGND VGND VPWR VPWR sky130_fd_sc_hd__fill_2
XFILLER_0_53 VGND VGND VPWR VPWR sky130_fd_sc_hd__decap_3
XFILLER_19_585 VGND VGND VPWR VPWR sky130_fd_sc_hd__fill_1
XFILLER_34_533 VGND VGND VPWR VPWR sky130_fd_sc_hd__fill_1
X_5850_ _1347_ _1386_ VGND VGND VPWR VPWR _1388_ sky130_fd_sc_hd__xor2_1
XFILLER_0_97 VPWR VGND VPWR VGND sky130_ef_sc_hd__decap_12
XFILLER_34_566 VGND VGND VPWR VPWR sky130_fd_sc_hd__fill_2
X_5781_ net474 net358 pe_array\[0\].u_pe.accum_reg\[5\] VGND VGND VPWR VPWR _1321_
+ sky130_fd_sc_hd__a21oi_1
XFILLER_61_385 VGND VGND VPWR VPWR sky130_fd_sc_hd__decap_4
X_4801_ _4427_ _0504_ _4428_ _0464_ VGND VGND VPWR VPWR _0550_ sky130_fd_sc_hd__or4b_4
XFILLER_9_51 VGND VGND VPWR VPWR sky130_fd_sc_hd__decap_4
X_4732_ net303 net437 VGND VGND VPWR VPWR _0482_ sky130_fd_sc_hd__nand2_8
X_7520_ _2543_ _2972_ VGND VGND VPWR VPWR _2973_ sky130_fd_sc_hd__xnor2_1
XFILLER_9_95 VPWR VGND VPWR VGND sky130_ef_sc_hd__decap_12
XFILLER_9_84 VGND VGND VPWR VPWR sky130_fd_sc_hd__decap_8
X_7451_ net268 _2904_ _2905_ VGND VGND VPWR VPWR _2906_ sky130_fd_sc_hd__nor3_1
X_4663_ _4422_ _4423_ _4381_ _4383_ VGND VGND VPWR VPWR _4425_ sky130_fd_sc_hd__o211ai_1
X_6402_ net279 _1922_ _1923_ VGND VGND VPWR VPWR _1925_ sky130_fd_sc_hd__or3_1
XPHY_EDGE_ROW_54_Left_172 VGND VGND VPWR VPWR sky130_fd_sc_hd__decap_3
X_7382_ net168 _2838_ _2839_ VGND VGND VPWR VPWR _2840_ sky130_fd_sc_hd__nand3_1
X_4594_ _4324_ _4356_ VGND VGND VPWR VPWR _4357_ sky130_fd_sc_hd__nor2_1
X_6333_ _1855_ _1856_ _1857_ VGND VGND VPWR VPWR _1859_ sky130_fd_sc_hd__a21o_1
X_9121_ clknet_leaf_18_clk _0233_ VGND VGND VPWR VPWR pe_array\[0\].u_pe.accum_reg\[7\]
+ sky130_fd_sc_hd__dfxtp_1
X_6264_ _1789_ _1790_ _1791_ VGND VGND VPWR VPWR _1792_ sky130_fd_sc_hd__and3_1
XFILLER_88_216 VGND VGND VPWR VPWR sky130_fd_sc_hd__fill_1
X_9052_ clknet_leaf_4_clk _0164_ VGND VGND VPWR VPWR net125 sky130_fd_sc_hd__dfxtp_1
XFILLER_0_109 VGND VGND VPWR VPWR sky130_fd_sc_hd__decap_3
X_8003_ _3363_ _3395_ VGND VGND VPWR VPWR _3397_ sky130_fd_sc_hd__xor2_1
X_5215_ _0947_ _0951_ VGND VGND VPWR VPWR _0952_ sky130_fd_sc_hd__xnor2_2
X_6195_ _1687_ _1688_ _1722_ _1723_ VGND VGND VPWR VPWR _1725_ sky130_fd_sc_hd__o211ai_1
XPHY_EDGE_ROW_63_Left_181 VGND VGND VPWR VPWR sky130_fd_sc_hd__decap_3
X_5146_ _0855_ _0857_ VGND VGND VPWR VPWR _0885_ sky130_fd_sc_hd__and2b_1
XFILLER_28_27 VGND VGND VPWR VPWR sky130_fd_sc_hd__fill_1
XFILLER_57_669 VGND VGND VPWR VPWR sky130_fd_sc_hd__decap_3
X_5077_ net282 _0815_ _0816_ VGND VGND VPWR VPWR _0818_ sky130_fd_sc_hd__or3_4
XFILLER_84_477 VGND VGND VPWR VPWR sky130_fd_sc_hd__decap_4
XFILLER_84_466 VGND VGND VPWR VPWR sky130_fd_sc_hd__decap_4
X_8905_ clknet_leaf_55_clk _0017_ VGND VGND VPWR VPWR pe_array\[3\].u_pe.accum_reg\[5\]
+ sky130_fd_sc_hd__dfxtp_1
XFILLER_71_149 VGND VGND VPWR VPWR sky130_fd_sc_hd__fill_1
XFILLER_37_382 VGND VGND VPWR VPWR sky130_fd_sc_hd__fill_1
XFILLER_37_393 VGND VGND VPWR VPWR sky130_fd_sc_hd__decap_4
XFILLER_44_15 VPWR VGND VPWR VGND sky130_ef_sc_hd__decap_12
X_8836_ net216 _3359_ VGND VGND VPWR VPWR _4199_ sky130_fd_sc_hd__nand2_1
XFILLER_52_352 VGND VGND VPWR VPWR sky130_fd_sc_hd__fill_1
X_8767_ _4137_ _4138_ VGND VGND VPWR VPWR _4139_ sky130_fd_sc_hd__or2_1
X_5979_ _1512_ _1513_ VGND VGND VPWR VPWR _1514_ sky130_fd_sc_hd__nor2_1
XFILLER_25_599 VPWR VGND VPWR VGND sky130_ef_sc_hd__decap_12
XPHY_EDGE_ROW_72_Left_190 VGND VGND VPWR VPWR sky130_fd_sc_hd__decap_3
X_7718_ pe_array\[1\].u_pe.accum_reg\[31\] _3163_ VGND VGND VPWR VPWR _3164_ sky130_fd_sc_hd__xnor2_1
X_8698_ _4066_ _4071_ VGND VGND VPWR VPWR _4072_ sky130_fd_sc_hd__xnor2_1
XFILLER_20_282 VGND VGND VPWR VPWR sky130_fd_sc_hd__fill_1
XFILLER_20_293 VPWR VGND VPWR VGND sky130_ef_sc_hd__decap_12
X_7649_ _3096_ _3097_ VGND VGND VPWR VPWR _3098_ sky130_fd_sc_hd__nor2_1
X_9319_ clknet_leaf_10_clk _0431_ VGND VGND VPWR VPWR pe_accum\[2\]\[29\] sky130_fd_sc_hd__dfxtp_1
XFILLER_107_3 VPWR VGND VPWR VGND sky130_ef_sc_hd__decap_12
XFILLER_69_12 VGND VGND VPWR VPWR sky130_fd_sc_hd__fill_2
XFILLER_106_365 VGND VGND VPWR VPWR sky130_fd_sc_hd__decap_8
XFILLER_106_387 VGND VGND VPWR VPWR sky130_fd_sc_hd__fill_1
XFILLER_79_249 VGND VGND VPWR VPWR sky130_fd_sc_hd__decap_6
XFILLER_102_571 VGND VGND VPWR VPWR sky130_fd_sc_hd__fill_2
XFILLER_85_11 VPWR VGND VPWR VGND sky130_ef_sc_hd__decap_12
XFILLER_48_625 VGND VGND VPWR VPWR sky130_fd_sc_hd__decap_4
XTAP_TAPCELL_ROW_89_1323 VGND VPWR sky130_fd_sc_hd__tapvpwrvgnd_1
XFILLER_75_433 VGND VGND VPWR VPWR sky130_fd_sc_hd__fill_1
XFILLER_63_617 VPWR VGND VPWR VGND sky130_ef_sc_hd__decap_12
XFILLER_18_60 VGND VGND VPWR VPWR sky130_fd_sc_hd__decap_6
XFILLER_18_71 VPWR VGND VPWR VGND sky130_ef_sc_hd__decap_12
XTAP_TAPCELL_ROW_46_804 VGND VPWR sky130_fd_sc_hd__tapvpwrvgnd_1
XFILLER_16_533 VPWR VGND VPWR VGND sky130_ef_sc_hd__decap_12
XTAP_TAPCELL_ROW_26_561 VGND VPWR sky130_fd_sc_hd__tapvpwrvgnd_1
XFILLER_31_558 VGND VGND VPWR VPWR sky130_fd_sc_hd__fill_2
XFILLER_34_92 VGND VGND VPWR VPWR sky130_fd_sc_hd__fill_2
XFILLER_79_7 VGND VGND VPWR VPWR sky130_fd_sc_hd__decap_6
Xwire151 _1552_ VGND VGND VPWR VPWR net151 sky130_fd_sc_hd__buf_4
XFILLER_112_357 VGND VGND VPWR VPWR sky130_fd_sc_hd__decap_6
X_5000_ _0742_ _0743_ _0709_ VGND VGND VPWR VPWR _0744_ sky130_fd_sc_hd__a21oi_4
XFILLER_22_3 VPWR VGND VPWR VGND sky130_ef_sc_hd__decap_12
XFILLER_66_433 VGND VGND VPWR VPWR sky130_fd_sc_hd__fill_2
XFILLER_39_669 VGND VGND VPWR VPWR sky130_fd_sc_hd__decap_3
XFILLER_93_252 VPWR VGND VPWR VGND sky130_ef_sc_hd__decap_12
XFILLER_66_477 VPWR VGND VPWR VGND sky130_ef_sc_hd__decap_12
XFILLER_54_617 VGND VGND VPWR VPWR sky130_fd_sc_hd__fill_1
XFILLER_53_105 VGND VGND VPWR VPWR sky130_fd_sc_hd__decap_6
XFILLER_38_157 VPWR VGND VPWR VGND sky130_ef_sc_hd__decap_12
XFILLER_53_138 VGND VGND VPWR VPWR sky130_fd_sc_hd__decap_3
XFILLER_19_393 VPWR VGND VPWR VGND sky130_ef_sc_hd__decap_12
X_6951_ _2417_ _2418_ _2419_ VGND VGND VPWR VPWR _2420_ sky130_fd_sc_hd__nand3_1
X_5902_ pe_array\[0\].u_pe.accum_reg\[8\] net614 net358 VGND VGND VPWR VPWR _1439_
+ sky130_fd_sc_hd__and3_1
X_6882_ net408 pe_array\[1\].u_pe.accum_reg\[6\] net231 _2352_ VGND VGND VPWR VPWR
+ _2353_ sky130_fd_sc_hd__o2bb2a_1
XFILLER_34_330 VPWR VGND VPWR VGND sky130_ef_sc_hd__decap_12
X_8621_ _3958_ _3960_ VGND VGND VPWR VPWR _3998_ sky130_fd_sc_hd__and2b_1
X_5833_ _1369_ _1370_ _1331_ _1334_ VGND VGND VPWR VPWR _1372_ sky130_fd_sc_hd__a211o_1
XFILLER_62_694 VGND VGND VPWR VPWR sky130_fd_sc_hd__decap_6
X_8552_ net162 _3929_ _3930_ VGND VGND VPWR VPWR _3931_ sky130_fd_sc_hd__or3_4
X_5764_ _1277_ _1304_ VGND VGND VPWR VPWR _1305_ sky130_fd_sc_hd__xnor2_1
X_7503_ _2955_ _2956_ VGND VGND VPWR VPWR _2957_ sky130_fd_sc_hd__xnor2_4
X_5695_ net1020 _1237_ _1240_ VGND VGND VPWR VPWR _0225_ sky130_fd_sc_hd__o21a_1
X_8483_ _3861_ _3862_ net191 VGND VGND VPWR VPWR _3864_ sky130_fd_sc_hd__a21o_1
XFILLER_30_580 VGND VGND VPWR VPWR sky130_fd_sc_hd__decap_8
X_4715_ _4429_ net517 VGND VGND VPWR VPWR _0466_ sky130_fd_sc_hd__xnor2_1
X_7434_ _2889_ _2888_ VGND VGND VPWR VPWR _2890_ sky130_fd_sc_hd__and2b_1
X_4646_ _4404_ _4406_ pe_array\[3\].u_pe.accum_reg\[7\] VGND VGND VPWR VPWR _4408_
+ sky130_fd_sc_hd__a21oi_1
XFILLER_107_129 VGND VGND VPWR VPWR sky130_fd_sc_hd__fill_1
X_7365_ net447 net338 pe_array\[1\].u_pe.accum_reg\[19\] VGND VGND VPWR VPWR _2823_
+ sky130_fd_sc_hd__a21oi_1
X_4577_ _4309_ _4302_ _4308_ VGND VGND VPWR VPWR _4341_ sky130_fd_sc_hd__a21bo_1
X_6316_ net431 _1842_ VGND VGND VPWR VPWR _0244_ sky130_fd_sc_hd__nor2_1
X_9104_ clknet_leaf_1_clk _0216_ VGND VGND VPWR VPWR pe_array\[2\].u_pe.weight_in\[2\]
+ sky130_fd_sc_hd__dfxtp_1
XTAP_TAPCELL_ROW_73_1135 VGND VPWR sky130_fd_sc_hd__tapvpwrvgnd_1
XTAP_TAPCELL_ROW_73_1124 VGND VPWR sky130_fd_sc_hd__tapvpwrvgnd_1
X_7296_ _2723_ _2755_ VGND VGND VPWR VPWR _2757_ sky130_fd_sc_hd__xnor2_2
XFILLER_103_335 VGND VGND VPWR VPWR sky130_fd_sc_hd__fill_1
X_6247_ _1738_ _1773_ _1739_ _1774_ VGND VGND VPWR VPWR _1776_ sky130_fd_sc_hd__or4bb_4
X_9035_ clknet_leaf_41_clk _0147_ VGND VGND VPWR VPWR net107 sky130_fd_sc_hd__dfxtp_1
X_6178_ _1706_ _1707_ _1668_ VGND VGND VPWR VPWR _1709_ sky130_fd_sc_hd__o21ai_1
XFILLER_57_400 VGND VGND VPWR VPWR sky130_fd_sc_hd__fill_1
X_5129_ _0807_ _0838_ _0842_ VGND VGND VPWR VPWR _0869_ sky130_fd_sc_hd__o21ba_4
XFILLER_29_113 VGND VGND VPWR VPWR sky130_fd_sc_hd__fill_2
XFILLER_57_488 VGND VGND VPWR VPWR sky130_fd_sc_hd__fill_1
XFILLER_45_617 VPWR VGND VPWR VGND sky130_ef_sc_hd__decap_12
XFILLER_72_447 VPWR VGND VPWR VGND sky130_ef_sc_hd__decap_12
XFILLER_55_69 VPWR VGND VPWR VGND sky130_ef_sc_hd__decap_12
X_8819_ _4180_ _4188_ VGND VGND VPWR VPWR _4189_ sky130_fd_sc_hd__xnor2_1
XTAP_TAPCELL_ROW_84_1264 VGND VPWR sky130_fd_sc_hd__tapvpwrvgnd_1
XFILLER_13_503 VGND VGND VPWR VPWR sky130_fd_sc_hd__fill_1
XFILLER_25_385 VGND VGND VPWR VPWR sky130_fd_sc_hd__decap_6
XTAP_TAPCELL_ROW_23_531 VGND VPWR sky130_fd_sc_hd__tapvpwrvgnd_1
XFILLER_71_57 VGND VGND VPWR VPWR sky130_fd_sc_hd__decap_8
XTAP_TAPCELL_ROW_51_862 VGND VPWR sky130_fd_sc_hd__tapvpwrvgnd_1
XFILLER_9_529 VGND VGND VPWR VPWR sky130_fd_sc_hd__decap_8
XFILLER_107_685 VGND VGND VPWR VPWR sky130_fd_sc_hd__decap_8
XTAP_TAPCELL_ROW_95_1393 VGND VPWR sky130_fd_sc_hd__tapvpwrvgnd_1
XFILLER_0_473 VGND VGND VPWR VPWR sky130_fd_sc_hd__decap_3
XFILLER_48_400 VGND VGND VPWR VPWR sky130_fd_sc_hd__fill_2
XTAP_TAPCELL_ROW_59_962 VGND VPWR sky130_fd_sc_hd__tapvpwrvgnd_1
XFILLER_29_92 VGND VGND VPWR VPWR sky130_fd_sc_hd__decap_8
XFILLER_48_477 VPWR VGND VPWR VGND sky130_ef_sc_hd__decap_12
XFILLER_35_105 VGND VGND VPWR VPWR sky130_fd_sc_hd__decap_6
XFILLER_16_363 VGND VGND VPWR VPWR sky130_fd_sc_hd__fill_1
X_5480_ net944 net251 _1200_ net367 VGND VGND VPWR VPWR _0050_ sky130_fd_sc_hd__o211a_1
X_4500_ _4262_ _4263_ _4266_ VGND VGND VPWR VPWR _4267_ sky130_fd_sc_hd__or3_1
XFILLER_117_449 VGND VGND VPWR VPWR sky130_fd_sc_hd__fill_2
XANTENNA_1 _1553_ VGND VGND VPWR VPWR sky130_fd_sc_hd__diode_2
XFILLER_6_41 VPWR VGND VPWR VGND sky130_ef_sc_hd__decap_12
X_7150_ _2389_ _2391_ _2614_ _2484_ _2437_ VGND VGND VPWR VPWR _2615_ sky130_fd_sc_hd__a2111o_1
XFILLER_112_121 VPWR VGND VPWR VGND sky130_ef_sc_hd__decap_12
XFILLER_98_333 VPWR VGND VPWR VGND sky130_ef_sc_hd__decap_12
Xfanout508 net10 VGND VGND VPWR VPWR net508 sky130_fd_sc_hd__buf_2
X_6101_ _1589_ _1633_ _1588_ VGND VGND VPWR VPWR _1634_ sky130_fd_sc_hd__or3b_1
X_7081_ net270 _2544_ _2545_ VGND VGND VPWR VPWR _2547_ sky130_fd_sc_hd__or3_4
X_6032_ _1556_ _1564_ VGND VGND VPWR VPWR _1566_ sky130_fd_sc_hd__xnor2_1
X_7983_ _3374_ _3375_ VGND VGND VPWR VPWR _3377_ sky130_fd_sc_hd__nand2_1
Xrebuffer46 net444 VGND VGND VPWR VPWR net561 sky130_fd_sc_hd__dlygate4sd1_1
XFILLER_54_414 VGND VGND VPWR VPWR sky130_fd_sc_hd__fill_1
XFILLER_26_105 VGND VGND VPWR VPWR sky130_fd_sc_hd__fill_1
Xrebuffer13 net194 VGND VGND VPWR VPWR net528 sky130_fd_sc_hd__dlygate4sd1_1
Xrebuffer24 _2545_ VGND VGND VPWR VPWR net539 sky130_fd_sc_hd__buf_1
XFILLER_39_488 VGND VGND VPWR VPWR sky130_fd_sc_hd__decap_8
Xrebuffer35 net450 VGND VGND VPWR VPWR net550 sky130_fd_sc_hd__dlygate4sd1_1
Xrebuffer57 net604 VGND VGND VPWR VPWR net572 sky130_fd_sc_hd__dlymetal6s2s_1
Xrebuffer68 net503 VGND VGND VPWR VPWR net583 sky130_fd_sc_hd__dlygate4sd1_1
X_6934_ _2401_ _2402_ VGND VGND VPWR VPWR _2403_ sky130_fd_sc_hd__xor2_1
Xrebuffer79 _0533_ VGND VGND VPWR VPWR net594 sky130_fd_sc_hd__buf_1
XFILLER_81_288 VGND VGND VPWR VPWR sky130_fd_sc_hd__decap_6
XFILLER_81_266 VGND VGND VPWR VPWR sky130_fd_sc_hd__fill_1
XFILLER_25_28 VGND VGND VPWR VPWR sky130_fd_sc_hd__fill_2
XFILLER_35_661 VGND VGND VPWR VPWR sky130_fd_sc_hd__decap_8
X_8604_ _3942_ _3971_ VGND VGND VPWR VPWR _3981_ sky130_fd_sc_hd__nor2_1
X_6865_ _2333_ _2334_ _2294_ _2295_ VGND VGND VPWR VPWR _2336_ sky130_fd_sc_hd__o211ai_2
X_5816_ _1353_ _1354_ VGND VGND VPWR VPWR _1355_ sky130_fd_sc_hd__and2b_1
X_6796_ _2266_ _2267_ _2239_ _2240_ VGND VGND VPWR VPWR _2269_ sky130_fd_sc_hd__a211o_1
XFILLER_22_377 VPWR VGND VPWR VGND sky130_ef_sc_hd__decap_12
X_8535_ _3886_ _3877_ _3913_ VGND VGND VPWR VPWR _3915_ sky130_fd_sc_hd__a21o_1
X_5747_ net505 net496 net353 net351 VGND VGND VPWR VPWR _1288_ sky130_fd_sc_hd__and4_1
XFILLER_41_27 VPWR VGND VPWR VGND sky130_ef_sc_hd__decap_12
Xrebuffer125 net641 VGND VGND VPWR VPWR net640 sky130_fd_sc_hd__buf_6
X_8466_ _3846_ _3847_ VGND VGND VPWR VPWR _3848_ sky130_fd_sc_hd__nor2_1
X_5678_ net16 _1230_ _1231_ net317 VGND VGND VPWR VPWR _0217_ sky130_fd_sc_hd__a22o_1
X_7417_ _2846_ _2873_ VGND VGND VPWR VPWR _2874_ sky130_fd_sc_hd__nand2_1
X_8397_ _3778_ _3779_ _3780_ VGND VGND VPWR VPWR _3781_ sky130_fd_sc_hd__and3_1
X_4629_ net493 net294 _4364_ _4363_ VGND VGND VPWR VPWR _4391_ sky130_fd_sc_hd__a31o_1
X_7348_ _2804_ _2805_ net166 VGND VGND VPWR VPWR _2807_ sky130_fd_sc_hd__o21ai_1
XFILLER_116_493 VGND VGND VPWR VPWR sky130_fd_sc_hd__decap_4
XFILLER_89_344 VGND VGND VPWR VPWR sky130_fd_sc_hd__decap_8
X_7279_ _2737_ _2738_ net195 VGND VGND VPWR VPWR _2740_ sky130_fd_sc_hd__a21o_1
XTAP_TAPCELL_ROW_9_359 VGND VPWR sky130_fd_sc_hd__tapvpwrvgnd_1
XFILLER_106_53 VPWR VGND VPWR VGND sky130_ef_sc_hd__decap_12
XFILLER_104_699 VGND VGND VPWR VPWR sky130_fd_sc_hd__fill_1
XFILLER_104_688 VGND VGND VPWR VPWR sky130_fd_sc_hd__decap_3
XFILLER_89_388 VGND VGND VPWR VPWR sky130_fd_sc_hd__fill_1
XFILLER_89_377 VGND VGND VPWR VPWR sky130_fd_sc_hd__fill_2
XFILLER_77_539 VGND VGND VPWR VPWR sky130_fd_sc_hd__fill_1
X_9018_ clknet_leaf_45_clk _0130_ VGND VGND VPWR VPWR net88 sky130_fd_sc_hd__dfxtp_1
XFILLER_103_198 VPWR VGND VPWR VGND sky130_ef_sc_hd__decap_12
XFILLER_103_187 VGND VGND VPWR VPWR sky130_fd_sc_hd__decap_4
XFILLER_66_35 VGND VGND VPWR VPWR sky130_fd_sc_hd__fill_1
XFILLER_57_252 VPWR VGND VPWR VGND sky130_ef_sc_hd__decap_12
XFILLER_18_606 VPWR VGND VPWR VGND sky130_ef_sc_hd__decap_12
XFILLER_57_274 VGND VGND VPWR VPWR sky130_fd_sc_hd__decap_6
XTAP_TAPCELL_ROW_56_921 VGND VPWR sky130_fd_sc_hd__tapvpwrvgnd_1
XFILLER_72_244 VGND VGND VPWR VPWR sky130_fd_sc_hd__decap_8
XFILLER_72_233 VGND VGND VPWR VPWR sky130_fd_sc_hd__decap_3
XFILLER_45_447 VGND VGND VPWR VPWR sky130_fd_sc_hd__fill_1
XFILLER_26_672 VGND VGND VPWR VPWR sky130_fd_sc_hd__fill_1
XFILLER_32_108 VGND VGND VPWR VPWR sky130_fd_sc_hd__decap_4
XFILLER_72_299 VGND VGND VPWR VPWR sky130_fd_sc_hd__fill_2
XFILLER_13_344 VGND VGND VPWR VPWR sky130_fd_sc_hd__decap_8
XFILLER_13_355 VPWR VGND VPWR VGND sky130_ef_sc_hd__decap_12
XFILLER_40_141 VGND VGND VPWR VPWR sky130_fd_sc_hd__decap_3
XFILLER_9_337 VGND VGND VPWR VPWR sky130_fd_sc_hd__fill_2
XTAP_TAPCELL_ROW_97_1422 VGND VPWR sky130_fd_sc_hd__tapvpwrvgnd_1
XFILLER_31_71 VGND VGND VPWR VPWR sky130_fd_sc_hd__fill_1
XFILLER_114_419 VGND VGND VPWR VPWR sky130_fd_sc_hd__fill_1
XFILLER_107_460 VGND VGND VPWR VPWR sky130_fd_sc_hd__decap_3
XFILLER_5_598 VPWR VGND VPWR VGND sky130_ef_sc_hd__decap_12
Xoutput60 net60 VGND VGND VPWR VPWR result_data[19] sky130_fd_sc_hd__buf_2
Xoutput71 net71 VGND VGND VPWR VPWR result_data[29] sky130_fd_sc_hd__buf_2
Xoutput93 net93 VGND VGND VPWR VPWR result_data[49] sky130_fd_sc_hd__buf_2
Xoutput82 net82 VGND VGND VPWR VPWR result_data[39] sky130_fd_sc_hd__buf_2
XFILLER_110_636 VGND VGND VPWR VPWR sky130_fd_sc_hd__decap_8
XFILLER_0_281 VGND VGND VPWR VPWR sky130_fd_sc_hd__decap_8
XFILLER_110_669 VPWR VGND VPWR VGND sky130_ef_sc_hd__decap_12
XFILLER_76_583 VGND VGND VPWR VPWR sky130_fd_sc_hd__decap_4
X_4980_ _0720_ _0721_ net283 VGND VGND VPWR VPWR _0724_ sky130_fd_sc_hd__o21ai_1
XFILLER_16_171 VGND VGND VPWR VPWR sky130_fd_sc_hd__fill_1
XFILLER_32_642 VGND VGND VPWR VPWR sky130_fd_sc_hd__fill_2
XTAP_TAPCELL_ROW_34_659 VGND VPWR sky130_fd_sc_hd__tapvpwrvgnd_1
X_6650_ _2130_ _2131_ _2164_ VGND VGND VPWR VPWR _2165_ sky130_fd_sc_hd__or3_1
XFILLER_31_130 VGND VGND VPWR VPWR sky130_fd_sc_hd__fill_1
X_6581_ pe_array\[0\].u_pe.accum_reg\[28\] net614 net357 VGND VGND VPWR VPWR _2098_
+ sky130_fd_sc_hd__and3_1
X_5601_ net961 net374 VGND VGND VPWR VPWR _0142_ sky130_fd_sc_hd__and2_1
X_8320_ net261 _3703_ _3704_ VGND VGND VPWR VPWR _3706_ sky130_fd_sc_hd__or3_4
X_5532_ net370 net21 net11 _4236_ VGND VGND VPWR VPWR _1226_ sky130_fd_sc_hd__and4_2
X_8251_ _3592_ _3594_ _3637_ _3638_ VGND VGND VPWR VPWR _3639_ sky130_fd_sc_hd__o211a_1
X_5463_ _1171_ _1190_ VGND VGND VPWR VPWR _1191_ sky130_fd_sc_hd__xnor2_1
XFILLER_117_279 VGND VGND VPWR VPWR sky130_fd_sc_hd__fill_1
X_8182_ _3526_ _3524_ _3570_ _3571_ VGND VGND VPWR VPWR _3572_ sky130_fd_sc_hd__a211o_1
X_5394_ _1123_ _1124_ VGND VGND VPWR VPWR _1125_ sky130_fd_sc_hd__or2_4
X_7202_ _2576_ _2626_ VGND VGND VPWR VPWR _2665_ sky130_fd_sc_hd__nor2_1
Xfanout305 pe_array\[3\].u_pe.weight_in\[1\] VGND VGND VPWR VPWR net305 sky130_fd_sc_hd__clkbuf_2
X_7133_ _2594_ _2595_ _2596_ VGND VGND VPWR VPWR _2598_ sky130_fd_sc_hd__a21o_1
XFILLER_99_697 VGND VGND VPWR VPWR sky130_fd_sc_hd__decap_3
XFILLER_98_152 VGND VGND VPWR VPWR sky130_fd_sc_hd__decap_6
XFILLER_98_141 VGND VGND VPWR VPWR sky130_fd_sc_hd__decap_6
Xfanout316 net319 VGND VGND VPWR VPWR net316 sky130_fd_sc_hd__clkbuf_2
Xfanout327 pe_array\[1\].u_pe.weight_in\[6\] VGND VGND VPWR VPWR net327 sky130_fd_sc_hd__dlymetal6s2s_1
Xfanout338 net340 VGND VGND VPWR VPWR net338 sky130_fd_sc_hd__buf_2
XTAP_TAPCELL_ROW_6_329 VGND VPWR sky130_fd_sc_hd__tapvpwrvgnd_1
Xfanout349 pe_array\[0\].u_pe.weight_in\[4\] VGND VGND VPWR VPWR net349 sky130_fd_sc_hd__clkbuf_2
X_7064_ net424 _2530_ VGND VGND VPWR VPWR _0304_ sky130_fd_sc_hd__nor2_1
XFILLER_100_146 VPWR VGND VPWR VGND sky130_ef_sc_hd__decap_12
X_6015_ _1501_ _1548_ VGND VGND VPWR VPWR _1550_ sky130_fd_sc_hd__xnor2_2
XFILLER_67_561 VPWR VGND VPWR VGND sky130_ef_sc_hd__decap_12
XFILLER_67_550 VGND VGND VPWR VPWR sky130_fd_sc_hd__decap_8
XFILLER_36_27 VGND VGND VPWR VPWR sky130_fd_sc_hd__fill_1
XFILLER_54_233 VPWR VGND VPWR VGND sky130_ef_sc_hd__decap_12
XFILLER_15_609 VGND VGND VPWR VPWR sky130_fd_sc_hd__decap_6
XFILLER_82_564 VPWR VGND VPWR VGND sky130_ef_sc_hd__decap_12
X_7966_ net422 _3360_ VGND VGND VPWR VPWR _0376_ sky130_fd_sc_hd__nor2_1
XTAP_TAPCELL_ROW_68_1067 VGND VPWR sky130_fd_sc_hd__tapvpwrvgnd_1
X_7897_ _3291_ _3292_ net485 net320 VGND VGND VPWR VPWR _3293_ sky130_fd_sc_hd__and4bb_1
XTAP_TAPCELL_ROW_81_1223 VGND VPWR sky130_fd_sc_hd__tapvpwrvgnd_1
X_6917_ _2385_ _2384_ VGND VGND VPWR VPWR _2387_ sky130_fd_sc_hd__xor2_2
X_6848_ net501 net327 VGND VGND VPWR VPWR _2319_ sky130_fd_sc_hd__nand2_1
XTAP_TAPCELL_ROW_61_990 VGND VPWR sky130_fd_sc_hd__tapvpwrvgnd_1
X_8518_ _3896_ _3895_ net192 VGND VGND VPWR VPWR _3898_ sky130_fd_sc_hd__a21o_1
X_6779_ _2234_ _2252_ VGND VGND VPWR VPWR _2253_ sky130_fd_sc_hd__and2_1
XFILLER_10_336 VPWR VGND VPWR VGND sky130_ef_sc_hd__decap_12
X_8449_ _3827_ _3828_ net263 VGND VGND VPWR VPWR _3831_ sky130_fd_sc_hd__o21ai_1
XTAP_TAPCELL_ROW_79_1196 VGND VPWR sky130_fd_sc_hd__tapvpwrvgnd_1
XFILLER_117_41 VPWR VGND VPWR VGND sky130_ef_sc_hd__decap_12
XTAP_TAPCELL_ROW_92_1363 VGND VPWR sky130_fd_sc_hd__tapvpwrvgnd_1
XTAP_TAPCELL_ROW_92_1352 VGND VPWR sky130_fd_sc_hd__tapvpwrvgnd_1
Xhold381 pe_accum\[0\]\[11\] VGND VGND VPWR VPWR net896 sky130_fd_sc_hd__dlygate4sd3_1
XFILLER_117_85 VPWR VGND VPWR VGND sky130_ef_sc_hd__decap_12
XFILLER_104_463 VPWR VGND VPWR VGND sky130_ef_sc_hd__decap_12
Xhold392 pe_accum\[0\]\[14\] VGND VGND VPWR VPWR net907 sky130_fd_sc_hd__dlygate4sd3_1
XFILLER_93_55 VGND VGND VPWR VPWR sky130_fd_sc_hd__fill_1
XFILLER_85_391 VGND VGND VPWR VPWR sky130_fd_sc_hd__fill_1
XFILLER_73_564 VGND VGND VPWR VPWR sky130_fd_sc_hd__fill_1
XFILLER_26_82 VGND VGND VPWR VPWR sky130_fd_sc_hd__fill_2
XTAP_TAPCELL_ROW_31_629 VGND VPWR sky130_fd_sc_hd__tapvpwrvgnd_1
XTAP_TAPCELL_ROW_101_1470 VGND VPWR sky130_fd_sc_hd__tapvpwrvgnd_1
XFILLER_9_167 VGND VGND VPWR VPWR sky130_fd_sc_hd__fill_1
Xrebuffer4 _2499_ VGND VGND VPWR VPWR net519 sky130_fd_sc_hd__dlygate4sd1_1
XFILLER_61_7 VPWR VGND VPWR VGND sky130_ef_sc_hd__decap_12
XTAP_TAPCELL_ROW_11_386 VGND VPWR sky130_fd_sc_hd__tapvpwrvgnd_1
XFILLER_5_351 VGND VGND VPWR VPWR sky130_fd_sc_hd__fill_1
XFILLER_96_645 VPWR VGND VPWR VGND sky130_ef_sc_hd__decap_12
XFILLER_110_455 VPWR VGND VPWR VGND sky130_ef_sc_hd__decap_12
XFILLER_110_477 VGND VGND VPWR VPWR sky130_fd_sc_hd__decap_6
XTAP_TAPCELL_ROW_39_718 VGND VPWR sky130_fd_sc_hd__tapvpwrvgnd_1
X_7820_ net421 _3220_ VGND VGND VPWR VPWR _0370_ sky130_fd_sc_hd__nor2_1
XFILLER_64_531 VGND VGND VPWR VPWR sky130_fd_sc_hd__fill_1
XFILLER_64_586 VGND VGND VPWR VPWR sky130_fd_sc_hd__fill_2
XFILLER_24_417 VGND VGND VPWR VPWR sky130_fd_sc_hd__decap_3
XFILLER_36_266 VGND VGND VPWR VPWR sky130_fd_sc_hd__fill_1
XFILLER_51_225 VPWR VGND VPWR VGND sky130_ef_sc_hd__decap_12
XTAP_TAPCELL_ROW_19_486 VGND VPWR sky130_fd_sc_hd__tapvpwrvgnd_1
X_7751_ net223 _2572_ VGND VGND VPWR VPWR _3185_ sky130_fd_sc_hd__nand2_1
X_4963_ _0705_ _0706_ _0682_ VGND VGND VPWR VPWR _0708_ sky130_fd_sc_hd__o21ai_1
X_6702_ net907 net236 _1714_ net244 VGND VGND VPWR VPWR _0272_ sky130_fd_sc_hd__o2bb2ai_1
X_7682_ _3096_ _3129_ VGND VGND VPWR VPWR _3130_ sky130_fd_sc_hd__or2_1
X_6633_ net172 _2147_ VGND VGND VPWR VPWR _2149_ sky130_fd_sc_hd__nor2_1
X_4894_ _0635_ _0639_ VGND VGND VPWR VPWR _0641_ sky130_fd_sc_hd__nand2_1
XFILLER_22_29 VPWR VGND VPWR VGND sky130_ef_sc_hd__decap_12
X_6564_ net158 _2081_ VGND VGND VPWR VPWR _2082_ sky130_fd_sc_hd__xnor2_1
XFILLER_20_678 VGND VGND VPWR VPWR sky130_fd_sc_hd__decap_4
X_9283_ clknet_leaf_8_clk _0395_ VGND VGND VPWR VPWR pe_array\[2\].u_pe.accum_reg\[25\]
+ sky130_fd_sc_hd__dfxtp_1
X_6495_ _2012_ _2013_ net276 VGND VGND VPWR VPWR _2015_ sky130_fd_sc_hd__o21ai_1
X_8303_ _3687_ _3688_ _3663_ VGND VGND VPWR VPWR _3690_ sky130_fd_sc_hd__o21ai_1
X_5515_ _1011_ net246 VGND VGND VPWR VPWR _1218_ sky130_fd_sc_hd__nand2_1
XTAP_TAPCELL_ROW_115_1639 VGND VPWR sky130_fd_sc_hd__tapvpwrvgnd_1
XTAP_TAPCELL_ROW_115_1628 VGND VPWR sky130_fd_sc_hd__tapvpwrvgnd_1
X_8234_ net401 pe_array\[2\].u_pe.accum_reg\[12\] net217 _3622_ VGND VGND VPWR VPWR
+ _3623_ sky130_fd_sc_hd__o2bb2a_1
X_5446_ _1174_ VGND VGND VPWR VPWR _1175_ sky130_fd_sc_hd__inv_2
X_8165_ net260 _3553_ _3554_ VGND VGND VPWR VPWR _3555_ sky130_fd_sc_hd__nor3_1
X_5377_ net743 _1072_ _1071_ VGND VGND VPWR VPWR _1108_ sky130_fd_sc_hd__a21oi_1
X_8096_ _3442_ _3486_ VGND VGND VPWR VPWR _3488_ sky130_fd_sc_hd__xor2_1
X_7116_ _2579_ _2580_ VGND VGND VPWR VPWR _2581_ sky130_fd_sc_hd__xor2_1
XFILLER_101_455 VGND VGND VPWR VPWR sky130_fd_sc_hd__decap_3
Xfanout157 _1717_ VGND VGND VPWR VPWR net157 sky130_fd_sc_hd__buf_4
Xfanout168 net169 VGND VGND VPWR VPWR net168 sky130_fd_sc_hd__buf_2
Xfanout179 net180 VGND VGND VPWR VPWR net179 sky130_fd_sc_hd__buf_2
X_7047_ _2513_ VGND VGND VPWR VPWR _2514_ sky130_fd_sc_hd__inv_2
XFILLER_86_177 VGND VGND VPWR VPWR sky130_fd_sc_hd__decap_3
XFILLER_67_391 VGND VGND VPWR VPWR sky130_fd_sc_hd__fill_1
XFILLER_27_211 VGND VGND VPWR VPWR sky130_fd_sc_hd__decap_6
X_8998_ clknet_leaf_23_clk _0110_ VGND VGND VPWR VPWR net66 sky130_fd_sc_hd__dfxtp_1
XFILLER_70_512 VGND VGND VPWR VPWR sky130_fd_sc_hd__decap_4
XFILLER_15_417 VPWR VGND VPWR VGND sky130_ef_sc_hd__decap_12
X_7949_ net506 pe_array\[2\].u_pe.weight_in\[5\] net309 net512 VGND VGND VPWR VPWR
+ _3344_ sky130_fd_sc_hd__a22o_1
XFILLER_63_69 VGND VGND VPWR VPWR sky130_fd_sc_hd__decap_6
XFILLER_70_589 VPWR VGND VPWR VGND sky130_ef_sc_hd__decap_12
XFILLER_109_511 VPWR VGND VPWR VGND sky130_ef_sc_hd__decap_12
XFILLER_11_689 VGND VGND VPWR VPWR sky130_fd_sc_hd__decap_6
XFILLER_10_177 VGND VGND VPWR VPWR sky130_fd_sc_hd__fill_1
XFILLER_104_271 VPWR VGND VPWR VGND sky130_ef_sc_hd__decap_12
XFILLER_78_645 VPWR VGND VPWR VGND sky130_ef_sc_hd__decap_12
XFILLER_77_166 VGND VGND VPWR VPWR sky130_fd_sc_hd__fill_2
XFILLER_18_200 VPWR VGND VPWR VGND sky130_ef_sc_hd__decap_12
XFILLER_80_309 VPWR VGND VPWR VGND sky130_ef_sc_hd__decap_12
XFILLER_73_361 VPWR VGND VPWR VGND sky130_ef_sc_hd__decap_12
XFILLER_18_244 VGND VGND VPWR VPWR sky130_fd_sc_hd__decap_3
XFILLER_46_553 VGND VGND VPWR VPWR sky130_fd_sc_hd__decap_6
XFILLER_61_523 VGND VGND VPWR VPWR sky130_fd_sc_hd__fill_2
XFILLER_46_597 VGND VGND VPWR VPWR sky130_fd_sc_hd__decap_3
XTAP_TAPCELL_ROW_16_445 VGND VPWR sky130_fd_sc_hd__tapvpwrvgnd_1
XFILLER_33_258 VGND VGND VPWR VPWR sky130_fd_sc_hd__fill_2
XTAP_TAPCELL_ROW_44_776 VGND VPWR sky130_fd_sc_hd__tapvpwrvgnd_1
XTAP_TAPCELL_ROW_44_787 VGND VPWR sky130_fd_sc_hd__tapvpwrvgnd_1
XFILLER_115_503 VGND VGND VPWR VPWR sky130_fd_sc_hd__fill_1
X_5300_ _1006_ _1032_ VGND VGND VPWR VPWR _1034_ sky130_fd_sc_hd__xnor2_1
XFILLER_115_558 VGND VGND VPWR VPWR sky130_fd_sc_hd__fill_2
X_6280_ _1776_ _1778_ VGND VGND VPWR VPWR _1808_ sky130_fd_sc_hd__and2_1
XFILLER_6_693 VGND VGND VPWR VPWR sky130_fd_sc_hd__decap_6
X_5231_ net186 _0965_ VGND VGND VPWR VPWR _0967_ sky130_fd_sc_hd__xnor2_1
XFILLER_68_111 VGND VGND VPWR VPWR sky130_fd_sc_hd__decap_8
X_5162_ net414 _0900_ VGND VGND VPWR VPWR _0032_ sky130_fd_sc_hd__nor2_1
XTAP_TAPCELL_ROW_110_1569 VGND VPWR sky130_fd_sc_hd__tapvpwrvgnd_1
XFILLER_68_155 VGND VGND VPWR VPWR sky130_fd_sc_hd__decap_4
X_5093_ net178 _0833_ VGND VGND VPWR VPWR _0834_ sky130_fd_sc_hd__xnor2_2
X_8921_ clknet_leaf_63_clk _0033_ VGND VGND VPWR VPWR pe_array\[3\].u_pe.accum_reg\[21\]
+ sky130_fd_sc_hd__dfxtp_1
X_8852_ _3697_ net209 VGND VGND VPWR VPWR _4207_ sky130_fd_sc_hd__nand2_1
X_8783_ _4153_ _4154_ VGND VGND VPWR VPWR _4155_ sky130_fd_sc_hd__nand2_2
X_7803_ pe_array\[2\].u_pe.tap_count\[2\] pe_array\[2\].u_pe.tap_count\[1\] pe_array\[2\].u_pe.tap_count\[0\]
+ pe_array\[2\].u_pe.tap_count\[3\] VGND VGND VPWR VPWR _3208_ sky130_fd_sc_hd__or4b_1
XTAP_TAPCELL_ROW_65_1037 VGND VPWR sky130_fd_sc_hd__tapvpwrvgnd_1
XFILLER_52_545 VGND VGND VPWR VPWR sky130_fd_sc_hd__decap_8
X_5995_ _1526_ _1527_ net275 VGND VGND VPWR VPWR _1530_ sky130_fd_sc_hd__o21ai_1
X_7734_ net911 net227 _3176_ net390 VGND VGND VPWR VPWR _0328_ sky130_fd_sc_hd__o211a_1
XFILLER_52_589 VGND VGND VPWR VPWR sky130_fd_sc_hd__decap_3
X_4946_ net283 _0689_ _0690_ VGND VGND VPWR VPWR _0691_ sky130_fd_sc_hd__nor3_1
XFILLER_20_431 VGND VGND VPWR VPWR sky130_fd_sc_hd__fill_1
X_4877_ _0609_ _0621_ _0622_ VGND VGND VPWR VPWR _0624_ sky130_fd_sc_hd__nand3_2
X_7665_ _3110_ _3111_ VGND VGND VPWR VPWR _3113_ sky130_fd_sc_hd__xor2_1
X_6616_ _2129_ _2130_ net274 VGND VGND VPWR VPWR _2132_ sky130_fd_sc_hd__o21a_1
X_7596_ _3043_ _3044_ net272 VGND VGND VPWR VPWR _3046_ sky130_fd_sc_hd__o21a_1
X_6547_ pe_array\[0\].u_pe.accum_reg\[27\] _1393_ VGND VGND VPWR VPWR _2065_ sky130_fd_sc_hd__nor2_1
X_6478_ _1962_ _1964_ _1998_ VGND VGND VPWR VPWR _1999_ sky130_fd_sc_hd__o21a_1
X_9266_ clknet_leaf_2_clk _0378_ VGND VGND VPWR VPWR pe_array\[2\].u_pe.accum_reg\[8\]
+ sky130_fd_sc_hd__dfxtp_1
XTAP_TAPCELL_ROW_76_1166 VGND VPWR sky130_fd_sc_hd__tapvpwrvgnd_1
XFILLER_106_569 VPWR VGND VPWR VGND sky130_ef_sc_hd__decap_12
X_8217_ _3591_ _3603_ net677 VGND VGND VPWR VPWR _3606_ sky130_fd_sc_hd__nand3_1
X_9197_ clknet_leaf_50_clk _0309_ VGND VGND VPWR VPWR pe_array\[1\].u_pe.accum_reg\[15\]
+ sky130_fd_sc_hd__dfxtp_1
X_5429_ pe_array\[3\].u_pe.accum_reg\[30\] _0521_ VGND VGND VPWR VPWR _1158_ sky130_fd_sc_hd__xnor2_1
XFILLER_59_111 VGND VGND VPWR VPWR sky130_fd_sc_hd__fill_1
X_8148_ net462 net560 _3417_ VGND VGND VPWR VPWR _3538_ sky130_fd_sc_hd__a21o_1
XFILLER_87_442 VGND VGND VPWR VPWR sky130_fd_sc_hd__decap_6
XFILLER_87_497 VGND VGND VPWR VPWR sky130_fd_sc_hd__decap_6
X_8079_ _3425_ _3426_ _3469_ _3470_ VGND VGND VPWR VPWR _3471_ sky130_fd_sc_hd__o211ai_2
XFILLER_114_53 VPWR VGND VPWR VGND sky130_ef_sc_hd__decap_12
XFILLER_74_24 VGND VGND VPWR VPWR sky130_fd_sc_hd__decap_4
XFILLER_114_97 VGND VGND VPWR VPWR sky130_fd_sc_hd__fill_2
XTAP_TAPCELL_ROW_87_1295 VGND VPWR sky130_fd_sc_hd__tapvpwrvgnd_1
XFILLER_15_225 VPWR VGND VPWR VGND sky130_ef_sc_hd__decap_12
XFILLER_90_34 VPWR VGND VPWR VGND sky130_ef_sc_hd__decap_12
XFILLER_70_397 VGND VGND VPWR VPWR sky130_fd_sc_hd__fill_2
XTAP_TAPCELL_ROW_13_404 VGND VPWR sky130_fd_sc_hd__tapvpwrvgnd_1
XTAP_TAPCELL_ROW_13_415 VGND VPWR sky130_fd_sc_hd__tapvpwrvgnd_1
XFILLER_43_589 VGND VGND VPWR VPWR sky130_fd_sc_hd__fill_1
XTAP_TAPCELL_ROW_41_746 VGND VPWR sky130_fd_sc_hd__tapvpwrvgnd_1
XFILLER_11_497 VGND VGND VPWR VPWR sky130_fd_sc_hd__decap_6
XFILLER_23_83 VPWR VGND VPWR VGND sky130_ef_sc_hd__decap_12
XFILLER_99_54 VGND VGND VPWR VPWR sky130_fd_sc_hd__fill_2
XFILLER_99_76 VPWR VGND VPWR VGND sky130_ef_sc_hd__decap_12
XFILLER_3_641 VPWR VGND VPWR VGND sky130_ef_sc_hd__decap_12
XFILLER_3_685 VPWR VGND VPWR VGND sky130_ef_sc_hd__decap_12
XFILLER_78_453 VGND VGND VPWR VPWR sky130_fd_sc_hd__fill_1
XFILLER_2_195 VGND VGND VPWR VPWR sky130_fd_sc_hd__fill_1
XFILLER_93_401 VPWR VGND VPWR VGND sky130_ef_sc_hd__decap_12
XFILLER_78_486 VGND VGND VPWR VPWR sky130_fd_sc_hd__decap_8
XFILLER_78_475 VGND VGND VPWR VPWR sky130_fd_sc_hd__fill_1
XFILLER_66_637 VGND VGND VPWR VPWR sky130_fd_sc_hd__decap_6
XFILLER_38_306 VGND VGND VPWR VPWR sky130_fd_sc_hd__fill_2
XTAP_TAPCELL_ROW_49_846 VGND VPWR sky130_fd_sc_hd__tapvpwrvgnd_1
XFILLER_65_169 VGND VGND VPWR VPWR sky130_fd_sc_hd__fill_2
XFILLER_19_553 VGND VGND VPWR VPWR sky130_fd_sc_hd__decap_6
XFILLER_80_139 VGND VGND VPWR VPWR sky130_fd_sc_hd__fill_1
X_4800_ _0504_ _0465_ VGND VGND VPWR VPWR _0549_ sky130_fd_sc_hd__and2b_1
X_5780_ _1316_ _1319_ VGND VGND VPWR VPWR _1320_ sky130_fd_sc_hd__xnor2_1
XFILLER_61_364 VGND VGND VPWR VPWR sky130_fd_sc_hd__decap_4
XFILLER_34_589 VGND VGND VPWR VPWR sky130_fd_sc_hd__decap_6
XFILLER_14_280 VGND VGND VPWR VPWR sky130_fd_sc_hd__decap_8
X_4731_ net534 _0480_ VGND VGND VPWR VPWR _0481_ sky130_fd_sc_hd__xnor2_2
X_7450_ pe_array\[1\].u_pe.accum_reg\[22\] net447 net340 VGND VGND VPWR VPWR _2905_
+ sky130_fd_sc_hd__and3_1
X_4662_ _4383_ _4381_ _4422_ _4423_ VGND VGND VPWR VPWR _4424_ sky130_fd_sc_hd__a211oi_2
X_6401_ net279 _1922_ _1923_ VGND VGND VPWR VPWR _1924_ sky130_fd_sc_hd__nor3_1
X_9120_ clknet_leaf_18_clk _0232_ VGND VGND VPWR VPWR pe_array\[0\].u_pe.accum_reg\[6\]
+ sky130_fd_sc_hd__dfxtp_1
X_7381_ _2835_ _2836_ _2837_ VGND VGND VPWR VPWR _2839_ sky130_fd_sc_hd__a21o_1
X_4593_ net501 net290 VGND VGND VPWR VPWR _4356_ sky130_fd_sc_hd__nand2_1
X_6332_ _1855_ _1856_ _1857_ VGND VGND VPWR VPWR _1858_ sky130_fd_sc_hd__nand3_1
X_6263_ net201 _1759_ _1757_ VGND VGND VPWR VPWR _1791_ sky130_fd_sc_hd__a21o_1
X_9051_ clknet_leaf_3_clk _0163_ VGND VGND VPWR VPWR net124 sky130_fd_sc_hd__dfxtp_1
X_8002_ _3363_ _3395_ VGND VGND VPWR VPWR _3396_ sky130_fd_sc_hd__nor2_1
X_5214_ _0898_ _0950_ _0949_ VGND VGND VPWR VPWR _0951_ sky130_fd_sc_hd__a21boi_4
X_6194_ _1687_ _1688_ _1722_ _1723_ VGND VGND VPWR VPWR _1724_ sky130_fd_sc_hd__o211a_1
XFILLER_111_561 VPWR VGND VPWR VGND sky130_ef_sc_hd__decap_12
XFILLER_96_250 VGND VGND VPWR VPWR sky130_fd_sc_hd__fill_2
X_5145_ net183 _0883_ VGND VGND VPWR VPWR _0884_ sky130_fd_sc_hd__xnor2_1
XFILLER_29_317 VGND VGND VPWR VPWR sky130_fd_sc_hd__decap_6
X_5076_ net282 _0815_ _0816_ VGND VGND VPWR VPWR _0817_ sky130_fd_sc_hd__nor3_1
X_8904_ clknet_leaf_55_clk _0016_ VGND VGND VPWR VPWR pe_array\[3\].u_pe.accum_reg\[4\]
+ sky130_fd_sc_hd__dfxtp_1
XFILLER_65_681 VGND VGND VPWR VPWR sky130_fd_sc_hd__decap_3
X_8835_ net953 net213 _4198_ net386 VGND VGND VPWR VPWR _0407_ sky130_fd_sc_hd__o211a_1
XFILLER_44_27 VGND VGND VPWR VPWR sky130_fd_sc_hd__fill_1
X_8766_ _4102_ _4104_ _4136_ VGND VGND VPWR VPWR _4138_ sky130_fd_sc_hd__nor3_1
X_5978_ net481 net473 net347 net344 VGND VGND VPWR VPWR _1513_ sky130_fd_sc_hd__and4_1
XFILLER_40_526 VGND VGND VPWR VPWR sky130_fd_sc_hd__fill_2
X_8697_ _4069_ _4070_ VGND VGND VPWR VPWR _4071_ sky130_fd_sc_hd__nor2_1
X_4929_ _0672_ _0673_ _0631_ VGND VGND VPWR VPWR _0675_ sky130_fd_sc_hd__or3b_4
XFILLER_40_537 VPWR VGND VPWR VGND sky130_ef_sc_hd__decap_12
X_7717_ pe_array\[1\].u_pe.accum_reg\[30\] net272 _3162_ VGND VGND VPWR VPWR _3163_
+ sky130_fd_sc_hd__o21a_1
X_7648_ _3094_ _3095_ VGND VGND VPWR VPWR _3097_ sky130_fd_sc_hd__and2b_1
XFILLER_4_405 VPWR VGND VPWR VGND sky130_ef_sc_hd__decap_12
X_7579_ _3001_ _3003_ _3029_ VGND VGND VPWR VPWR _3030_ sky130_fd_sc_hd__o21a_1
X_9318_ clknet_leaf_10_clk _0430_ VGND VGND VPWR VPWR pe_accum\[2\]\[28\] sky130_fd_sc_hd__dfxtp_1
XFILLER_69_57 VGND VGND VPWR VPWR sky130_fd_sc_hd__fill_2
X_9249_ clknet_leaf_54_clk _0361_ VGND VGND VPWR VPWR pe_array\[3\].u_pe.weight_in\[3\]
+ sky130_fd_sc_hd__dfxtp_2
XFILLER_94_209 VPWR VGND VPWR VGND sky130_ef_sc_hd__decap_12
XFILLER_85_23 VGND VGND VPWR VPWR sky130_fd_sc_hd__decap_6
XTAP_TAPCELL_ROW_89_1324 VGND VPWR sky130_fd_sc_hd__tapvpwrvgnd_1
XFILLER_63_629 VGND VGND VPWR VPWR sky130_fd_sc_hd__decap_8
XFILLER_18_50 VGND VGND VPWR VPWR sky130_fd_sc_hd__fill_1
XFILLER_47_169 VGND VGND VPWR VPWR sky130_fd_sc_hd__decap_8
XTAP_TAPCELL_ROW_46_805 VGND VPWR sky130_fd_sc_hd__tapvpwrvgnd_1
XFILLER_56_681 VPWR VGND VPWR VGND sky130_ef_sc_hd__decap_12
XFILLER_18_83 VGND VGND VPWR VPWR sky130_fd_sc_hd__fill_1
XFILLER_16_545 VGND VGND VPWR VPWR sky130_fd_sc_hd__decap_8
XFILLER_16_589 VGND VGND VPWR VPWR sky130_fd_sc_hd__decap_4
XTAP_TAPCELL_ROW_26_562 VGND VPWR sky130_fd_sc_hd__tapvpwrvgnd_1
XFILLER_34_60 VPWR VGND VPWR VGND sky130_ef_sc_hd__decap_12
XFILLER_43_397 VGND VGND VPWR VPWR sky130_fd_sc_hd__fill_1
XFILLER_7_210 VGND VGND VPWR VPWR sky130_fd_sc_hd__fill_1
XFILLER_7_265 VPWR VGND VPWR VGND sky130_ef_sc_hd__decap_12
XFILLER_112_369 VGND VGND VPWR VPWR sky130_fd_sc_hd__fill_1
XFILLER_78_272 VGND VGND VPWR VPWR sky130_fd_sc_hd__decap_8
XFILLER_78_261 VGND VGND VPWR VPWR sky130_fd_sc_hd__fill_1
XPHY_EDGE_ROW_0_Left_118 VGND VGND VPWR VPWR sky130_fd_sc_hd__decap_3
XFILLER_78_294 VPWR VGND VPWR VGND sky130_ef_sc_hd__decap_12
XFILLER_15_3 VPWR VGND VPWR VGND sky130_ef_sc_hd__decap_12
XFILLER_93_264 VGND VGND VPWR VPWR sky130_fd_sc_hd__decap_4
XFILLER_26_309 VGND VGND VPWR VPWR sky130_fd_sc_hd__decap_8
XFILLER_38_169 VGND VGND VPWR VPWR sky130_fd_sc_hd__decap_6
X_6950_ _2368_ _2370_ _2369_ VGND VGND VPWR VPWR _2419_ sky130_fd_sc_hd__o21ai_1
XTAP_TAPCELL_ROW_109_1560 VGND VPWR sky130_fd_sc_hd__tapvpwrvgnd_1
X_5901_ net453 net354 VGND VGND VPWR VPWR _1438_ sky130_fd_sc_hd__nand2_4
XFILLER_93_297 VGND VGND VPWR VPWR sky130_fd_sc_hd__decap_8
XFILLER_66_489 VGND VGND VPWR VPWR sky130_fd_sc_hd__decap_6
XFILLER_19_361 VPWR VGND VPWR VGND sky130_ef_sc_hd__decap_12
X_6881_ _2350_ _2351_ VGND VGND VPWR VPWR _2352_ sky130_fd_sc_hd__xnor2_1
XFILLER_34_342 VGND VGND VPWR VPWR sky130_fd_sc_hd__fill_1
X_8620_ net176 _3995_ VGND VGND VPWR VPWR _3997_ sky130_fd_sc_hd__xnor2_1
X_5832_ _1331_ _1334_ _1369_ _1370_ VGND VGND VPWR VPWR _1371_ sky130_fd_sc_hd__o211a_1
X_8551_ net571 _3927_ net574 VGND VGND VPWR VPWR _3930_ sky130_fd_sc_hd__a21oi_2
X_5763_ _1301_ _1302_ VGND VGND VPWR VPWR _1304_ sky130_fd_sc_hd__xnor2_1
X_7502_ _2926_ _2929_ _2925_ VGND VGND VPWR VPWR _2956_ sky130_fd_sc_hd__o21ba_4
X_4714_ _4429_ _0464_ VGND VGND VPWR VPWR _0465_ sky130_fd_sc_hd__and2_1
XFILLER_108_609 VPWR VGND VPWR VGND sky130_ef_sc_hd__decap_12
X_5694_ net1020 _1237_ net234 VGND VGND VPWR VPWR _1240_ sky130_fd_sc_hd__a21boi_1
X_8482_ net188 _3860_ _3862_ VGND VGND VPWR VPWR _3863_ sky130_fd_sc_hd__or3b_1
X_7433_ net196 _2857_ _2856_ VGND VGND VPWR VPWR _2889_ sky130_fd_sc_hd__a21oi_1
X_4645_ pe_array\[3\].u_pe.accum_reg\[7\] _4404_ _4406_ VGND VGND VPWR VPWR _4407_
+ sky130_fd_sc_hd__and3_1
X_7364_ net425 _2822_ VGND VGND VPWR VPWR _0312_ sky130_fd_sc_hd__nor2_1
X_4576_ _4337_ _4338_ _4331_ VGND VGND VPWR VPWR _4340_ sky130_fd_sc_hd__a21o_1
X_6315_ net411 pe_array\[0\].u_pe.accum_reg\[18\] net241 _1841_ VGND VGND VPWR VPWR
+ _1842_ sky130_fd_sc_hd__o2bb2a_4
X_9103_ clknet_leaf_1_clk _0215_ VGND VGND VPWR VPWR pe_array\[2\].u_pe.weight_in\[1\]
+ sky130_fd_sc_hd__dfxtp_1
XTAP_TAPCELL_ROW_73_1125 VGND VPWR sky130_fd_sc_hd__tapvpwrvgnd_1
X_7295_ _2723_ _2752_ _2754_ VGND VGND VPWR VPWR _2756_ sky130_fd_sc_hd__or3_1
X_9034_ clknet_leaf_41_clk _0146_ VGND VGND VPWR VPWR net106 sky130_fd_sc_hd__dfxtp_1
X_6246_ _1773_ _1774_ VGND VGND VPWR VPWR _1775_ sky130_fd_sc_hd__nand2b_1
X_6177_ _1668_ _1706_ _1707_ VGND VGND VPWR VPWR _1708_ sky130_fd_sc_hd__or3_1
XFILLER_111_391 VGND VGND VPWR VPWR sky130_fd_sc_hd__fill_1
XFILLER_57_423 VGND VGND VPWR VPWR sky130_fd_sc_hd__fill_1
X_5128_ _0836_ _0866_ VGND VGND VPWR VPWR _0868_ sky130_fd_sc_hd__xor2_2
XFILLER_29_169 VGND VGND VPWR VPWR sky130_fd_sc_hd__fill_1
XFILLER_84_275 VPWR VGND VPWR VGND sky130_ef_sc_hd__decap_12
XFILLER_72_437 VGND VGND VPWR VPWR sky130_fd_sc_hd__fill_1
X_5059_ net184 _0762_ _0761_ VGND VGND VPWR VPWR _0801_ sky130_fd_sc_hd__o21bai_1
XFILLER_45_629 VPWR VGND VPWR VGND sky130_ef_sc_hd__decap_12
XFILLER_72_459 VPWR VGND VPWR VGND sky130_ef_sc_hd__decap_12
XFILLER_53_651 VGND VGND VPWR VPWR sky130_fd_sc_hd__decap_8
X_8818_ _4186_ _4187_ VGND VGND VPWR VPWR _4188_ sky130_fd_sc_hd__xnor2_1
XTAP_TAPCELL_ROW_84_1265 VGND VPWR sky130_fd_sc_hd__tapvpwrvgnd_1
XFILLER_80_470 VGND VGND VPWR VPWR sky130_fd_sc_hd__decap_6
XFILLER_13_515 VGND VGND VPWR VPWR sky130_fd_sc_hd__fill_1
XTAP_TAPCELL_ROW_23_532 VGND VPWR sky130_fd_sc_hd__tapvpwrvgnd_1
X_8749_ _4095_ _4092_ _4121_ VGND VGND VPWR VPWR _4122_ sky130_fd_sc_hd__a21oi_4
XTAP_TAPCELL_ROW_51_863 VGND VPWR sky130_fd_sc_hd__tapvpwrvgnd_1
XPHY_EDGE_ROW_109_Right_109 VGND VGND VPWR VPWR sky130_fd_sc_hd__decap_3
XFILLER_106_141 VPWR VGND VPWR VGND sky130_ef_sc_hd__decap_12
XFILLER_4_257 VGND VGND VPWR VPWR sky130_fd_sc_hd__fill_1
XTAP_TAPCELL_ROW_95_1394 VGND VPWR sky130_fd_sc_hd__tapvpwrvgnd_1
XFILLER_75_253 VPWR VGND VPWR VGND sky130_ef_sc_hd__decap_12
XTAP_TAPCELL_ROW_59_963 VGND VPWR sky130_fd_sc_hd__tapvpwrvgnd_1
XFILLER_75_297 VGND VGND VPWR VPWR sky130_fd_sc_hd__fill_2
XFILLER_48_489 VGND VGND VPWR VPWR sky130_fd_sc_hd__decap_6
XFILLER_90_234 VGND VGND VPWR VPWR sky130_fd_sc_hd__fill_1
XTAP_TAPCELL_ROW_3_290 VGND VPWR sky130_fd_sc_hd__tapvpwrvgnd_1
XFILLER_43_150 VGND VGND VPWR VPWR sky130_fd_sc_hd__decap_8
XFILLER_45_81 VPWR VGND VPWR VGND sky130_ef_sc_hd__decap_12
XFILLER_71_481 VPWR VGND VPWR VGND sky130_ef_sc_hd__decap_12
XFILLER_31_334 VGND VGND VPWR VPWR sky130_fd_sc_hd__fill_2
XANTENNA_2 pe_array\[3\].u_pe.weight_in\[3\] VGND VGND VPWR VPWR sky130_fd_sc_hd__diode_2
XFILLER_6_53 VPWR VGND VPWR VGND sky130_ef_sc_hd__decap_12
X_6100_ _1631_ _1632_ VGND VGND VPWR VPWR _1633_ sky130_fd_sc_hd__nand2b_1
XFILLER_112_133 VGND VGND VPWR VPWR sky130_fd_sc_hd__decap_6
XFILLER_98_345 VGND VGND VPWR VPWR sky130_fd_sc_hd__decap_3
X_7080_ net551 _2544_ net540 VGND VGND VPWR VPWR _2546_ sky130_fd_sc_hd__nor3_1
Xfanout509 net510 VGND VGND VPWR VPWR net509 sky130_fd_sc_hd__buf_6
XFILLER_100_317 VPWR VGND VPWR VGND sky130_ef_sc_hd__decap_12
XFILLER_100_306 VGND VGND VPWR VPWR sky130_fd_sc_hd__fill_2
XFILLER_98_378 VGND VGND VPWR VPWR sky130_fd_sc_hd__decap_8
X_6031_ _1556_ _1564_ VGND VGND VPWR VPWR _1565_ sky130_fd_sc_hd__nand2b_1
XFILLER_39_401 VGND VGND VPWR VPWR sky130_fd_sc_hd__fill_1
XFILLER_81_201 VGND VGND VPWR VPWR sky130_fd_sc_hd__decap_6
X_7982_ _3374_ _3375_ VGND VGND VPWR VPWR _3376_ sky130_fd_sc_hd__nor2_1
Xrebuffer25 net539 VGND VGND VPWR VPWR net540 sky130_fd_sc_hd__dlymetal6s2s_1
Xrebuffer14 _2455_ VGND VGND VPWR VPWR net529 sky130_fd_sc_hd__dlygate4sd1_1
Xrebuffer47 _3691_ VGND VGND VPWR VPWR net562 sky130_fd_sc_hd__dlymetal6s2s_1
XFILLER_26_139 VGND VGND VPWR VPWR sky130_fd_sc_hd__fill_1
X_6933_ net500 _4234_ VGND VGND VPWR VPWR _2402_ sky130_fd_sc_hd__nor2_1
Xrebuffer69 _4304_ VGND VGND VPWR VPWR net584 sky130_fd_sc_hd__dlygate4sd1_1
X_6864_ _2295_ _2294_ _2333_ _2334_ VGND VGND VPWR VPWR _2335_ sky130_fd_sc_hd__a211o_1
XFILLER_35_673 VGND VGND VPWR VPWR sky130_fd_sc_hd__decap_4
X_8603_ _3912_ _3979_ _3972_ _3943_ VGND VGND VPWR VPWR _3980_ sky130_fd_sc_hd__a211o_1
X_5815_ net480 net352 net350 net490 VGND VGND VPWR VPWR _1354_ sky130_fd_sc_hd__a22o_1
X_6795_ _2239_ _2240_ _2266_ _2267_ VGND VGND VPWR VPWR _2268_ sky130_fd_sc_hd__o211ai_2
X_5746_ net428 _1287_ VGND VGND VPWR VPWR _0229_ sky130_fd_sc_hd__nor2_1
X_8534_ _3886_ _3877_ VGND VGND VPWR VPWR _3914_ sky130_fd_sc_hd__nand2_4
XFILLER_22_389 VPWR VGND VPWR VGND sky130_ef_sc_hd__decap_12
XFILLER_41_39 VPWR VGND VPWR VGND sky130_ef_sc_hd__decap_12
Xrebuffer126 net643 VGND VGND VPWR VPWR net641 sky130_fd_sc_hd__buf_6
X_8465_ _3814_ _3816_ VGND VGND VPWR VPWR _3847_ sky130_fd_sc_hd__and2_1
X_5677_ net15 _1230_ _1231_ net321 VGND VGND VPWR VPWR _0216_ sky130_fd_sc_hd__a22o_1
Xrebuffer137 _0779_ VGND VGND VPWR VPWR net652 sky130_fd_sc_hd__clkbuf_1
X_7416_ _2845_ _2816_ _2788_ VGND VGND VPWR VPWR _2873_ sky130_fd_sc_hd__or3b_1
X_4628_ net509 _4230_ VGND VGND VPWR VPWR _4390_ sky130_fd_sc_hd__nor2_1
X_8396_ net189 _3739_ _3737_ VGND VGND VPWR VPWR _3780_ sky130_fd_sc_hd__a21o_1
X_7347_ net165 _2804_ _2805_ VGND VGND VPWR VPWR _2806_ sky130_fd_sc_hd__or3_1
X_4559_ _4299_ _4301_ _4298_ VGND VGND VPWR VPWR _4323_ sky130_fd_sc_hd__o21bai_1
XFILLER_104_645 VGND VGND VPWR VPWR sky130_fd_sc_hd__decap_3
XFILLER_103_111 VGND VGND VPWR VPWR sky130_fd_sc_hd__fill_1
X_7278_ net193 _2736_ _2738_ VGND VGND VPWR VPWR _2739_ sky130_fd_sc_hd__or3b_4
XFILLER_103_166 VGND VGND VPWR VPWR sky130_fd_sc_hd__fill_2
X_6229_ _1720_ _1721_ _1755_ _1756_ VGND VGND VPWR VPWR _1758_ sky130_fd_sc_hd__o211ai_1
X_9017_ clknet_leaf_42_clk _0129_ VGND VGND VPWR VPWR net87 sky130_fd_sc_hd__dfxtp_1
XFILLER_106_65 VPWR VGND VPWR VGND sky130_ef_sc_hd__decap_12
XFILLER_66_58 VGND VGND VPWR VPWR sky130_fd_sc_hd__decap_3
XFILLER_18_618 VPWR VGND VPWR VGND sky130_ef_sc_hd__decap_12
XFILLER_57_264 VGND VGND VPWR VPWR sky130_fd_sc_hd__decap_3
XTAP_TAPCELL_ROW_56_922 VGND VPWR sky130_fd_sc_hd__tapvpwrvgnd_1
XFILLER_82_35 VGND VGND VPWR VPWR sky130_fd_sc_hd__decap_3
XFILLER_60_429 VGND VGND VPWR VPWR sky130_fd_sc_hd__decap_6
XFILLER_25_150 VGND VGND VPWR VPWR sky130_fd_sc_hd__decap_6
XFILLER_13_334 VGND VGND VPWR VPWR sky130_fd_sc_hd__fill_2
XFILLER_13_301 VPWR VGND VPWR VGND sky130_ef_sc_hd__decap_12
XFILLER_25_172 VGND VGND VPWR VPWR sky130_fd_sc_hd__decap_4
XTAP_TAPCELL_ROW_36_690 VGND VPWR sky130_fd_sc_hd__tapvpwrvgnd_1
XFILLER_9_305 VPWR VGND VPWR VGND sky130_ef_sc_hd__decap_12
XFILLER_13_367 VPWR VGND VPWR VGND sky130_ef_sc_hd__decap_12
XFILLER_15_51 VGND VGND VPWR VPWR sky130_fd_sc_hd__fill_1
XTAP_TAPCELL_ROW_97_1423 VGND VPWR sky130_fd_sc_hd__tapvpwrvgnd_1
XTAP_TAPCELL_ROW_97_1412 VGND VPWR sky130_fd_sc_hd__tapvpwrvgnd_1
XFILLER_31_83 VGND VGND VPWR VPWR sky130_fd_sc_hd__decap_3
XFILLER_107_483 VGND VGND VPWR VPWR sky130_fd_sc_hd__fill_2
Xoutput61 net61 VGND VGND VPWR VPWR result_data[1] sky130_fd_sc_hd__buf_2
Xoutput50 net50 VGND VGND VPWR VPWR result_data[125] sky130_fd_sc_hd__buf_2
Xoutput94 net94 VGND VGND VPWR VPWR result_data[4] sky130_fd_sc_hd__buf_2
Xoutput72 net72 VGND VGND VPWR VPWR result_data[2] sky130_fd_sc_hd__buf_2
Xoutput83 net83 VGND VGND VPWR VPWR result_data[3] sky130_fd_sc_hd__buf_2
XFILLER_95_304 VGND VGND VPWR VPWR sky130_fd_sc_hd__fill_1
XFILLER_68_529 VGND VGND VPWR VPWR sky130_fd_sc_hd__decap_3
XFILLER_95_337 VGND VGND VPWR VPWR sky130_fd_sc_hd__decap_3
XPHY_EDGE_ROW_90_Left_208 VGND VGND VPWR VPWR sky130_fd_sc_hd__decap_3
XFILLER_36_404 VPWR VGND VPWR VGND sky130_ef_sc_hd__decap_12
XTAP_TAPCELL_ROW_106_1530 VGND VPWR sky130_fd_sc_hd__tapvpwrvgnd_1
XFILLER_17_673 VGND VGND VPWR VPWR sky130_fd_sc_hd__decap_3
XFILLER_16_194 VGND VGND VPWR VPWR sky130_fd_sc_hd__fill_2
X_6580_ _2092_ _1985_ _2093_ _2096_ VGND VGND VPWR VPWR _2097_ sky130_fd_sc_hd__a31oi_4
X_5600_ net958 net374 VGND VGND VPWR VPWR _0141_ sky130_fd_sc_hd__and2_1
X_5531_ net392 net891 VGND VGND VPWR VPWR _0076_ sky130_fd_sc_hd__and2_1
XFILLER_117_225 VGND VGND VPWR VPWR sky130_fd_sc_hd__fill_2
X_8250_ _3634_ _3635_ net683 VGND VGND VPWR VPWR _3638_ sky130_fd_sc_hd__o21ai_1
XFILLER_105_409 VGND VGND VPWR VPWR sky130_fd_sc_hd__fill_1
X_5462_ _1181_ _1189_ VGND VGND VPWR VPWR _1190_ sky130_fd_sc_hd__xnor2_1
X_7201_ _2623_ _2662_ VGND VGND VPWR VPWR _2664_ sky130_fd_sc_hd__and2_4
XTAP_TAPCELL_ROW_117_1670 VGND VPWR sky130_fd_sc_hd__tapvpwrvgnd_1
X_8181_ _3568_ _3569_ _3500_ _3503_ VGND VGND VPWR VPWR _3571_ sky130_fd_sc_hd__o211a_1
X_5393_ _1093_ _1096_ _1122_ VGND VGND VPWR VPWR _1124_ sky130_fd_sc_hd__and3_1
XFILLER_98_131 VGND VGND VPWR VPWR sky130_fd_sc_hd__decap_8
X_7132_ _2594_ _2595_ _2596_ VGND VGND VPWR VPWR _2597_ sky130_fd_sc_hd__nand3_2
Xfanout317 net319 VGND VGND VPWR VPWR net317 sky130_fd_sc_hd__buf_2
Xfanout339 net340 VGND VGND VPWR VPWR net339 sky130_fd_sc_hd__buf_2
X_7063_ net406 pe_array\[1\].u_pe.accum_reg\[10\] net231 _2529_ VGND VGND VPWR VPWR
+ _2530_ sky130_fd_sc_hd__o2bb2a_1
Xfanout328 pe_array\[1\].u_pe.weight_in\[5\] VGND VGND VPWR VPWR net328 sky130_fd_sc_hd__clkbuf_2
Xfanout306 net307 VGND VGND VPWR VPWR net306 sky130_fd_sc_hd__buf_2
XFILLER_98_197 VGND VGND VPWR VPWR sky130_fd_sc_hd__fill_2
XFILLER_86_337 VGND VGND VPWR VPWR sky130_fd_sc_hd__fill_1
X_6014_ _1501_ _1548_ VGND VGND VPWR VPWR _1549_ sky130_fd_sc_hd__and2b_1
XFILLER_100_158 VPWR VGND VPWR VGND sky130_ef_sc_hd__decap_12
XFILLER_100_136 VGND VGND VPWR VPWR sky130_fd_sc_hd__fill_1
XFILLER_67_573 VPWR VGND VPWR VGND sky130_ef_sc_hd__decap_12
X_7965_ net404 pe_array\[2\].u_pe.accum_reg\[6\] net219 _3359_ VGND VGND VPWR VPWR
+ _3360_ sky130_fd_sc_hd__o2bb2a_1
XTAP_TAPCELL_ROW_68_1068 VGND VPWR sky130_fd_sc_hd__tapvpwrvgnd_1
X_7896_ pe_array\[2\].u_pe.accum_reg\[5\] net496 net318 VGND VGND VPWR VPWR _3292_
+ sky130_fd_sc_hd__and3_4
XTAP_TAPCELL_ROW_81_1224 VGND VPWR sky130_fd_sc_hd__tapvpwrvgnd_1
X_6916_ _2384_ _2385_ VGND VGND VPWR VPWR _2386_ sky130_fd_sc_hd__nor2_1
XFILLER_52_27 VGND VGND VPWR VPWR sky130_fd_sc_hd__fill_1
X_6847_ net587 net329 net327 net510 VGND VGND VPWR VPWR _2318_ sky130_fd_sc_hd__a22o_1
XTAP_TAPCELL_ROW_61_991 VGND VPWR sky130_fd_sc_hd__tapvpwrvgnd_1
XTAP_TAPCELL_ROW_61_980 VGND VPWR sky130_fd_sc_hd__tapvpwrvgnd_1
X_6778_ _2250_ _2251_ VGND VGND VPWR VPWR _2252_ sky130_fd_sc_hd__and2_1
XFILLER_22_164 VPWR VGND VPWR VGND sky130_ef_sc_hd__decap_12
XFILLER_23_698 VGND VGND VPWR VPWR sky130_fd_sc_hd__fill_2
X_8517_ net187 _3894_ _3896_ VGND VGND VPWR VPWR _3897_ sky130_fd_sc_hd__or3b_4
X_5729_ _1268_ _1269_ net496 net354 VGND VGND VPWR VPWR _1271_ sky130_fd_sc_hd__or4bb_1
XFILLER_10_348 VPWR VGND VPWR VGND sky130_ef_sc_hd__decap_12
XFILLER_22_197 VGND VGND VPWR VPWR sky130_fd_sc_hd__fill_2
X_8448_ net263 _3827_ _3828_ VGND VGND VPWR VPWR _3830_ sky130_fd_sc_hd__or3_1
XTAP_TAPCELL_ROW_79_1197 VGND VPWR sky130_fd_sc_hd__tapvpwrvgnd_1
X_8379_ _3760_ _3655_ _3657_ _3617_ VGND VGND VPWR VPWR _3764_ sky130_fd_sc_hd__and4_1
XFILLER_117_53 VGND VGND VPWR VPWR sky130_fd_sc_hd__decap_3
XTAP_TAPCELL_ROW_92_1353 VGND VPWR sky130_fd_sc_hd__tapvpwrvgnd_1
XFILLER_89_120 VGND VGND VPWR VPWR sky130_fd_sc_hd__fill_2
XFILLER_117_97 VPWR VGND VPWR VGND sky130_ef_sc_hd__decap_12
Xhold393 pe_accum\[0\]\[24\] VGND VGND VPWR VPWR net908 sky130_fd_sc_hd__dlygate4sd3_1
Xhold382 pe_accum\[0\]\[4\] VGND VGND VPWR VPWR net897 sky130_fd_sc_hd__dlygate4sd3_1
XFILLER_104_475 VGND VGND VPWR VPWR sky130_fd_sc_hd__fill_1
XFILLER_89_186 VGND VGND VPWR VPWR sky130_fd_sc_hd__decap_6
XFILLER_77_337 VGND VGND VPWR VPWR sky130_fd_sc_hd__fill_2
XFILLER_77_315 VPWR VGND VPWR VGND sky130_ef_sc_hd__decap_12
XTAP_TAPCELL_ROW_101_1460 VGND VPWR sky130_fd_sc_hd__tapvpwrvgnd_1
XTAP_TAPCELL_ROW_101_1471 VGND VPWR sky130_fd_sc_hd__tapvpwrvgnd_1
Xrebuffer5 _2563_ VGND VGND VPWR VPWR net520 sky130_fd_sc_hd__dlymetal6s2s_1
XTAP_TAPCELL_ROW_11_387 VGND VPWR sky130_fd_sc_hd__tapvpwrvgnd_1
XFILLER_54_7 VPWR VGND VPWR VGND sky130_ef_sc_hd__decap_12
XFILLER_96_635 VGND VGND VPWR VPWR sky130_fd_sc_hd__fill_2
XFILLER_68_315 VGND VGND VPWR VPWR sky130_fd_sc_hd__fill_1
XFILLER_110_467 VGND VGND VPWR VPWR sky130_fd_sc_hd__decap_8
XFILLER_96_657 VPWR VGND VPWR VGND sky130_ef_sc_hd__decap_12
XFILLER_95_167 VGND VGND VPWR VPWR sky130_fd_sc_hd__fill_1
XFILLER_67_90 VGND VGND VPWR VPWR sky130_fd_sc_hd__decap_6
XTAP_TAPCELL_ROW_39_719 VGND VPWR sky130_fd_sc_hd__tapvpwrvgnd_1
XFILLER_64_565 VGND VGND VPWR VPWR sky130_fd_sc_hd__fill_2
XFILLER_51_237 VPWR VGND VPWR VGND sky130_ef_sc_hd__decap_12
XTAP_TAPCELL_ROW_19_476 VGND VPWR sky130_fd_sc_hd__tapvpwrvgnd_1
XTAP_TAPCELL_ROW_19_487 VGND VPWR sky130_fd_sc_hd__tapvpwrvgnd_1
X_7750_ net1003 net225 _3184_ net376 VGND VGND VPWR VPWR _0336_ sky130_fd_sc_hd__o211a_1
X_4962_ _0682_ _0705_ _0706_ VGND VGND VPWR VPWR _0707_ sky130_fd_sc_hd__or3_4
X_6701_ net895 net236 _1676_ net244 VGND VGND VPWR VPWR _0271_ sky130_fd_sc_hd__o2bb2ai_1
X_4893_ _0635_ _0639_ VGND VGND VPWR VPWR _0640_ sky130_fd_sc_hd__nor2_2
X_7681_ _3127_ _3128_ VGND VGND VPWR VPWR _3129_ sky130_fd_sc_hd__nor2_1
X_6632_ net172 _2147_ VGND VGND VPWR VPWR _2148_ sky130_fd_sc_hd__and2_1
XFILLER_32_473 VGND VGND VPWR VPWR sky130_fd_sc_hd__decap_3
X_6563_ _2078_ _2079_ VGND VGND VPWR VPWR _2081_ sky130_fd_sc_hd__xnor2_1
X_6494_ net276 _2012_ _2013_ VGND VGND VPWR VPWR _2014_ sky130_fd_sc_hd__or3_1
X_9282_ clknet_leaf_8_clk _0394_ VGND VGND VPWR VPWR pe_array\[2\].u_pe.accum_reg\[24\]
+ sky130_fd_sc_hd__dfxtp_1
X_8302_ _3663_ _3687_ _3688_ VGND VGND VPWR VPWR _3689_ sky130_fd_sc_hd__or3_1
X_5514_ net977 net246 _1217_ net363 VGND VGND VPWR VPWR _0067_ sky130_fd_sc_hd__o211a_1
XTAP_TAPCELL_ROW_115_1629 VGND VPWR sky130_fd_sc_hd__tapvpwrvgnd_1
X_8233_ _3617_ _3621_ VGND VGND VPWR VPWR _3622_ sky130_fd_sc_hd__xnor2_1
X_5445_ _1147_ _1173_ VGND VGND VPWR VPWR _1174_ sky130_fd_sc_hd__xnor2_1
X_8164_ net439 net314 pe_array\[2\].u_pe.accum_reg\[11\] VGND VGND VPWR VPWR _3554_
+ sky130_fd_sc_hd__a21oi_1
X_5376_ _1105_ _1106_ VGND VGND VPWR VPWR _1107_ sky130_fd_sc_hd__nor2_1
X_7115_ net875 _4234_ VGND VGND VPWR VPWR _2580_ sky130_fd_sc_hd__nor2_1
X_8095_ _3444_ _3445_ _3486_ VGND VGND VPWR VPWR _3487_ sky130_fd_sc_hd__and3_1
XFILLER_59_337 VGND VGND VPWR VPWR sky130_fd_sc_hd__fill_2
Xfanout158 _1717_ VGND VGND VPWR VPWR net158 sky130_fd_sc_hd__buf_2
Xfanout169 net170 VGND VGND VPWR VPWR net169 sky130_fd_sc_hd__clkbuf_2
X_7046_ _2510_ _2511_ net544 VGND VGND VPWR VPWR _2513_ sky130_fd_sc_hd__nand3_4
XFILLER_74_329 VPWR VGND VPWR VGND sky130_ef_sc_hd__decap_12
X_8997_ clknet_leaf_26_clk _0109_ VGND VGND VPWR VPWR net65 sky130_fd_sc_hd__dfxtp_1
XFILLER_103_55 VGND VGND VPWR VPWR sky130_fd_sc_hd__fill_1
XFILLER_70_502 VGND VGND VPWR VPWR sky130_fd_sc_hd__fill_2
XFILLER_63_15 VPWR VGND VPWR VGND sky130_ef_sc_hd__decap_12
XFILLER_103_99 VGND VGND VPWR VPWR sky130_fd_sc_hd__fill_1
X_7948_ net506 pe_array\[2\].u_pe.weight_in\[4\] _3300_ _3299_ net324 VGND VGND VPWR
+ VPWR _3343_ sky130_fd_sc_hd__a32o_1
XFILLER_15_429 VPWR VGND VPWR VGND sky130_ef_sc_hd__decap_12
X_7879_ _3274_ _3275_ VGND VGND VPWR VPWR _3276_ sky130_fd_sc_hd__or2_1
XFILLER_50_270 VGND VGND VPWR VPWR sky130_fd_sc_hd__fill_2
XFILLER_109_523 VPWR VGND VPWR VGND sky130_ef_sc_hd__decap_12
XFILLER_7_617 VPWR VGND VPWR VGND sky130_ef_sc_hd__decap_12
XFILLER_12_63 VPWR VGND VPWR VGND sky130_ef_sc_hd__decap_12
XFILLER_12_41 VPWR VGND VPWR VGND sky130_ef_sc_hd__decap_12
XFILLER_6_138 VGND VGND VPWR VPWR sky130_fd_sc_hd__fill_2
XFILLER_12_85 VPWR VGND VPWR VGND sky130_ef_sc_hd__decap_12
XFILLER_2_333 VGND VGND VPWR VPWR sky130_fd_sc_hd__fill_1
XFILLER_104_283 VGND VGND VPWR VPWR sky130_fd_sc_hd__decap_8
XFILLER_93_605 VGND VGND VPWR VPWR sky130_fd_sc_hd__fill_1
XFILLER_78_657 VPWR VGND VPWR VGND sky130_ef_sc_hd__decap_12
XFILLER_77_134 VGND VGND VPWR VPWR sky130_fd_sc_hd__decap_8
XFILLER_92_126 VGND VGND VPWR VPWR sky130_fd_sc_hd__fill_1
XFILLER_18_212 VGND VGND VPWR VPWR sky130_fd_sc_hd__fill_1
XPHY_EDGE_ROW_16_Right_16 VGND VGND VPWR VPWR sky130_fd_sc_hd__decap_3
XFILLER_73_373 VPWR VGND VPWR VGND sky130_ef_sc_hd__decap_12
XFILLER_46_587 VGND VGND VPWR VPWR sky130_fd_sc_hd__fill_1
XTAP_TAPCELL_ROW_16_446 VGND VPWR sky130_fd_sc_hd__tapvpwrvgnd_1
XFILLER_33_237 VGND VGND VPWR VPWR sky130_fd_sc_hd__fill_2
XFILLER_53_81 VPWR VGND VPWR VGND sky130_ef_sc_hd__decap_12
XTAP_TAPCELL_ROW_44_777 VGND VPWR sky130_fd_sc_hd__tapvpwrvgnd_1
XFILLER_41_281 VGND VGND VPWR VPWR sky130_fd_sc_hd__decap_8
XPHY_EDGE_ROW_25_Right_25 VGND VGND VPWR VPWR sky130_fd_sc_hd__decap_3
X_5230_ net183 _0965_ VGND VGND VPWR VPWR _0966_ sky130_fd_sc_hd__nor2_1
XFILLER_45_3 VPWR VGND VPWR VGND sky130_ef_sc_hd__decap_12
X_5161_ net397 pe_array\[3\].u_pe.accum_reg\[20\] net255 _0899_ VGND VGND VPWR VPWR
+ _0900_ sky130_fd_sc_hd__o2bb2a_4
XFILLER_96_443 VGND VGND VPWR VPWR sky130_fd_sc_hd__fill_1
XFILLER_68_145 VGND VGND VPWR VPWR sky130_fd_sc_hd__fill_1
X_5092_ _0831_ _0832_ VGND VGND VPWR VPWR _0833_ sky130_fd_sc_hd__and2b_1
XFILLER_110_253 VPWR VGND VPWR VGND sky130_ef_sc_hd__decap_12
XFILLER_84_638 VGND VGND VPWR VPWR sky130_fd_sc_hd__decap_6
X_8920_ clknet_leaf_65_clk _0032_ VGND VGND VPWR VPWR pe_array\[3\].u_pe.accum_reg\[20\]
+ sky130_fd_sc_hd__dfxtp_1
XPHY_EDGE_ROW_34_Right_34 VGND VGND VPWR VPWR sky130_fd_sc_hd__decap_3
X_8851_ net935 net209 _4206_ net382 VGND VGND VPWR VPWR _0415_ sky130_fd_sc_hd__o211a_1
X_8782_ _4119_ _4122_ _4150_ _4151_ VGND VGND VPWR VPWR _4154_ sky130_fd_sc_hd__o211ai_2
X_5994_ net275 _1526_ _1527_ VGND VGND VPWR VPWR _1529_ sky130_fd_sc_hd__or3_1
X_7802_ net20 _3206_ _3207_ net1035 VGND VGND VPWR VPWR _0365_ sky130_fd_sc_hd__a22o_1
XTAP_TAPCELL_ROW_65_1038 VGND VPWR sky130_fd_sc_hd__tapvpwrvgnd_1
X_7733_ net226 _2236_ VGND VGND VPWR VPWR _3176_ sky130_fd_sc_hd__nand2_1
X_4945_ pe_array\[3\].u_pe.accum_reg\[14\] net298 net435 VGND VGND VPWR VPWR _0690_
+ sky130_fd_sc_hd__and3_1
X_4876_ _0609_ _0621_ _0622_ VGND VGND VPWR VPWR _0623_ sky130_fd_sc_hd__and3_1
X_7664_ _3110_ _3111_ VGND VGND VPWR VPWR _3112_ sky130_fd_sc_hd__nand2_1
X_6615_ net274 _2129_ _2130_ VGND VGND VPWR VPWR _2131_ sky130_fd_sc_hd__nor3_1
XFILLER_20_465 VGND VGND VPWR VPWR sky130_fd_sc_hd__decap_8
X_7595_ net273 _3043_ _3044_ VGND VGND VPWR VPWR _3045_ sky130_fd_sc_hd__nor3_1
XPHY_EDGE_ROW_43_Right_43 VGND VGND VPWR VPWR sky130_fd_sc_hd__decap_3
X_6546_ pe_array\[0\].u_pe.accum_reg\[27\] net612 net356 VGND VGND VPWR VPWR _2064_
+ sky130_fd_sc_hd__and3_1
X_6477_ net654 _1997_ VGND VGND VPWR VPWR _1998_ sky130_fd_sc_hd__xnor2_1
X_9265_ clknet_leaf_2_clk _0377_ VGND VGND VPWR VPWR pe_array\[2\].u_pe.accum_reg\[7\]
+ sky130_fd_sc_hd__dfxtp_1
XTAP_TAPCELL_ROW_76_1167 VGND VPWR sky130_fd_sc_hd__tapvpwrvgnd_1
X_8216_ _3591_ _3604_ _3603_ VGND VGND VPWR VPWR _3605_ sky130_fd_sc_hd__and3_1
X_9196_ clknet_3_2__leaf_clk _0308_ VGND VGND VPWR VPWR pe_array\[1\].u_pe.accum_reg\[14\]
+ sky130_fd_sc_hd__dfxtp_1
X_5428_ net185 _1138_ _1137_ VGND VGND VPWR VPWR _1157_ sky130_fd_sc_hd__o21ba_1
X_8147_ net419 _3537_ VGND VGND VPWR VPWR _0380_ sky130_fd_sc_hd__nor2_1
XFILLER_58_15 VPWR VGND VPWR VGND sky130_ef_sc_hd__decap_12
X_5359_ net416 _1090_ VGND VGND VPWR VPWR _0039_ sky130_fd_sc_hd__nor2_1
X_8078_ _3466_ _3467_ net680 VGND VGND VPWR VPWR _3470_ sky130_fd_sc_hd__o21ai_1
XPHY_EDGE_ROW_52_Right_52 VGND VGND VPWR VPWR sky130_fd_sc_hd__decap_3
X_7029_ _2487_ _2495_ VGND VGND VPWR VPWR _2496_ sky130_fd_sc_hd__nand2b_1
XFILLER_114_65 VPWR VGND VPWR VGND sky130_ef_sc_hd__decap_12
XFILLER_28_554 VGND VGND VPWR VPWR sky130_fd_sc_hd__fill_2
XFILLER_28_565 VGND VGND VPWR VPWR sky130_fd_sc_hd__fill_1
XTAP_TAPCELL_ROW_87_1296 VGND VPWR sky130_fd_sc_hd__tapvpwrvgnd_1
XFILLER_74_69 VPWR VGND VPWR VGND sky130_ef_sc_hd__decap_12
XFILLER_70_321 VGND VGND VPWR VPWR sky130_fd_sc_hd__decap_8
XFILLER_15_237 VGND VGND VPWR VPWR sky130_fd_sc_hd__decap_3
XFILLER_90_46 VGND VGND VPWR VPWR sky130_fd_sc_hd__decap_8
XFILLER_70_365 VPWR VGND VPWR VGND sky130_ef_sc_hd__decap_12
XTAP_TAPCELL_ROW_13_405 VGND VPWR sky130_fd_sc_hd__tapvpwrvgnd_1
XPHY_EDGE_ROW_61_Right_61 VGND VGND VPWR VPWR sky130_fd_sc_hd__decap_3
XTAP_TAPCELL_ROW_41_747 VGND VPWR sky130_fd_sc_hd__tapvpwrvgnd_1
XFILLER_7_447 VGND VGND VPWR VPWR sky130_fd_sc_hd__fill_1
XFILLER_109_353 VGND VGND VPWR VPWR sky130_fd_sc_hd__fill_1
XFILLER_99_88 VGND VGND VPWR VPWR sky130_fd_sc_hd__decap_8
XFILLER_99_99 VPWR VGND VPWR VGND sky130_ef_sc_hd__decap_12
XFILLER_3_653 VPWR VGND VPWR VGND sky130_ef_sc_hd__decap_12
XPHY_EDGE_ROW_70_Right_70 VGND VGND VPWR VPWR sky130_fd_sc_hd__decap_3
XFILLER_3_697 VGND VGND VPWR VPWR sky130_fd_sc_hd__decap_3
XFILLER_2_174 VGND VGND VPWR VPWR sky130_fd_sc_hd__fill_1
XFILLER_93_413 VGND VGND VPWR VPWR sky130_fd_sc_hd__decap_4
XTAP_TAPCELL_ROW_49_836 VGND VPWR sky130_fd_sc_hd__tapvpwrvgnd_1
XTAP_TAPCELL_ROW_49_847 VGND VPWR sky130_fd_sc_hd__tapvpwrvgnd_1
XFILLER_93_457 VGND VGND VPWR VPWR sky130_fd_sc_hd__fill_1
XFILLER_80_118 VGND VGND VPWR VPWR sky130_fd_sc_hd__fill_1
XFILLER_74_693 VGND VGND VPWR VPWR sky130_fd_sc_hd__decap_3
XFILLER_61_310 VPWR VGND VPWR VGND sky130_ef_sc_hd__decap_12
X_4730_ net293 net469 VGND VGND VPWR VPWR _0480_ sky130_fd_sc_hd__nand2_1
X_4661_ _4420_ _4421_ _4360_ VGND VGND VPWR VPWR _4423_ sky130_fd_sc_hd__a21oi_1
X_6400_ pe_array\[0\].u_pe.accum_reg\[22\] net456 net359 VGND VGND VPWR VPWR _1923_
+ sky130_fd_sc_hd__and3_1
X_7380_ _2835_ _2836_ _2837_ VGND VGND VPWR VPWR _2838_ sky130_fd_sc_hd__nand3_1
X_6331_ net173 _1823_ _1822_ VGND VGND VPWR VPWR _1857_ sky130_fd_sc_hd__o21bai_1
X_4592_ net501 net292 net290 net510 VGND VGND VPWR VPWR _4355_ sky130_fd_sc_hd__a22o_1
X_6262_ _1787_ _1788_ net200 VGND VGND VPWR VPWR _1790_ sky130_fd_sc_hd__a21o_1
X_9050_ clknet_leaf_4_clk _0162_ VGND VGND VPWR VPWR net123 sky130_fd_sc_hd__dfxtp_1
XFILLER_115_389 VGND VGND VPWR VPWR sky130_fd_sc_hd__decap_3
X_6193_ _1719_ _1720_ net277 VGND VGND VPWR VPWR _1723_ sky130_fd_sc_hd__o21ai_1
X_8001_ _3348_ _3393_ VGND VGND VPWR VPWR _3395_ sky130_fd_sc_hd__xnor2_1
X_5213_ _0893_ _0921_ VGND VGND VPWR VPWR _0950_ sky130_fd_sc_hd__nor2_1
X_5144_ _0880_ _0881_ VGND VGND VPWR VPWR _0883_ sky130_fd_sc_hd__xor2_1
XFILLER_111_573 VPWR VGND VPWR VGND sky130_ef_sc_hd__decap_12
XFILLER_96_262 VPWR VGND VPWR VGND sky130_ef_sc_hd__decap_12
XFILLER_28_29 VGND VGND VPWR VPWR sky130_fd_sc_hd__decap_8
X_5075_ net295 net433 pe_array\[3\].u_pe.accum_reg\[18\] VGND VGND VPWR VPWR _0816_
+ sky130_fd_sc_hd__a21oi_1
X_8903_ clknet_leaf_57_clk _0015_ VGND VGND VPWR VPWR pe_array\[3\].u_pe.accum_reg\[3\]
+ sky130_fd_sc_hd__dfxtp_1
X_8834_ net216 _3322_ VGND VGND VPWR VPWR _4198_ sky130_fd_sc_hd__nand2_1
XFILLER_71_129 VGND VGND VPWR VPWR sky130_fd_sc_hd__decap_8
XFILLER_65_671 VGND VGND VPWR VPWR sky130_fd_sc_hd__fill_1
XFILLER_64_170 VGND VGND VPWR VPWR sky130_fd_sc_hd__decap_3
XFILLER_64_181 VGND VGND VPWR VPWR sky130_fd_sc_hd__decap_6
XFILLER_52_332 VGND VGND VPWR VPWR sky130_fd_sc_hd__decap_4
X_8765_ _4102_ _4104_ _4136_ VGND VGND VPWR VPWR _4137_ sky130_fd_sc_hd__o21a_1
X_5977_ net473 net347 net344 net481 VGND VGND VPWR VPWR _1512_ sky130_fd_sc_hd__a22oi_1
X_8696_ _4067_ _4068_ net264 VGND VGND VPWR VPWR _4070_ sky130_fd_sc_hd__o21a_1
X_7716_ pe_array\[1\].u_pe.accum_reg\[30\] net272 _2368_ VGND VGND VPWR VPWR _3162_
+ sky130_fd_sc_hd__a21o_1
XFILLER_40_549 VGND VGND VPWR VPWR sky130_fd_sc_hd__fill_2
X_4928_ _0672_ _0673_ _0631_ VGND VGND VPWR VPWR _0674_ sky130_fd_sc_hd__o21ba_1
XFILLER_60_27 VGND VGND VPWR VPWR sky130_fd_sc_hd__fill_1
X_7647_ _3095_ _3094_ VGND VGND VPWR VPWR _3096_ sky130_fd_sc_hd__and2b_1
X_4859_ _0598_ _0605_ VGND VGND VPWR VPWR _0606_ sky130_fd_sc_hd__or2_1
Xclkbuf_3_0__f_clk clknet_0_clk VGND VGND VPWR VPWR clknet_3_0__leaf_clk sky130_fd_sc_hd__clkbuf_16
X_7578_ net167 _3028_ VGND VGND VPWR VPWR _3029_ sky130_fd_sc_hd__xnor2_1
X_9317_ clknet_leaf_10_clk _0429_ VGND VGND VPWR VPWR pe_accum\[2\]\[27\] sky130_fd_sc_hd__dfxtp_1
X_6529_ net202 _2017_ _2016_ VGND VGND VPWR VPWR _2048_ sky130_fd_sc_hd__a21oi_1
XFILLER_4_417 VGND VGND VPWR VPWR sky130_fd_sc_hd__decap_3
XFILLER_109_98 VPWR VGND VPWR VGND sky130_ef_sc_hd__decap_12
X_9248_ clknet_leaf_0_clk _0360_ VGND VGND VPWR VPWR pe_array\[3\].u_pe.weight_in\[2\]
+ sky130_fd_sc_hd__dfxtp_1
XFILLER_0_601 VPWR VGND VPWR VGND sky130_ef_sc_hd__decap_12
X_9179_ clknet_leaf_40_clk _0291_ VGND VGND VPWR VPWR pe_array\[1\].u_pe.tap_count\[1\]
+ sky130_fd_sc_hd__dfxtp_1
XFILLER_0_645 VPWR VGND VPWR VGND sky130_ef_sc_hd__decap_12
XFILLER_102_562 VGND VGND VPWR VPWR sky130_fd_sc_hd__fill_1
XTAP_TAPCELL_ROW_89_1325 VGND VPWR sky130_fd_sc_hd__tapvpwrvgnd_1
XFILLER_85_68 VPWR VGND VPWR VGND sky130_ef_sc_hd__decap_12
XFILLER_85_57 VGND VGND VPWR VPWR sky130_fd_sc_hd__decap_3
XFILLER_75_457 VGND VGND VPWR VPWR sky130_fd_sc_hd__fill_1
XFILLER_63_608 VGND VGND VPWR VPWR sky130_fd_sc_hd__decap_8
XFILLER_28_351 VPWR VGND VPWR VGND sky130_ef_sc_hd__decap_12
XTAP_TAPCELL_ROW_46_806 VGND VPWR sky130_fd_sc_hd__tapvpwrvgnd_1
XFILLER_56_693 VGND VGND VPWR VPWR sky130_fd_sc_hd__decap_6
XFILLER_71_652 VGND VGND VPWR VPWR sky130_fd_sc_hd__decap_6
XFILLER_71_641 VGND VGND VPWR VPWR sky130_fd_sc_hd__decap_4
XTAP_TAPCELL_ROW_26_563 VGND VPWR sky130_fd_sc_hd__tapvpwrvgnd_1
XFILLER_34_50 VGND VGND VPWR VPWR sky130_fd_sc_hd__fill_1
XFILLER_34_83 VGND VGND VPWR VPWR sky130_fd_sc_hd__fill_1
XFILLER_7_222 VGND VGND VPWR VPWR sky130_fd_sc_hd__fill_2
XFILLER_116_109 VPWR VGND VPWR VGND sky130_ef_sc_hd__decap_12
XFILLER_7_277 VGND VGND VPWR VPWR sky130_fd_sc_hd__decap_3
XFILLER_3_461 VPWR VGND VPWR VGND sky130_ef_sc_hd__decap_12
XFILLER_93_210 VGND VGND VPWR VPWR sky130_fd_sc_hd__decap_4
XTAP_TAPCELL_ROW_109_1561 VGND VPWR sky130_fd_sc_hd__tapvpwrvgnd_1
X_5900_ _1435_ _1436_ VGND VGND VPWR VPWR _1437_ sky130_fd_sc_hd__xnor2_1
XFILLER_19_373 VPWR VGND VPWR VGND sky130_ef_sc_hd__decap_12
X_6880_ _2311_ _2313_ VGND VGND VPWR VPWR _2351_ sky130_fd_sc_hd__nor2_1
XFILLER_34_321 VGND VGND VPWR VPWR sky130_fd_sc_hd__decap_3
X_5831_ _1367_ _1368_ _1350_ VGND VGND VPWR VPWR _1370_ sky130_fd_sc_hd__a21o_1
XFILLER_62_663 VPWR VGND VPWR VGND sky130_ef_sc_hd__decap_12
X_8550_ _3927_ _3926_ _3928_ VGND VGND VPWR VPWR _3929_ sky130_fd_sc_hd__and3_1
X_5762_ _1301_ _1302_ VGND VGND VPWR VPWR _1303_ sky130_fd_sc_hd__and2b_1
XFILLER_34_387 VGND VGND VPWR VPWR sky130_fd_sc_hd__fill_1
XPHY_EDGE_ROW_101_Left_219 VGND VGND VPWR VPWR sky130_fd_sc_hd__decap_3
X_7501_ _2923_ _2953_ VGND VGND VPWR VPWR _2955_ sky130_fd_sc_hd__xnor2_1
X_4713_ _0463_ _0462_ VGND VGND VPWR VPWR _0464_ sky130_fd_sc_hd__xor2_1
X_5693_ net409 _1228_ net394 VGND VGND VPWR VPWR _1239_ sky130_fd_sc_hd__o21a_1
X_8481_ _3858_ _3859_ _3828_ _3829_ VGND VGND VPWR VPWR _3862_ sky130_fd_sc_hd__a211o_1
Xrebuffer319 _0639_ VGND VGND VPWR VPWR net834 sky130_fd_sc_hd__dlymetal6s2s_1
XFILLER_107_109 VGND VGND VPWR VPWR sky130_fd_sc_hd__decap_3
X_7432_ net196 _2887_ VGND VGND VPWR VPWR _2888_ sky130_fd_sc_hd__xnor2_1
X_4644_ net299 net477 pe_array\[3\].u_pe.weight_in\[7\] VGND VGND VPWR VPWR _4406_
+ sky130_fd_sc_hd__nand3_1
X_7363_ net407 pe_array\[1\].u_pe.accum_reg\[18\] net230 _2821_ VGND VGND VPWR VPWR
+ _2822_ sky130_fd_sc_hd__o2bb2a_1
X_4575_ _4331_ _4337_ _4338_ VGND VGND VPWR VPWR _4339_ sky130_fd_sc_hd__nand3_1
XFILLER_116_643 VGND VGND VPWR VPWR sky130_fd_sc_hd__fill_1
X_6314_ _1840_ _1837_ VGND VGND VPWR VPWR _1841_ sky130_fd_sc_hd__xnor2_2
X_9102_ clknet_leaf_0_clk _0214_ VGND VGND VPWR VPWR pe_array\[2\].u_pe.weight_in\[0\]
+ sky130_fd_sc_hd__dfxtp_1
X_7294_ _2752_ _2754_ VGND VGND VPWR VPWR _2755_ sky130_fd_sc_hd__or2_4
X_6245_ _1770_ _1771_ _1772_ VGND VGND VPWR VPWR _1774_ sky130_fd_sc_hd__a21o_1
XTAP_TAPCELL_ROW_73_1126 VGND VPWR sky130_fd_sc_hd__tapvpwrvgnd_1
XFILLER_1_409 VPWR VGND VPWR VGND sky130_ef_sc_hd__decap_12
X_9033_ clknet_leaf_42_clk _0145_ VGND VGND VPWR VPWR net104 sky130_fd_sc_hd__dfxtp_1
XFILLER_103_337 VPWR VGND VPWR VGND sky130_ef_sc_hd__decap_12
XFILLER_39_28 VPWR VGND VPWR VGND sky130_ef_sc_hd__decap_12
XPHY_EDGE_ROW_110_Left_228 VGND VGND VPWR VPWR sky130_fd_sc_hd__decap_3
X_6176_ _1704_ _1705_ _1664_ _1666_ VGND VGND VPWR VPWR _1707_ sky130_fd_sc_hd__a211oi_1
XFILLER_84_221 VGND VGND VPWR VPWR sky130_fd_sc_hd__fill_2
X_5127_ _0836_ _0866_ VGND VGND VPWR VPWR _0867_ sky130_fd_sc_hd__and2_1
XPHY_EDGE_ROW_2_Right_2 VGND VGND VPWR VPWR sky130_fd_sc_hd__decap_3
X_5058_ _0797_ _0798_ net184 VGND VGND VPWR VPWR _0800_ sky130_fd_sc_hd__o21ai_1
XFILLER_84_287 VGND VGND VPWR VPWR sky130_fd_sc_hd__decap_4
Xclkbuf_leaf_64_clk clknet_3_0__leaf_clk VGND VGND VPWR VPWR clknet_leaf_64_clk sky130_fd_sc_hd__clkbuf_8
XFILLER_111_55 VGND VGND VPWR VPWR sky130_fd_sc_hd__fill_1
X_8817_ _4164_ _4165_ _3668_ VGND VGND VPWR VPWR _4187_ sky130_fd_sc_hd__mux2_1
XTAP_TAPCELL_ROW_84_1266 VGND VPWR sky130_fd_sc_hd__tapvpwrvgnd_1
X_8748_ _4120_ VGND VGND VPWR VPWR _4121_ sky130_fd_sc_hd__inv_2
XFILLER_71_26 VGND VGND VPWR VPWR sky130_fd_sc_hd__fill_2
XFILLER_71_15 VGND VGND VPWR VPWR sky130_fd_sc_hd__decap_3
XTAP_TAPCELL_ROW_51_864 VGND VPWR sky130_fd_sc_hd__tapvpwrvgnd_1
XTAP_TAPCELL_ROW_23_533 VGND VPWR sky130_fd_sc_hd__tapvpwrvgnd_1
X_8679_ net159 _4027_ _4025_ VGND VGND VPWR VPWR _4054_ sky130_fd_sc_hd__a21oi_1
XFILLER_112_3 VPWR VGND VPWR VGND sky130_ef_sc_hd__decap_12
XFILLER_106_153 VGND VGND VPWR VPWR sky130_fd_sc_hd__decap_8
XTAP_TAPCELL_ROW_95_1395 VGND VPWR sky130_fd_sc_hd__tapvpwrvgnd_1
XFILLER_96_34 VGND VGND VPWR VPWR sky130_fd_sc_hd__decap_8
XFILLER_95_519 VGND VGND VPWR VPWR sky130_fd_sc_hd__decap_4
XFILLER_95_508 VGND VGND VPWR VPWR sky130_fd_sc_hd__fill_2
XFILLER_102_381 VGND VGND VPWR VPWR sky130_fd_sc_hd__fill_1
XFILLER_75_221 VGND VGND VPWR VPWR sky130_fd_sc_hd__decap_3
XFILLER_48_424 VGND VGND VPWR VPWR sky130_fd_sc_hd__decap_6
XTAP_TAPCELL_ROW_59_964 VGND VPWR sky130_fd_sc_hd__tapvpwrvgnd_1
XFILLER_36_608 VGND VGND VPWR VPWR sky130_fd_sc_hd__decap_4
XFILLER_75_265 VPWR VGND VPWR VGND sky130_ef_sc_hd__decap_12
XFILLER_29_671 VGND VGND VPWR VPWR sky130_fd_sc_hd__fill_1
XFILLER_63_449 VGND VGND VPWR VPWR sky130_fd_sc_hd__decap_3
XTAP_TAPCELL_ROW_3_291 VGND VPWR sky130_fd_sc_hd__tapvpwrvgnd_1
XFILLER_16_321 VPWR VGND VPWR VGND sky130_ef_sc_hd__decap_12
Xclkbuf_leaf_55_clk clknet_3_1__leaf_clk VGND VGND VPWR VPWR clknet_leaf_55_clk sky130_fd_sc_hd__clkbuf_8
XFILLER_44_630 VGND VGND VPWR VPWR sky130_fd_sc_hd__decap_6
XFILLER_71_460 VPWR VGND VPWR VGND sky130_ef_sc_hd__decap_12
XFILLER_16_365 VPWR VGND VPWR VGND sky130_ef_sc_hd__decap_12
XFILLER_44_652 VGND VGND VPWR VPWR sky130_fd_sc_hd__fill_1
XFILLER_71_493 VGND VGND VPWR VPWR sky130_fd_sc_hd__decap_8
XFILLER_45_93 VGND VGND VPWR VPWR sky130_fd_sc_hd__fill_2
XFILLER_12_560 VGND VGND VPWR VPWR sky130_fd_sc_hd__decap_8
XFILLER_61_92 VGND VGND VPWR VPWR sky130_fd_sc_hd__decap_3
XFILLER_117_429 VGND VGND VPWR VPWR sky130_fd_sc_hd__fill_1
XANTENNA_3 net5 VGND VGND VPWR VPWR sky130_fd_sc_hd__diode_2
XFILLER_8_597 VPWR VGND VPWR VGND sky130_ef_sc_hd__decap_12
XFILLER_6_65 VGND VGND VPWR VPWR sky130_fd_sc_hd__fill_1
X_6030_ _1557_ _1562_ VGND VGND VPWR VPWR _1564_ sky130_fd_sc_hd__xor2_1
XFILLER_100_329 VPWR VGND VPWR VGND sky130_ef_sc_hd__decap_12
XFILLER_79_582 VGND VGND VPWR VPWR sky130_fd_sc_hd__fill_2
XFILLER_66_210 VGND VGND VPWR VPWR sky130_fd_sc_hd__decap_4
XFILLER_27_608 VGND VGND VPWR VPWR sky130_fd_sc_hd__decap_8
X_7981_ _3326_ _3327_ _3328_ VGND VGND VPWR VPWR _3375_ sky130_fd_sc_hd__a21boi_2
Xrebuffer26 net540 VGND VGND VPWR VPWR net541 sky130_fd_sc_hd__dlymetal6s2s_1
Xrebuffer15 _2455_ VGND VGND VPWR VPWR net530 sky130_fd_sc_hd__dlygate4sd1_1
Xrebuffer59 _3928_ VGND VGND VPWR VPWR net574 sky130_fd_sc_hd__dlymetal6s4s_1
Xrebuffer48 net445 VGND VGND VPWR VPWR net563 sky130_fd_sc_hd__buf_8
Xclkbuf_leaf_46_clk clknet_3_2__leaf_clk VGND VGND VPWR VPWR clknet_leaf_46_clk sky130_fd_sc_hd__clkbuf_8
Xrebuffer37 net553 VGND VGND VPWR VPWR net552 sky130_fd_sc_hd__dlygate4sd1_1
X_6932_ _2399_ _2400_ VGND VGND VPWR VPWR _2401_ sky130_fd_sc_hd__nor2_1
XFILLER_81_279 VGND VGND VPWR VPWR sky130_fd_sc_hd__fill_1
X_6863_ _2331_ _2332_ _2330_ VGND VGND VPWR VPWR _2334_ sky130_fd_sc_hd__o21a_1
X_8602_ _3875_ _3911_ _3877_ VGND VGND VPWR VPWR _3979_ sky130_fd_sc_hd__o21bai_1
X_5814_ net490 net480 net352 net350 VGND VGND VPWR VPWR _1353_ sky130_fd_sc_hd__and4_1
X_6794_ _2263_ _2264_ net489 net337 VGND VGND VPWR VPWR _2267_ sky130_fd_sc_hd__a2bb2o_1
X_8533_ _3875_ _3911_ VGND VGND VPWR VPWR _3913_ sky130_fd_sc_hd__xnor2_2
X_5745_ net409 pe_array\[0\].u_pe.accum_reg\[3\] net239 _1286_ VGND VGND VPWR VPWR
+ _1287_ sky130_fd_sc_hd__o2bb2a_1
X_8464_ net160 _3845_ VGND VGND VPWR VPWR _3846_ sky130_fd_sc_hd__xnor2_1
X_5676_ net14 _1230_ _1231_ net322 VGND VGND VPWR VPWR _0215_ sky130_fd_sc_hd__a22o_1
Xrebuffer116 _0854_ VGND VGND VPWR VPWR net631 sky130_fd_sc_hd__dlymetal6s4s_1
X_7415_ _2843_ _2870_ VGND VGND VPWR VPWR _2872_ sky130_fd_sc_hd__xnor2_2
X_4627_ net418 _4389_ VGND VGND VPWR VPWR _0018_ sky130_fd_sc_hd__nor2_1
X_8395_ _3776_ _3777_ net189 VGND VGND VPWR VPWR _3779_ sky130_fd_sc_hd__a21o_1
Xhold520 pe_array\[3\].u_pe.weight_in\[7\] VGND VGND VPWR VPWR net1035 sky130_fd_sc_hd__dlygate4sd3_1
X_7346_ _2801_ _2802_ _2803_ VGND VGND VPWR VPWR _2805_ sky130_fd_sc_hd__a21oi_1
X_4558_ net417 _4322_ VGND VGND VPWR VPWR _0016_ sky130_fd_sc_hd__nor2_1
X_7277_ _2734_ _2735_ _2703_ _2704_ VGND VGND VPWR VPWR _2738_ sky130_fd_sc_hd__a211o_1
X_4489_ _4255_ _4256_ VGND VGND VPWR VPWR _4257_ sky130_fd_sc_hd__nand2_1
X_6228_ _1720_ _1721_ _1755_ _1756_ VGND VGND VPWR VPWR _1757_ sky130_fd_sc_hd__o211a_1
X_9016_ clknet_leaf_42_clk _0128_ VGND VGND VPWR VPWR net86 sky130_fd_sc_hd__dfxtp_1
XFILLER_106_77 VGND VGND VPWR VPWR sky130_fd_sc_hd__decap_6
X_6159_ _1686_ _1687_ net277 VGND VGND VPWR VPWR _1690_ sky130_fd_sc_hd__o21ai_1
XFILLER_66_15 VPWR VGND VPWR VGND sky130_ef_sc_hd__decap_12
XFILLER_85_552 VGND VGND VPWR VPWR sky130_fd_sc_hd__decap_8
XTAP_TAPCELL_ROW_56_923 VGND VPWR sky130_fd_sc_hd__tapvpwrvgnd_1
XFILLER_45_405 VGND VGND VPWR VPWR sky130_fd_sc_hd__decap_3
Xclkbuf_leaf_37_clk clknet_3_3__leaf_clk VGND VGND VPWR VPWR clknet_leaf_37_clk sky130_fd_sc_hd__clkbuf_8
XFILLER_45_449 VGND VGND VPWR VPWR sky130_fd_sc_hd__fill_1
XTAP_TAPCELL_ROW_0_250 VGND VPWR sky130_fd_sc_hd__tapvpwrvgnd_1
XFILLER_13_313 VGND VGND VPWR VPWR sky130_fd_sc_hd__fill_1
XTAP_TAPCELL_ROW_36_680 VGND VPWR sky130_fd_sc_hd__tapvpwrvgnd_1
XFILLER_15_63 VPWR VGND VPWR VGND sky130_ef_sc_hd__decap_12
XTAP_TAPCELL_ROW_36_691 VGND VPWR sky130_fd_sc_hd__tapvpwrvgnd_1
XFILLER_41_666 VGND VGND VPWR VPWR sky130_fd_sc_hd__fill_1
XFILLER_9_317 VGND VGND VPWR VPWR sky130_fd_sc_hd__fill_1
XFILLER_13_379 VPWR VGND VPWR VGND sky130_ef_sc_hd__decap_12
XTAP_TAPCELL_ROW_97_1413 VGND VPWR sky130_fd_sc_hd__tapvpwrvgnd_1
XFILLER_21_390 VGND VGND VPWR VPWR sky130_fd_sc_hd__fill_2
XFILLER_5_534 VGND VGND VPWR VPWR sky130_fd_sc_hd__fill_2
Xoutput51 net51 VGND VGND VPWR VPWR result_data[126] sky130_fd_sc_hd__buf_2
Xoutput40 net40 VGND VGND VPWR VPWR result_data[116] sky130_fd_sc_hd__buf_2
Xoutput73 net73 VGND VGND VPWR VPWR result_data[30] sky130_fd_sc_hd__buf_2
Xoutput62 net62 VGND VGND VPWR VPWR result_data[20] sky130_fd_sc_hd__buf_2
XTAP_TAPCELL_ROW_8_350 VGND VPWR sky130_fd_sc_hd__tapvpwrvgnd_1
Xoutput84 net84 VGND VGND VPWR VPWR result_data[40] sky130_fd_sc_hd__buf_2
Xoutput95 net95 VGND VGND VPWR VPWR result_data[50] sky130_fd_sc_hd__buf_2
XFILLER_0_294 VGND VGND VPWR VPWR sky130_fd_sc_hd__decap_3
XFILLER_36_416 VGND VGND VPWR VPWR sky130_fd_sc_hd__decap_4
XTAP_TAPCELL_ROW_106_1520 VGND VPWR sky130_fd_sc_hd__tapvpwrvgnd_1
Xclkbuf_leaf_28_clk clknet_3_6__leaf_clk VGND VGND VPWR VPWR clknet_leaf_28_clk sky130_fd_sc_hd__clkbuf_8
XTAP_TAPCELL_ROW_106_1531 VGND VPWR sky130_fd_sc_hd__tapvpwrvgnd_1
XFILLER_16_184 VGND VGND VPWR VPWR sky130_fd_sc_hd__decap_3
XFILLER_32_633 VGND VGND VPWR VPWR sky130_fd_sc_hd__fill_1
XFILLER_71_290 VPWR VGND VPWR VGND sky130_ef_sc_hd__decap_12
XFILLER_75_3 VGND VGND VPWR VPWR sky130_fd_sc_hd__decap_3
X_5530_ net1000 net252 _1225_ net368 VGND VGND VPWR VPWR _0075_ sky130_fd_sc_hd__o211a_1
X_5461_ _1187_ _1188_ VGND VGND VPWR VPWR _1189_ sky130_fd_sc_hd__xnor2_1
X_7200_ _2623_ _2662_ VGND VGND VPWR VPWR _2663_ sky130_fd_sc_hd__nor2_1
XTAP_TAPCELL_ROW_117_1671 VGND VPWR sky130_fd_sc_hd__tapvpwrvgnd_1
XTAP_TAPCELL_ROW_117_1660 VGND VPWR sky130_fd_sc_hd__tapvpwrvgnd_1
X_8180_ _3500_ _3503_ _3568_ _3569_ VGND VGND VPWR VPWR _3570_ sky130_fd_sc_hd__a211oi_4
X_5392_ _1096_ _1093_ _1122_ VGND VGND VPWR VPWR _1123_ sky130_fd_sc_hd__a21oi_4
XPHY_EDGE_ROW_99_Right_99 VGND VGND VPWR VPWR sky130_fd_sc_hd__decap_3
X_7131_ _2542_ _2551_ _2549_ VGND VGND VPWR VPWR _2596_ sky130_fd_sc_hd__a21o_1
XFILLER_101_605 VGND VGND VPWR VPWR sky130_fd_sc_hd__decap_8
Xfanout318 net319 VGND VGND VPWR VPWR net318 sky130_fd_sc_hd__buf_2
Xfanout329 pe_array\[1\].u_pe.weight_in\[5\] VGND VGND VPWR VPWR net329 sky130_fd_sc_hd__buf_2
Xfanout307 pe_array\[3\].u_pe.weight_in\[0\] VGND VGND VPWR VPWR net307 sky130_fd_sc_hd__clkbuf_2
X_7062_ _2526_ _2528_ VGND VGND VPWR VPWR _2529_ sky130_fd_sc_hd__xnor2_1
XFILLER_101_627 VGND VGND VPWR VPWR sky130_fd_sc_hd__decap_4
XFILLER_100_104 VGND VGND VPWR VPWR sky130_fd_sc_hd__fill_1
X_6013_ _1545_ _1546_ VGND VGND VPWR VPWR _1548_ sky130_fd_sc_hd__xnor2_1
XFILLER_67_585 VPWR VGND VPWR VGND sky130_ef_sc_hd__decap_12
XFILLER_27_416 VPWR VGND VPWR VGND sky130_ef_sc_hd__decap_12
X_7964_ _3324_ _3358_ VGND VGND VPWR VPWR _3359_ sky130_fd_sc_hd__xnor2_1
XFILLER_82_533 VGND VGND VPWR VPWR sky130_fd_sc_hd__fill_2
XFILLER_27_449 VGND VGND VPWR VPWR sky130_fd_sc_hd__decap_4
XTAP_TAPCELL_ROW_68_1069 VGND VPWR sky130_fd_sc_hd__tapvpwrvgnd_1
X_6915_ _2345_ _2284_ _2344_ VGND VGND VPWR VPWR _2385_ sky130_fd_sc_hd__a21oi_4
XFILLER_42_419 VGND VGND VPWR VPWR sky130_fd_sc_hd__fill_1
X_7895_ net496 net318 pe_array\[2\].u_pe.accum_reg\[5\] VGND VGND VPWR VPWR _3291_
+ sky130_fd_sc_hd__a21oi_1
XTAP_TAPCELL_ROW_81_1225 VGND VPWR sky130_fd_sc_hd__tapvpwrvgnd_1
XFILLER_23_633 VGND VGND VPWR VPWR sky130_fd_sc_hd__fill_2
X_6846_ net587 net331 _2290_ _2288_ VGND VGND VPWR VPWR _2317_ sky130_fd_sc_hd__a31o_1
XTAP_TAPCELL_ROW_61_981 VGND VPWR sky130_fd_sc_hd__tapvpwrvgnd_1
X_6777_ _2229_ _2231_ _2249_ VGND VGND VPWR VPWR _2251_ sky130_fd_sc_hd__nand3_1
XFILLER_22_176 VGND VGND VPWR VPWR sky130_fd_sc_hd__decap_4
XTAP_TAPCELL_ROW_33_650 VGND VPWR sky130_fd_sc_hd__tapvpwrvgnd_1
X_8516_ _3893_ _3892_ _3855_ _3857_ VGND VGND VPWR VPWR _3896_ sky130_fd_sc_hd__a211o_1
X_5728_ _1268_ _1269_ net498 net354 VGND VGND VPWR VPWR _1270_ sky130_fd_sc_hd__and4bb_1
XFILLER_108_204 VGND VGND VPWR VPWR sky130_fd_sc_hd__fill_2
XFILLER_6_309 VGND VGND VPWR VPWR sky130_fd_sc_hd__fill_2
X_8447_ net263 _3827_ _3828_ VGND VGND VPWR VPWR _3829_ sky130_fd_sc_hd__nor3_1
X_5659_ net947 net364 VGND VGND VPWR VPWR _0200_ sky130_fd_sc_hd__and2_1
XTAP_TAPCELL_ROW_79_1198 VGND VPWR sky130_fd_sc_hd__tapvpwrvgnd_1
X_8378_ _3695_ _3728_ _3761_ _3762_ _3727_ VGND VGND VPWR VPWR _3763_ sky130_fd_sc_hd__o311ai_4
XFILLER_2_515 VGND VGND VPWR VPWR sky130_fd_sc_hd__decap_6
XFILLER_104_421 VGND VGND VPWR VPWR sky130_fd_sc_hd__decap_4
XTAP_TAPCELL_ROW_92_1354 VGND VPWR sky130_fd_sc_hd__tapvpwrvgnd_1
X_7329_ _2786_ _2787_ VGND VGND VPWR VPWR _2789_ sky130_fd_sc_hd__xnor2_1
Xhold394 pe_accum\[0\]\[19\] VGND VGND VPWR VPWR net909 sky130_fd_sc_hd__dlygate4sd3_1
Xhold383 pe_accum\[0\]\[2\] VGND VGND VPWR VPWR net898 sky130_fd_sc_hd__dlygate4sd3_1
XFILLER_77_327 VGND VGND VPWR VPWR sky130_fd_sc_hd__decap_8
XFILLER_77_349 VPWR VGND VPWR VGND sky130_ef_sc_hd__decap_12
XFILLER_58_552 VGND VGND VPWR VPWR sky130_fd_sc_hd__fill_2
XFILLER_58_541 VGND VGND VPWR VPWR sky130_fd_sc_hd__decap_3
XFILLER_93_13 VGND VGND VPWR VPWR sky130_fd_sc_hd__fill_1
XFILLER_85_371 VPWR VGND VPWR VGND sky130_ef_sc_hd__decap_12
XFILLER_93_46 VGND VGND VPWR VPWR sky130_fd_sc_hd__fill_1
XFILLER_85_393 VGND VGND VPWR VPWR sky130_fd_sc_hd__fill_2
XFILLER_33_419 VGND VGND VPWR VPWR sky130_fd_sc_hd__decap_6
XFILLER_45_268 VGND VGND VPWR VPWR sky130_fd_sc_hd__fill_2
XFILLER_73_599 VGND VGND VPWR VPWR sky130_fd_sc_hd__decap_4
XFILLER_60_205 VGND VGND VPWR VPWR sky130_fd_sc_hd__fill_1
XFILLER_26_62 VPWR VGND VPWR VGND sky130_ef_sc_hd__decap_12
XFILLER_13_121 VPWR VGND VPWR VGND sky130_ef_sc_hd__decap_12
XFILLER_41_430 VGND VGND VPWR VPWR sky130_fd_sc_hd__decap_3
XTAP_TAPCELL_ROW_101_1461 VGND VPWR sky130_fd_sc_hd__tapvpwrvgnd_1
XFILLER_9_147 VGND VGND VPWR VPWR sky130_fd_sc_hd__fill_1
XFILLER_42_83 VGND VGND VPWR VPWR sky130_fd_sc_hd__fill_1
XTAP_TAPCELL_ROW_11_388 VGND VPWR sky130_fd_sc_hd__tapvpwrvgnd_1
Xrebuffer6 _4373_ VGND VGND VPWR VPWR net521 sky130_fd_sc_hd__clkbuf_2
XFILLER_107_281 VPWR VGND VPWR VGND sky130_ef_sc_hd__decap_12
XFILLER_47_7 VPWR VGND VPWR VGND sky130_ef_sc_hd__decap_12
XFILLER_110_413 VGND VGND VPWR VPWR sky130_fd_sc_hd__decap_6
XFILLER_95_113 VGND VGND VPWR VPWR sky130_fd_sc_hd__decap_8
XFILLER_68_338 VGND VGND VPWR VPWR sky130_fd_sc_hd__decap_8
XFILLER_68_305 VGND VGND VPWR VPWR sky130_fd_sc_hd__decap_3
XFILLER_3_55 VGND VGND VPWR VPWR sky130_fd_sc_hd__fill_1
XFILLER_110_435 VGND VGND VPWR VPWR sky130_fd_sc_hd__decap_3
XFILLER_96_669 VPWR VGND VPWR VGND sky130_ef_sc_hd__decap_12
XFILLER_95_146 VPWR VGND VPWR VGND sky130_ef_sc_hd__decap_12
XFILLER_91_330 VGND VGND VPWR VPWR sky130_fd_sc_hd__decap_6
XFILLER_76_382 VGND VGND VPWR VPWR sky130_fd_sc_hd__decap_8
XFILLER_64_533 VPWR VGND VPWR VGND sky130_ef_sc_hd__decap_12
XTAP_TAPCELL_ROW_19_477 VGND VPWR sky130_fd_sc_hd__tapvpwrvgnd_1
X_4961_ _0702_ _0703_ _0704_ VGND VGND VPWR VPWR _0706_ sky130_fd_sc_hd__a21oi_1
X_6700_ net894 net236 _1637_ net244 VGND VGND VPWR VPWR _0270_ sky130_fd_sc_hd__o2bb2ai_1
XFILLER_51_249 VPWR VGND VPWR VGND sky130_ef_sc_hd__decap_12
XFILLER_17_493 VGND VGND VPWR VPWR sky130_fd_sc_hd__decap_8
X_4892_ _0549_ net153 _0638_ VGND VGND VPWR VPWR _0639_ sky130_fd_sc_hd__a21boi_4
XFILLER_44_290 VGND VGND VPWR VPWR sky130_fd_sc_hd__fill_1
X_7680_ _3125_ _3126_ VGND VGND VPWR VPWR _3128_ sky130_fd_sc_hd__and2b_1
X_6631_ _2145_ _2146_ VGND VGND VPWR VPWR _2147_ sky130_fd_sc_hd__nor2_1
X_6562_ _2079_ _2078_ VGND VGND VPWR VPWR _2080_ sky130_fd_sc_hd__and2b_1
X_8301_ _3684_ _3685_ _3686_ VGND VGND VPWR VPWR _3688_ sky130_fd_sc_hd__a21oi_1
X_6493_ pe_array\[0\].u_pe.accum_reg\[25\] _1393_ VGND VGND VPWR VPWR _2013_ sky130_fd_sc_hd__nor2_1
X_9281_ clknet_leaf_5_clk _0393_ VGND VGND VPWR VPWR pe_array\[2\].u_pe.accum_reg\[23\]
+ sky130_fd_sc_hd__dfxtp_1
X_5513_ net246 _0978_ VGND VGND VPWR VPWR _1217_ sky130_fd_sc_hd__nand2_1
Xclkbuf_leaf_8_clk clknet_3_5__leaf_clk VGND VGND VPWR VPWR clknet_leaf_8_clk sky130_fd_sc_hd__clkbuf_8
X_8232_ _3490_ _3619_ _3620_ VGND VGND VPWR VPWR _3621_ sky130_fd_sc_hd__a21o_1
X_5444_ _1171_ _1172_ VGND VGND VPWR VPWR _1173_ sky130_fd_sc_hd__nor2_1
X_8163_ pe_array\[2\].u_pe.accum_reg\[11\] net440 net314 VGND VGND VPWR VPWR _3553_
+ sky130_fd_sc_hd__and3_4
X_5375_ net743 _1104_ VGND VGND VPWR VPWR _1106_ sky130_fd_sc_hd__nor2_1
X_7114_ _2577_ _2578_ VGND VGND VPWR VPWR _2579_ sky130_fd_sc_hd__nor2_1
XFILLER_101_402 VPWR VGND VPWR VGND sky130_ef_sc_hd__decap_12
X_8094_ _3450_ _3484_ VGND VGND VPWR VPWR _3486_ sky130_fd_sc_hd__xor2_1
Xfanout159 _3699_ VGND VGND VPWR VPWR net159 sky130_fd_sc_hd__clkbuf_4
XFILLER_87_669 VGND VGND VPWR VPWR sky130_fd_sc_hd__decap_3
X_7045_ _2466_ _2459_ _2465_ VGND VGND VPWR VPWR _2512_ sky130_fd_sc_hd__a21bo_1
XFILLER_67_371 VPWR VGND VPWR VGND sky130_ef_sc_hd__decap_12
X_8996_ clknet_leaf_26_clk _0108_ VGND VGND VPWR VPWR net64 sky130_fd_sc_hd__dfxtp_1
XFILLER_82_352 VGND VGND VPWR VPWR sky130_fd_sc_hd__decap_3
X_7947_ _3339_ _3340_ _3325_ VGND VGND VPWR VPWR _3342_ sky130_fd_sc_hd__a21o_1
XFILLER_63_27 VPWR VGND VPWR VGND sky130_ef_sc_hd__decap_12
XFILLER_55_588 VPWR VGND VPWR VGND sky130_ef_sc_hd__decap_12
X_7878_ net485 net323 net325 net478 VGND VGND VPWR VPWR _3275_ sky130_fd_sc_hd__a22oi_1
X_6829_ _2262_ _2269_ _2268_ VGND VGND VPWR VPWR _2301_ sky130_fd_sc_hd__a21bo_1
XFILLER_11_658 VGND VGND VPWR VPWR sky130_fd_sc_hd__decap_4
XFILLER_10_113 VGND VGND VPWR VPWR sky130_fd_sc_hd__decap_4
XFILLER_50_293 VGND VGND VPWR VPWR sky130_fd_sc_hd__fill_1
XFILLER_10_135 VGND VGND VPWR VPWR sky130_fd_sc_hd__decap_4
XFILLER_7_629 VPWR VGND VPWR VGND sky130_ef_sc_hd__decap_12
XFILLER_109_535 VGND VGND VPWR VPWR sky130_fd_sc_hd__decap_4
XFILLER_12_53 VGND VGND VPWR VPWR sky130_fd_sc_hd__decap_6
XFILLER_12_97 VGND VGND VPWR VPWR sky130_fd_sc_hd__fill_2
XFILLER_2_301 VGND VGND VPWR VPWR sky130_fd_sc_hd__fill_1
XFILLER_5_3 VPWR VGND VPWR VGND sky130_ef_sc_hd__decap_12
XFILLER_77_113 VGND VGND VPWR VPWR sky130_fd_sc_hd__fill_1
XFILLER_78_669 VPWR VGND VPWR VGND sky130_ef_sc_hd__decap_12
XFILLER_77_179 VGND VGND VPWR VPWR sky130_fd_sc_hd__decap_8
XFILLER_73_385 VGND VGND VPWR VPWR sky130_fd_sc_hd__decap_6
XFILLER_61_536 VGND VGND VPWR VPWR sky130_fd_sc_hd__fill_1
XFILLER_18_279 VGND VGND VPWR VPWR sky130_fd_sc_hd__decap_6
XTAP_TAPCELL_ROW_16_447 VGND VPWR sky130_fd_sc_hd__tapvpwrvgnd_1
XTAP_TAPCELL_ROW_44_778 VGND VPWR sky130_fd_sc_hd__tapvpwrvgnd_1
XFILLER_53_93 VPWR VGND VPWR VGND sky130_ef_sc_hd__decap_12
X_5160_ _0898_ _0894_ VGND VGND VPWR VPWR _0899_ sky130_fd_sc_hd__xnor2_4
XFILLER_38_3 VPWR VGND VPWR VGND sky130_ef_sc_hd__decap_12
X_5091_ _0828_ _0829_ _0830_ VGND VGND VPWR VPWR _0832_ sky130_fd_sc_hd__a21o_1
XFILLER_110_265 VPWR VGND VPWR VGND sky130_ef_sc_hd__decap_12
XFILLER_96_477 VGND VGND VPWR VPWR sky130_fd_sc_hd__decap_8
XFILLER_83_127 VGND VGND VPWR VPWR sky130_fd_sc_hd__fill_1
XFILLER_92_661 VGND VGND VPWR VPWR sky130_fd_sc_hd__decap_8
XFILLER_83_149 VPWR VGND VPWR VGND sky130_ef_sc_hd__decap_12
X_8850_ net209 _3660_ VGND VGND VPWR VPWR _4206_ sky130_fd_sc_hd__nand2_1
X_8781_ _4150_ _4151_ _4122_ _4119_ VGND VGND VPWR VPWR _4153_ sky130_fd_sc_hd__a211o_1
X_5993_ net275 _1526_ _1527_ VGND VGND VPWR VPWR _1528_ sky130_fd_sc_hd__nor3_1
XTAP_TAPCELL_ROW_65_1028 VGND VPWR sky130_fd_sc_hd__tapvpwrvgnd_1
XFILLER_64_363 VGND VGND VPWR VPWR sky130_fd_sc_hd__fill_1
X_7801_ net19 _3206_ _3207_ net290 VGND VGND VPWR VPWR _0364_ sky130_fd_sc_hd__a22o_1
XFILLER_52_503 VPWR VGND VPWR VGND sky130_ef_sc_hd__decap_12
XTAP_TAPCELL_ROW_65_1039 VGND VPWR sky130_fd_sc_hd__tapvpwrvgnd_1
X_7732_ net903 net227 _3175_ net390 VGND VGND VPWR VPWR _0327_ sky130_fd_sc_hd__o211a_1
X_4944_ net298 net435 pe_array\[3\].u_pe.accum_reg\[14\] VGND VGND VPWR VPWR _0689_
+ sky130_fd_sc_hd__a21oi_1
XFILLER_33_19 VPWR VGND VPWR VGND sky130_ef_sc_hd__decap_12
XFILLER_32_260 VGND VGND VPWR VPWR sky130_fd_sc_hd__decap_4
XFILLER_32_282 VGND VGND VPWR VPWR sky130_fd_sc_hd__decap_6
X_4875_ _0619_ _0618_ _0620_ VGND VGND VPWR VPWR _0622_ sky130_fd_sc_hd__a21o_1
X_7663_ _3076_ _3078_ VGND VGND VPWR VPWR _3111_ sky130_fd_sc_hd__or2_1
X_6614_ pe_array\[0\].u_pe.accum_reg\[29\] net612 net357 VGND VGND VPWR VPWR _2130_
+ sky130_fd_sc_hd__and3_1
X_7594_ pe_array\[1\].u_pe.accum_reg\[27\] _2367_ VGND VGND VPWR VPWR _3044_ sky130_fd_sc_hd__nor2_1
X_6545_ net428 _2063_ VGND VGND VPWR VPWR _0252_ sky130_fd_sc_hd__nor2_1
XFILLER_20_477 VPWR VGND VPWR VGND sky130_ef_sc_hd__decap_12
X_9264_ clknet_leaf_2_clk _0376_ VGND VGND VPWR VPWR pe_array\[2\].u_pe.accum_reg\[6\]
+ sky130_fd_sc_hd__dfxtp_1
XFILLER_106_527 VGND VGND VPWR VPWR sky130_fd_sc_hd__decap_4
X_6476_ _1994_ _1995_ VGND VGND VPWR VPWR _1997_ sky130_fd_sc_hd__xnor2_1
X_8215_ _3601_ _3600_ _3602_ VGND VGND VPWR VPWR _3604_ sky130_fd_sc_hd__a21o_1
XTAP_TAPCELL_ROW_76_1168 VGND VPWR sky130_fd_sc_hd__tapvpwrvgnd_1
X_5427_ net417 _1156_ VGND VGND VPWR VPWR _0041_ sky130_fd_sc_hd__nor2_1
X_9195_ clknet_3_2__leaf_clk _0307_ VGND VGND VPWR VPWR pe_array\[1\].u_pe.accum_reg\[13\]
+ sky130_fd_sc_hd__dfxtp_1
X_8146_ net401 pe_array\[2\].u_pe.accum_reg\[10\] net217 _3536_ VGND VGND VPWR VPWR
+ _3537_ sky130_fd_sc_hd__o2bb2a_1
XFILLER_58_27 VGND VGND VPWR VPWR sky130_fd_sc_hd__fill_1
X_5358_ net399 pe_array\[3\].u_pe.accum_reg\[27\] net258 _1089_ VGND VGND VPWR VPWR
+ _1090_ sky130_fd_sc_hd__o2bb2a_4
X_8077_ net680 _3466_ _3467_ VGND VGND VPWR VPWR _3469_ sky130_fd_sc_hd__or3_4
XFILLER_59_113 VPWR VGND VPWR VGND sky130_ef_sc_hd__decap_12
XFILLER_87_466 VGND VGND VPWR VPWR sky130_fd_sc_hd__fill_2
X_5289_ _1020_ _1021_ VGND VGND VPWR VPWR _1023_ sky130_fd_sc_hd__xor2_1
X_7028_ _2488_ _2493_ VGND VGND VPWR VPWR _2495_ sky130_fd_sc_hd__xnor2_1
XFILLER_114_77 VGND VGND VPWR VPWR sky130_fd_sc_hd__decap_6
X_8979_ clknet_leaf_22_clk _0091_ VGND VGND VPWR VPWR net105 sky130_fd_sc_hd__dfxtp_1
XTAP_TAPCELL_ROW_87_1297 VGND VPWR sky130_fd_sc_hd__tapvpwrvgnd_1
XFILLER_70_377 VPWR VGND VPWR VGND sky130_ef_sc_hd__decap_12
XTAP_TAPCELL_ROW_13_406 VGND VPWR sky130_fd_sc_hd__tapvpwrvgnd_1
XTAP_TAPCELL_ROW_41_748 VGND VPWR sky130_fd_sc_hd__tapvpwrvgnd_1
XFILLER_11_455 VGND VGND VPWR VPWR sky130_fd_sc_hd__fill_1
XFILLER_23_41 VGND VGND VPWR VPWR sky130_fd_sc_hd__fill_1
XFILLER_11_488 VGND VGND VPWR VPWR sky130_fd_sc_hd__decap_3
XFILLER_3_665 VGND VGND VPWR VPWR sky130_fd_sc_hd__decap_6
XFILLER_2_197 VGND VGND VPWR VPWR sky130_fd_sc_hd__fill_1
Xfanout490 net491 VGND VGND VPWR VPWR net490 sky130_fd_sc_hd__buf_2
XFILLER_48_93 VGND VGND VPWR VPWR sky130_fd_sc_hd__fill_1
XTAP_TAPCELL_ROW_49_837 VGND VPWR sky130_fd_sc_hd__tapvpwrvgnd_1
XFILLER_74_661 VPWR VGND VPWR VGND sky130_ef_sc_hd__decap_12
XFILLER_46_363 VGND VGND VPWR VPWR sky130_fd_sc_hd__fill_1
XFILLER_61_322 VGND VGND VPWR VPWR sky130_fd_sc_hd__decap_6
XPHY_EDGE_ROW_14_Left_132 VGND VGND VPWR VPWR sky130_fd_sc_hd__decap_3
XFILLER_64_92 VGND VGND VPWR VPWR sky130_fd_sc_hd__fill_2
X_4660_ _4360_ _4420_ _4421_ VGND VGND VPWR VPWR _4422_ sky130_fd_sc_hd__and3_1
X_6330_ _1853_ _1854_ net174 VGND VGND VPWR VPWR _1856_ sky130_fd_sc_hd__o21ai_1
X_4591_ net501 net294 _4330_ _4328_ VGND VGND VPWR VPWR _4354_ sky130_fd_sc_hd__a31o_1
XFILLER_115_324 VGND VGND VPWR VPWR sky130_fd_sc_hd__decap_3
XFILLER_115_302 VGND VGND VPWR VPWR sky130_fd_sc_hd__decap_6
XFILLER_115_335 VGND VGND VPWR VPWR sky130_fd_sc_hd__fill_1
X_6261_ net199 _1786_ _1788_ VGND VGND VPWR VPWR _1789_ sky130_fd_sc_hd__or3b_1
XPHY_EDGE_ROW_23_Left_141 VGND VGND VPWR VPWR sky130_fd_sc_hd__decap_3
XFILLER_88_208 VGND VGND VPWR VPWR sky130_fd_sc_hd__decap_8
X_6192_ _1720_ _1719_ net277 VGND VGND VPWR VPWR _1722_ sky130_fd_sc_hd__or3_4
X_8000_ _3348_ _3393_ VGND VGND VPWR VPWR _3394_ sky130_fd_sc_hd__nand2_1
X_5212_ _0890_ _0920_ _0948_ VGND VGND VPWR VPWR _0949_ sky130_fd_sc_hd__o21ai_1
XFILLER_111_530 VGND VGND VPWR VPWR sky130_fd_sc_hd__decap_8
X_5143_ _0880_ _0881_ VGND VGND VPWR VPWR _0882_ sky130_fd_sc_hd__nor2_1
XFILLER_111_552 VGND VGND VPWR VPWR sky130_fd_sc_hd__decap_8
XFILLER_111_585 VGND VGND VPWR VPWR sky130_fd_sc_hd__decap_6
XFILLER_96_274 VGND VGND VPWR VPWR sky130_fd_sc_hd__decap_8
X_5074_ pe_array\[3\].u_pe.accum_reg\[18\] net295 net433 VGND VGND VPWR VPWR _0815_
+ sky130_fd_sc_hd__and3_4
X_8902_ clknet_leaf_53_clk _0014_ VGND VGND VPWR VPWR pe_array\[3\].u_pe.accum_reg\[2\]
+ sky130_fd_sc_hd__dfxtp_1
X_8833_ net997 net215 _4197_ net387 VGND VGND VPWR VPWR _0406_ sky130_fd_sc_hd__o211a_1
XFILLER_80_620 VPWR VGND VPWR VGND sky130_ef_sc_hd__decap_12
XFILLER_25_503 VGND VGND VPWR VPWR sky130_fd_sc_hd__fill_1
XPHY_EDGE_ROW_32_Left_150 VGND VGND VPWR VPWR sky130_fd_sc_hd__decap_3
XFILLER_44_29 VPWR VGND VPWR VGND sky130_ef_sc_hd__decap_12
X_8764_ _4134_ _4135_ VGND VGND VPWR VPWR _4136_ sky130_fd_sc_hd__and2_1
XFILLER_80_686 VPWR VGND VPWR VGND sky130_ef_sc_hd__decap_12
X_5976_ net466 _1477_ _1479_ _1480_ VGND VGND VPWR VPWR _1511_ sky130_fd_sc_hd__o2bb2a_1
XFILLER_100_46 VGND VGND VPWR VPWR sky130_fd_sc_hd__fill_1
XFILLER_100_35 VGND VGND VPWR VPWR sky130_fd_sc_hd__fill_1
X_8695_ net264 _4067_ _4068_ VGND VGND VPWR VPWR _4069_ sky130_fd_sc_hd__nor3_1
X_7715_ net170 _3149_ _3147_ VGND VGND VPWR VPWR _3161_ sky130_fd_sc_hd__a21o_1
X_4927_ _0670_ _0671_ _0627_ _0629_ VGND VGND VPWR VPWR _0673_ sky130_fd_sc_hd__o211a_1
X_7646_ net170 _3060_ _3059_ VGND VGND VPWR VPWR _3095_ sky130_fd_sc_hd__a21oi_1
X_4858_ _0603_ _0604_ VGND VGND VPWR VPWR _0605_ sky130_fd_sc_hd__xnor2_1
X_9316_ clknet_leaf_10_clk _0428_ VGND VGND VPWR VPWR pe_accum\[2\]\[26\] sky130_fd_sc_hd__dfxtp_1
X_7577_ _3025_ _3026_ VGND VGND VPWR VPWR _3028_ sky130_fd_sc_hd__xnor2_1
X_4789_ _0492_ _0494_ _0534_ _0536_ VGND VGND VPWR VPWR _0538_ sky130_fd_sc_hd__a211o_1
XFILLER_109_55 VGND VGND VPWR VPWR sky130_fd_sc_hd__fill_1
X_6528_ net202 _2046_ VGND VGND VPWR VPWR _2047_ sky130_fd_sc_hd__xnor2_1
X_6459_ _1944_ _1947_ _1974_ VGND VGND VPWR VPWR _1980_ sky130_fd_sc_hd__and3_1
XFILLER_69_48 VGND VGND VPWR VPWR sky130_fd_sc_hd__fill_1
X_9247_ clknet_leaf_0_clk _0359_ VGND VGND VPWR VPWR pe_array\[3\].u_pe.weight_in\[1\]
+ sky130_fd_sc_hd__dfxtp_1
XFILLER_106_379 VGND VGND VPWR VPWR sky130_fd_sc_hd__decap_8
X_9178_ clknet_leaf_39_clk _0290_ VGND VGND VPWR VPWR pe_array\[1\].u_pe.tap_count\[0\]
+ sky130_fd_sc_hd__dfxtp_1
XFILLER_0_613 VGND VGND VPWR VPWR sky130_fd_sc_hd__decap_3
X_8129_ _3517_ _3518_ _3505_ VGND VGND VPWR VPWR _3520_ sky130_fd_sc_hd__a21o_1
XFILLER_0_657 VPWR VGND VPWR VGND sky130_ef_sc_hd__decap_12
XTAP_TAPCELL_ROW_89_1326 VGND VPWR sky130_fd_sc_hd__tapvpwrvgnd_1
XFILLER_87_296 VGND VGND VPWR VPWR sky130_fd_sc_hd__decap_4
XFILLER_87_285 VGND VGND VPWR VPWR sky130_fd_sc_hd__fill_1
XFILLER_28_341 VGND VGND VPWR VPWR sky130_fd_sc_hd__fill_2
XFILLER_47_149 VPWR VGND VPWR VGND sky130_ef_sc_hd__decap_12
XTAP_TAPCELL_ROW_46_807 VGND VPWR sky130_fd_sc_hd__tapvpwrvgnd_1
XFILLER_55_160 VGND VGND VPWR VPWR sky130_fd_sc_hd__decap_8
XFILLER_16_503 VGND VGND VPWR VPWR sky130_fd_sc_hd__fill_1
XFILLER_16_514 VGND VGND VPWR VPWR sky130_fd_sc_hd__fill_1
XFILLER_18_85 VPWR VGND VPWR VGND sky130_ef_sc_hd__decap_12
XFILLER_28_363 VGND VGND VPWR VPWR sky130_fd_sc_hd__fill_1
XFILLER_43_322 VGND VGND VPWR VPWR sky130_fd_sc_hd__fill_1
XFILLER_43_333 VGND VGND VPWR VPWR sky130_fd_sc_hd__decap_3
XFILLER_70_141 VGND VGND VPWR VPWR sky130_fd_sc_hd__decap_3
XTAP_TAPCELL_ROW_26_564 VGND VPWR sky130_fd_sc_hd__tapvpwrvgnd_1
XFILLER_43_366 VPWR VGND VPWR VGND sky130_ef_sc_hd__decap_12
XFILLER_7_256 VGND VGND VPWR VPWR sky130_fd_sc_hd__fill_1
XFILLER_50_83 VGND VGND VPWR VPWR sky130_fd_sc_hd__fill_1
XFILLER_98_506 VPWR VGND VPWR VGND sky130_ef_sc_hd__decap_12
XFILLER_3_473 VGND VGND VPWR VPWR sky130_fd_sc_hd__decap_8
XFILLER_59_81 VGND VGND VPWR VPWR sky130_fd_sc_hd__decap_8
XTAP_TAPCELL_ROW_109_1562 VGND VPWR sky130_fd_sc_hd__tapvpwrvgnd_1
XFILLER_75_80 VGND VGND VPWR VPWR sky130_fd_sc_hd__fill_2
XFILLER_74_491 VGND VGND VPWR VPWR sky130_fd_sc_hd__decap_3
XFILLER_19_385 VGND VGND VPWR VPWR sky130_fd_sc_hd__decap_6
XFILLER_46_171 VGND VGND VPWR VPWR sky130_fd_sc_hd__decap_3
XFILLER_46_193 VGND VGND VPWR VPWR sky130_fd_sc_hd__decap_3
X_5830_ _1350_ _1367_ _1368_ VGND VGND VPWR VPWR _1369_ sky130_fd_sc_hd__nand3_1
XFILLER_62_675 VGND VGND VPWR VPWR sky130_fd_sc_hd__fill_2
XFILLER_62_653 VGND VGND VPWR VPWR sky130_fd_sc_hd__fill_2
X_5761_ _1274_ _1278_ _1273_ VGND VGND VPWR VPWR _1302_ sky130_fd_sc_hd__a21o_1
X_8480_ _3828_ _3829_ _3858_ _3859_ VGND VGND VPWR VPWR _3861_ sky130_fd_sc_hd__o211ai_1
X_7500_ _2923_ _2953_ VGND VGND VPWR VPWR _2954_ sky130_fd_sc_hd__nand2_1
X_4712_ _4390_ _4425_ _4424_ VGND VGND VPWR VPWR _0463_ sky130_fd_sc_hd__a21o_1
X_5692_ _1237_ _1238_ VGND VGND VPWR VPWR _0224_ sky130_fd_sc_hd__nor2_1
X_7431_ _2885_ _2886_ VGND VGND VPWR VPWR _2887_ sky130_fd_sc_hd__nand2_1
XFILLER_30_561 VGND VGND VPWR VPWR sky130_fd_sc_hd__fill_1
X_4643_ net300 net477 pe_array\[3\].u_pe.weight_in\[7\] VGND VGND VPWR VPWR _4405_
+ sky130_fd_sc_hd__and3_1
X_7362_ _2817_ _2820_ VGND VGND VPWR VPWR _2821_ sky130_fd_sc_hd__xnor2_1
X_4574_ _4335_ _4336_ net584 _4305_ VGND VGND VPWR VPWR _4338_ sky130_fd_sc_hd__a211o_1
X_6313_ _1751_ _1838_ _1839_ VGND VGND VPWR VPWR _1840_ sky130_fd_sc_hd__a21oi_4
X_9101_ clknet_leaf_59_clk _0213_ VGND VGND VPWR VPWR net52 sky130_fd_sc_hd__dfxtp_1
X_7293_ _2749_ _2750_ _2751_ VGND VGND VPWR VPWR _2754_ sky130_fd_sc_hd__a21oi_1
XFILLER_116_699 VGND VGND VPWR VPWR sky130_fd_sc_hd__fill_1
XFILLER_115_143 VGND VGND VPWR VPWR sky130_fd_sc_hd__fill_2
XFILLER_89_539 VGND VGND VPWR VPWR sky130_fd_sc_hd__fill_1
X_6244_ _1770_ _1771_ _1772_ VGND VGND VPWR VPWR _1773_ sky130_fd_sc_hd__and3_4
XTAP_TAPCELL_ROW_73_1127 VGND VPWR sky130_fd_sc_hd__tapvpwrvgnd_1
X_9032_ clknet_leaf_41_clk _0144_ VGND VGND VPWR VPWR net103 sky130_fd_sc_hd__dfxtp_1
XFILLER_103_349 VGND VGND VPWR VPWR sky130_fd_sc_hd__fill_2
XFILLER_97_561 VPWR VGND VPWR VGND sky130_ef_sc_hd__decap_12
X_6175_ _1664_ _1666_ _1704_ _1705_ VGND VGND VPWR VPWR _1706_ sky130_fd_sc_hd__o211a_1
XFILLER_69_285 VGND VGND VPWR VPWR sky130_fd_sc_hd__fill_1
XFILLER_69_274 VGND VGND VPWR VPWR sky130_fd_sc_hd__decap_6
X_5126_ _0863_ _0864_ VGND VGND VPWR VPWR _0866_ sky130_fd_sc_hd__xor2_1
XFILLER_29_105 VGND VGND VPWR VPWR sky130_fd_sc_hd__decap_6
XFILLER_57_447 VGND VGND VPWR VPWR sky130_fd_sc_hd__fill_1
X_5057_ net184 _0797_ _0798_ VGND VGND VPWR VPWR _0799_ sky130_fd_sc_hd__or3_1
XFILLER_84_266 VGND VGND VPWR VPWR sky130_fd_sc_hd__fill_1
XFILLER_38_661 VGND VGND VPWR VPWR sky130_fd_sc_hd__fill_1
X_8816_ net155 _4185_ VGND VGND VPWR VPWR _4186_ sky130_fd_sc_hd__xnor2_1
XTAP_TAPCELL_ROW_84_1267 VGND VPWR sky130_fd_sc_hd__tapvpwrvgnd_1
XTAP_TAPCELL_ROW_84_1256 VGND VPWR sky130_fd_sc_hd__tapvpwrvgnd_1
X_8747_ _4083_ _4118_ VGND VGND VPWR VPWR _4120_ sky130_fd_sc_hd__xor2_1
X_5959_ _1476_ _1492_ net658 VGND VGND VPWR VPWR _1495_ sky130_fd_sc_hd__nand3_1
XFILLER_53_697 VGND VGND VPWR VPWR sky130_fd_sc_hd__decap_3
XTAP_TAPCELL_ROW_51_865 VGND VPWR sky130_fd_sc_hd__tapvpwrvgnd_1
XTAP_TAPCELL_ROW_23_534 VGND VPWR sky130_fd_sc_hd__tapvpwrvgnd_1
X_8678_ net155 _4052_ VGND VGND VPWR VPWR _4053_ sky130_fd_sc_hd__xnor2_1
XFILLER_21_550 VGND VGND VPWR VPWR sky130_fd_sc_hd__fill_1
XFILLER_21_572 VPWR VGND VPWR VGND sky130_ef_sc_hd__decap_12
X_7629_ net272 _3076_ _3077_ VGND VGND VPWR VPWR _3078_ sky130_fd_sc_hd__nor3_1
XFILLER_107_644 VPWR VGND VPWR VGND sky130_ef_sc_hd__decap_12
XFILLER_105_3 VPWR VGND VPWR VGND sky130_ef_sc_hd__decap_12
XTAP_TAPCELL_ROW_95_1396 VGND VPWR sky130_fd_sc_hd__tapvpwrvgnd_1
XFILLER_96_24 VGND VGND VPWR VPWR sky130_fd_sc_hd__decap_4
XFILLER_0_421 VPWR VGND VPWR VGND sky130_ef_sc_hd__decap_12
XFILLER_75_233 VGND VGND VPWR VPWR sky130_fd_sc_hd__fill_2
XTAP_TAPCELL_ROW_59_965 VGND VPWR sky130_fd_sc_hd__tapvpwrvgnd_1
XFILLER_75_277 VGND VGND VPWR VPWR sky130_fd_sc_hd__decap_3
XTAP_TAPCELL_ROW_3_292 VGND VPWR sky130_fd_sc_hd__tapvpwrvgnd_1
XFILLER_16_333 VPWR VGND VPWR VGND sky130_ef_sc_hd__decap_12
XFILLER_71_472 VGND VGND VPWR VPWR sky130_fd_sc_hd__decap_4
XFILLER_16_377 VPWR VGND VPWR VGND sky130_ef_sc_hd__decap_12
XFILLER_8_587 VGND VGND VPWR VPWR sky130_fd_sc_hd__fill_1
XANTENNA_4 net9 VGND VGND VPWR VPWR sky130_fd_sc_hd__diode_2
XFILLER_98_369 VGND VGND VPWR VPWR sky130_fd_sc_hd__fill_1
XFILLER_86_509 VGND VGND VPWR VPWR sky130_fd_sc_hd__fill_1
XFILLER_79_561 VGND VGND VPWR VPWR sky130_fd_sc_hd__decap_4
XFILLER_20_3 VPWR VGND VPWR VGND sky130_ef_sc_hd__decap_12
XFILLER_66_244 VGND VGND VPWR VPWR sky130_fd_sc_hd__decap_8
X_7980_ _3371_ _3372_ VGND VGND VPWR VPWR _3374_ sky130_fd_sc_hd__xor2_1
XFILLER_66_277 VGND VGND VPWR VPWR sky130_fd_sc_hd__decap_6
XFILLER_66_266 VGND VGND VPWR VPWR sky130_fd_sc_hd__fill_1
Xrebuffer27 net541 VGND VGND VPWR VPWR net542 sky130_fd_sc_hd__buf_1
Xrebuffer16 _0438_ VGND VGND VPWR VPWR net531 sky130_fd_sc_hd__dlygate4sd1_1
X_6931_ net487 net329 net327 net495 VGND VGND VPWR VPWR _2400_ sky130_fd_sc_hd__a22oi_1
Xrebuffer38 net554 VGND VGND VPWR VPWR net553 sky130_fd_sc_hd__dlygate4sd1_1
X_6862_ _2330_ _2331_ _2332_ VGND VGND VPWR VPWR _2333_ sky130_fd_sc_hd__nor3_1
XFILLER_34_141 VGND VGND VPWR VPWR sky130_fd_sc_hd__decap_4
X_8601_ _3620_ _3765_ _3977_ _3766_ VGND VGND VPWR VPWR _3978_ sky130_fd_sc_hd__o211ai_4
X_5813_ net480 net350 VGND VGND VPWR VPWR _1352_ sky130_fd_sc_hd__nand2_1
X_8532_ _3875_ _3911_ VGND VGND VPWR VPWR _3912_ sky130_fd_sc_hd__nand2_1
X_6793_ _2263_ _2264_ net489 net336 VGND VGND VPWR VPWR _2266_ sky130_fd_sc_hd__or4bb_4
XFILLER_22_358 VGND VGND VPWR VPWR sky130_fd_sc_hd__decap_6
X_5744_ _1283_ _1285_ VGND VGND VPWR VPWR _1286_ sky130_fd_sc_hd__or2_1
Xrebuffer128 net705 VGND VGND VPWR VPWR net643 sky130_fd_sc_hd__buf_6
X_8463_ _3843_ _3844_ VGND VGND VPWR VPWR _3845_ sky130_fd_sc_hd__and2b_1
X_5675_ net13 _1230_ _1231_ net324 VGND VGND VPWR VPWR _0214_ sky130_fd_sc_hd__a22o_1
XFILLER_108_419 VGND VGND VPWR VPWR sky130_fd_sc_hd__fill_1
X_8394_ net187 _3775_ _3777_ VGND VGND VPWR VPWR _3778_ sky130_fd_sc_hd__or3b_1
X_7414_ _2843_ _2870_ VGND VGND VPWR VPWR _2871_ sky130_fd_sc_hd__nor2_1
X_4626_ net399 pe_array\[3\].u_pe.accum_reg\[6\] net257 _4388_ VGND VGND VPWR VPWR
+ _4389_ sky130_fd_sc_hd__o2bb2a_1
Xhold510 pe_accum\[0\]\[6\] VGND VGND VPWR VPWR net1025 sky130_fd_sc_hd__dlygate4sd3_1
X_7345_ _2801_ _2802_ _2803_ VGND VGND VPWR VPWR _2804_ sky130_fd_sc_hd__and3_1
XFILLER_104_603 VGND VGND VPWR VPWR sky130_fd_sc_hd__decap_3
Xhold521 pe_array\[2\].u_pe.weight_in\[7\] VGND VGND VPWR VPWR net1036 sky130_fd_sc_hd__dlygate4sd3_1
XFILLER_1_207 VGND VGND VPWR VPWR sky130_fd_sc_hd__fill_1
X_4557_ net400 pe_array\[3\].u_pe.accum_reg\[4\] net257 _4321_ VGND VGND VPWR VPWR
+ _4322_ sky130_fd_sc_hd__o2bb2a_1
XFILLER_103_113 VGND VGND VPWR VPWR sky130_fd_sc_hd__decap_4
XFILLER_89_314 VGND VGND VPWR VPWR sky130_fd_sc_hd__fill_2
X_7276_ _2703_ _2704_ _2734_ _2735_ VGND VGND VPWR VPWR _2737_ sky130_fd_sc_hd__o211ai_1
XFILLER_1_229 VGND VGND VPWR VPWR sky130_fd_sc_hd__fill_2
X_4488_ net306 net509 net305 net592 VGND VGND VPWR VPWR _4256_ sky130_fd_sc_hd__nand4_1
XFILLER_103_157 VGND VGND VPWR VPWR sky130_fd_sc_hd__fill_2
XFILLER_89_369 VGND VGND VPWR VPWR sky130_fd_sc_hd__decap_8
X_6227_ _1752_ _1753_ net277 VGND VGND VPWR VPWR _1756_ sky130_fd_sc_hd__o21ai_2
X_9015_ clknet_leaf_41_clk _0127_ VGND VGND VPWR VPWR net85 sky130_fd_sc_hd__dfxtp_1
X_6158_ net277 _1686_ _1687_ VGND VGND VPWR VPWR _1689_ sky130_fd_sc_hd__or3_4
XFILLER_66_27 VGND VGND VPWR VPWR sky130_fd_sc_hd__fill_1
X_5109_ _0845_ _0846_ net282 VGND VGND VPWR VPWR _0849_ sky130_fd_sc_hd__o21ai_1
X_6089_ _1618_ _1619_ _1620_ VGND VGND VPWR VPWR _1622_ sky130_fd_sc_hd__a21o_1
XTAP_TAPCELL_ROW_56_924 VGND VPWR sky130_fd_sc_hd__tapvpwrvgnd_1
XFILLER_72_225 VGND VGND VPWR VPWR sky130_fd_sc_hd__decap_8
XTAP_TAPCELL_ROW_0_240 VGND VPWR sky130_fd_sc_hd__tapvpwrvgnd_1
XTAP_TAPCELL_ROW_0_251 VGND VPWR sky130_fd_sc_hd__tapvpwrvgnd_1
XFILLER_53_472 VPWR VGND VPWR VGND sky130_ef_sc_hd__decap_12
XFILLER_13_325 VGND VGND VPWR VPWR sky130_fd_sc_hd__fill_1
XTAP_TAPCELL_ROW_36_681 VGND VPWR sky130_fd_sc_hd__tapvpwrvgnd_1
XFILLER_40_100 VGND VGND VPWR VPWR sky130_fd_sc_hd__fill_2
XFILLER_15_75 VGND VGND VPWR VPWR sky130_fd_sc_hd__decap_8
XFILLER_15_86 VPWR VGND VPWR VGND sky130_ef_sc_hd__decap_12
XFILLER_41_689 VGND VGND VPWR VPWR sky130_fd_sc_hd__fill_1
XTAP_TAPCELL_ROW_97_1414 VGND VPWR sky130_fd_sc_hd__tapvpwrvgnd_1
XFILLER_107_474 VGND VGND VPWR VPWR sky130_fd_sc_hd__decap_6
XFILLER_107_452 VGND VGND VPWR VPWR sky130_fd_sc_hd__decap_8
XFILLER_107_441 VGND VGND VPWR VPWR sky130_fd_sc_hd__decap_6
Xoutput30 net30 VGND VGND VPWR VPWR result_data[107] sky130_fd_sc_hd__buf_2
Xoutput41 net41 VGND VGND VPWR VPWR result_data[117] sky130_fd_sc_hd__buf_2
Xoutput52 net52 VGND VGND VPWR VPWR result_data[127] sky130_fd_sc_hd__buf_2
Xoutput74 net74 VGND VGND VPWR VPWR result_data[31] sky130_fd_sc_hd__buf_2
Xoutput63 net63 VGND VGND VPWR VPWR result_data[21] sky130_fd_sc_hd__buf_2
XTAP_TAPCELL_ROW_8_351 VGND VPWR sky130_fd_sc_hd__tapvpwrvgnd_1
Xoutput85 net85 VGND VGND VPWR VPWR result_data[41] sky130_fd_sc_hd__buf_2
XFILLER_0_273 VGND VGND VPWR VPWR sky130_fd_sc_hd__decap_6
Xoutput96 net96 VGND VGND VPWR VPWR result_data[51] sky130_fd_sc_hd__buf_2
XFILLER_76_531 VGND VGND VPWR VPWR sky130_fd_sc_hd__fill_1
XTAP_TAPCELL_ROW_106_1521 VGND VPWR sky130_fd_sc_hd__tapvpwrvgnd_1
XFILLER_91_545 VGND VGND VPWR VPWR sky130_fd_sc_hd__fill_1
XFILLER_48_299 VGND VGND VPWR VPWR sky130_fd_sc_hd__decap_8
XFILLER_91_567 VPWR VGND VPWR VGND sky130_ef_sc_hd__decap_12
XFILLER_16_141 VPWR VGND VPWR VGND sky130_ef_sc_hd__decap_12
XFILLER_32_601 VPWR VGND VPWR VGND sky130_ef_sc_hd__decap_12
XFILLER_32_645 VPWR VGND VPWR VGND sky130_ef_sc_hd__decap_12
XFILLER_31_199 VGND VGND VPWR VPWR sky130_fd_sc_hd__decap_6
XFILLER_117_205 VGND VGND VPWR VPWR sky130_fd_sc_hd__fill_1
X_5460_ _1164_ _1165_ net185 VGND VGND VPWR VPWR _1188_ sky130_fd_sc_hd__mux2_1
XFILLER_117_238 VGND VGND VPWR VPWR sky130_fd_sc_hd__decap_3
XTAP_TAPCELL_ROW_117_1672 VGND VPWR sky130_fd_sc_hd__tapvpwrvgnd_1
XTAP_TAPCELL_ROW_117_1661 VGND VPWR sky130_fd_sc_hd__tapvpwrvgnd_1
X_5391_ _1121_ VGND VGND VPWR VPWR _1122_ sky130_fd_sc_hd__inv_2
X_7130_ _2592_ _2593_ _2542_ VGND VGND VPWR VPWR _2595_ sky130_fd_sc_hd__a21o_1
XFILLER_99_689 VGND VGND VPWR VPWR sky130_fd_sc_hd__decap_8
Xfanout319 pe_array\[2\].u_pe.weight_in\[3\] VGND VGND VPWR VPWR net319 sky130_fd_sc_hd__buf_2
Xfanout308 pe_array\[2\].u_pe.weight_in\[6\] VGND VGND VPWR VPWR net308 sky130_fd_sc_hd__buf_2
X_7061_ _2484_ _2438_ _2527_ _2483_ VGND VGND VPWR VPWR _2528_ sky130_fd_sc_hd__o22a_1
XFILLER_101_617 VGND VGND VPWR VPWR sky130_fd_sc_hd__decap_3
XFILLER_86_306 VGND VGND VPWR VPWR sky130_fd_sc_hd__fill_2
X_6012_ _1545_ _1546_ VGND VGND VPWR VPWR _1547_ sky130_fd_sc_hd__and2b_1
.ends
